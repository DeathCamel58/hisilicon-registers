`ifndef EHI3535_VDP_RDL
`define EHI3535_VDP_RDL
regfile eHI3535_VDP {
    name = "Video display processor (VDP)";
    desc = "Video display processor (VDP). 322 registers extracted programmatically from the Hi3535 H.264 codec processor (Hi3535 user guide) data sheet (Issue 00B08, 2014-02-25); chapter 11.5, table 11-1. Field names, bit ranges, access types and reset values are taken from the register tables; reset values are the data sheet total reset values split onto the fields (per-field values where the table has them). Label: PROVEN. Hardware not verified here (no board).";
    reg {
        name = "VOCTRL";
        desc = "VOCTRL is the VO control register. Surface bus request arbitration mode. VOCTRL (offset 0x0000, total reset 0x0000_0000; PROVEN: Hi3535 data sheet, PDF page 972, section 11.5).";
        field {
            name = "vo_ck_gt_en";
            desc = "VDP clock gate enable.
- 0: Clock gate off;
- 1: The internal clock gate of the VDP is on.";
            sw = rw; hw = r;
            reset = 0x0;
        } vo_ck_gt_en[31:31];
        field {
            name = "reserved";
            desc = "Reserved.";
            sw = r; hw = w;
            reset = 0x0;
        } reserved_30_4[30:4];
        field {
            name = "m0_arb_mode";
            desc = "Arbitration mode for bus data requests of the surfaces inside VO MAC0.
- 0000: Round robin;
- 0001: Graphics layer first;
Other values: reserved.";
            sw = rw; hw = r;
            reset = 0x0;
        } m0_arb_mode[3:0];
    } VOCTRL @ 0x0;
    reg {
        name = "VOINTSTA";
        desc = "VOINTSTA is the VO interrupt status register, read-only. VOINTSTA (offset 0x0004, total reset 0x0000_0044; PROVEN: Hi3535 data sheet, PDF page 973, section 11.5).";
        field {
            name = "reserved";
            desc = "Reserved.";
            sw = r; hw = w;
            reset = 0x0;
        } reserved_31_31[31:31];
        field {
            name = "m0_be_int";
            desc = "AXI MASTER 0 bus error interrupt.
- 0: No interrupt.
- 1: Interrupt reported.";
            sw = r; hw = w;
            reset = 0x0;
        } m0_be_int[30:30];
        field {
            name = "reserved";
            desc = "Reserved.";
            sw = r; hw = w;
            reset = 0x0;
        } reserved_29_27[29:27];
        field {
            name = "g4rr_int";
            desc = "g4 register update interrupt.
- 0: No interrupt;
- 1: Interrupt reported.";
            sw = r; hw = w;
            reset = 0x0;
        } g4rr_int[26:26];
        field {
            name = "reserved";
            desc = "Reserved.";
            sw = r; hw = w;
            reset = 0x0;
        } reserved_25_25[25:25];
        field {
            name = "g2rr_int";
            desc = "g2 register update interrupt.
- 0: No interrupt;
- 1: Interrupt reported.";
            sw = r; hw = w;
            reset = 0x0;
        } g2rr_int[24:24];
        field {
            name = "g1rr_int";
            desc = "g1 register update interrupt.
- 0: No interrupt;
- 1: Interrupt reported.";
            sw = r; hw = w;
            reset = 0x0;
        } g1rr_int[23:23];
        field {
            name = "g0rr_int";
            desc = "g0 register update interrupt.
- 0: No interrupt;
- 1: Interrupt reported.";
            sw = r; hw = w;
            reset = 0x0;
        } g0rr_int[22:22];
        field {
            name = "reserved";
            desc = "Reserved.";
            sw = r; hw = w;
            reset = 0x0;
        } reserved_21_21[21:21];
        field {
            name = "v4rr_int";
            desc = "v4 register update interrupt.
- 0: No interrupt;
- 1: Interrupt reported.";
            sw = r; hw = w;
            reset = 0x0;
        } v4rr_int[20:20];
        field {
            name = "v3rr_int";
            desc = "v3 register update interrupt.
- 0: No interrupt;
- 1: Interrupt reported.";
            sw = r; hw = w;
            reset = 0x0;
        } v3rr_int[19:19];
        field {
            name = "reserved";
            desc = "Reserved.";
            sw = r; hw = w;
            reset = 0x0;
        } reserved_18_18[18:18];
        field {
            name = "dsd0uf_int";
            desc = "SD channel low-bandwidth alarm interrupt.
- 0: No interrupt.
- 1: Interrupt reported.";
            sw = r; hw = w;
            reset = 0x0;
        } dsd0uf_int[17:17];
        field {
            name = "dsd0vtthd1_int";
            desc = "SD channel vertical timing interrupt 1.
- 0: No interrupt;
- 1: Interrupt reported.";
            sw = r; hw = w;
            reset = 0x0;
        } dsd0vtthd1_int[16:16];
        field {
            name = "vdac3_unload_int";
            desc = "DAC3 no-load interrupt.
- 0: No interrupt;
- 1: Interrupt reported.";
            sw = r; hw = w;
            reset = 0x0;
        } vdac3_unload_int[15:15];
        field {
            name = "vdac2_unload_int";
            desc = "DAC2 no-load interrupt.
- 0: No interrupt;
- 1: Interrupt reported.";
            sw = r; hw = w;
            reset = 0x0;
        } vdac2_unload_int[14:14];
        field {
            name = "vdac1_unload_int";
            desc = "DAC1 no-load interrupt.
- 0: No interrupt;
- 1: Interrupt reported.";
            sw = r; hw = w;
            reset = 0x0;
        } vdac1_unload_int[13:13];
        field {
            name = "vdac0_unload_int";
            desc = "DAC0 no-load interrupt.
- 0: No interrupt;
- 1: Interrupt reported.";
            sw = r; hw = w;
            reset = 0x0;
        } vdac0_unload_int[12:12];
        field {
            name = "g4wbc_vte_int";
            desc = "G4WBC task completion interrupt.
- 0: No interrupt;
- 1: Interrupt reported.";
            sw = r; hw = w;
            reset = 0x0;
        } g4wbc_vte_int[11:11];
        field {
            name = "g0wbc_vte_int";
            desc = "G0WBC task complete interrupt.
- 0: No interrupt;
- 1: Interrupt reported.";
            sw = r; hw = w;
            reset = 0x0;
        } g0wbc_vte_int[10:10];
        field {
            name = "dwbc0_vte_int";
            desc = "DWBC0 task complete interrupt.
- 0: No interrupt;
- 1: Interrupt reported.";
            sw = r; hw = w;
            reset = 0x0;
        } dwbc0_vte_int[9:9];
        field {
            name = "reserved";
            desc = "Reserved.";
            sw = r; hw = w;
            reset = 0x0;
        } reserved_8_8[8:8];
        field {
            name = "dhd1uf_int";
            desc = "HD1 channel low bandwidth alarm interrupt.
- 0: No interrupt;
- 1: Interrupt reported.";
            sw = r; hw = w;
            reset = 0x0;
        } dhd1uf_int[7:7];
        field {
            name = "dhd1vtthd3_int";
            desc = "HD1 channel vertical timing interrupt 3.
- 0: No interrupt;
- 1: Interrupt reported.";
            sw = r; hw = w;
            reset = 0x1;
        } dhd1vtthd3_int[6:6];
        field {
            name = "dhd1vtthd2_int";
            desc = "HD1 channel vertical timing interrupt 2.
- 0: No interrupt;
- 1: Interrupt reported.";
            sw = r; hw = w;
            reset = 0x0;
        } dhd1vtthd2_int[5:5];
        field {
            name = "dhd1vtthd1_int";
            desc = "HD1 channel vertical timing interrupt 1.
- 0: No interrupt.
- 1: Interrupt reported.";
            sw = r; hw = w;
            reset = 0x0;
        } dhd1vtthd1_int[4:4];
        field {
            name = "dhd0uf_int";
            desc = "HD0 channel low-bandwidth alarm interrupt.
- 0: No interrupt;
- 1: Interrupt reported.";
            sw = r; hw = w;
            reset = 0x0;
        } dhd0uf_int[3:3];
        field {
            name = "dhd0vtthd3_int";
            desc = "HD0 channel vertical timing interrupt 3.
- 0: No interrupt;
- 1: Interrupt reported.";
            sw = r; hw = w;
            reset = 0x1;
        } dhd0vtthd3_int[2:2];
        field {
            name = "dhd0vtthd2_int";
            desc = "HD0 channel vertical timing interrupt 2.
- 0: No interrupt.
- 1: Interrupt reported.";
            sw = r; hw = w;
            reset = 0x0;
        } dhd0vtthd2_int[1:1];
        field {
            name = "dhd0vtthd1_int";
            desc = "HD0 channel vertical timing interrupt 1.
- 0: No interrupt;
- 1: Interrupt reported.";
            sw = r; hw = w;
            reset = 0x0;
        } dhd0vtthd1_int[0:0];
    } VOINTSTA @ 0x4;
    reg {
        name = "VOMSKINTSTA";
        desc = "VOMSKINTSTA is the VO masked interrupt status register. Write 1 to clear. VOMSKINTSTA (offset 0x0008, total reset 0x0000_0000; PROVEN: Hi3535 data sheet, PDF page 976, section 11.5).";
        field {
            name = "reserved";
            desc = "Reserved.";
            sw = r; hw = w;
            reset = 0x0;
        } reserved_31_31[31:31];
        field {
            name = "m0_be_clr";
            desc = "AXI MASTER 0 bus error interrupt.
- 0: No interrupt.
- 1: Interrupt reported. (data sheet access type WC)";
            sw = rw; hw = r; onwrite = woclr;
            reset = 0x0;
        } m0_be_clr[30:30];
        field {
            name = "reserved";
            desc = "Reserved.";
            sw = r; hw = w;
            reset = 0x0;
        } reserved_29_27[29:27];
        field {
            name = "g4rr_clr";
            desc = "g4 register update interrupt.
- 0: No interrupt;
- 1: Interrupt reported. (data sheet access type WC)";
            sw = rw; hw = r; onwrite = woclr;
            reset = 0x0;
        } g4rr_clr[26:26];
        field {
            name = "reserved";
            desc = "Reserved.";
            sw = r; hw = w;
            reset = 0x0;
        } reserved_25_25[25:25];
        field {
            name = "g2rr_clr";
            desc = "g2 register update interrupt.
- 0: No interrupt;
- 1: Interrupt reported. (data sheet access type WC)";
            sw = rw; hw = r; onwrite = woclr;
            reset = 0x0;
        } g2rr_clr[24:24];
        field {
            name = "g1rr_clr";
            desc = "g1 register update interrupt.
- 0: No interrupt;
- 1: Interrupt reported. (data sheet access type WC)";
            sw = rw; hw = r; onwrite = woclr;
            reset = 0x0;
        } g1rr_clr[23:23];
        field {
            name = "g0rr_clr";
            desc = "g0 register update interrupt.
- 0: No interrupt;
- 1: Interrupt reported. (data sheet access type WC)";
            sw = rw; hw = r; onwrite = woclr;
            reset = 0x0;
        } g0rr_clr[22:22];
        field {
            name = "reserved";
            desc = "Reserved.";
            sw = r; hw = w;
            reset = 0x0;
        } reserved_21_21[21:21];
        field {
            name = "v4rr_clr";
            desc = "v4 register update interrupt.
- 0: No interrupt;
- 1: Interrupt reported. (data sheet access type WC)";
            sw = rw; hw = r; onwrite = woclr;
            reset = 0x0;
        } v4rr_clr[20:20];
        field {
            name = "v3rr_clr";
            desc = "v3 register update interrupt.
- 0: No interrupt;
- 1: Interrupt reported. (data sheet access type WC)";
            sw = rw; hw = r; onwrite = woclr;
            reset = 0x0;
        } v3rr_clr[19:19];
        field {
            name = "reserved";
            desc = "Reserved.";
            sw = r; hw = w;
            reset = 0x0;
        } reserved_18_18[18:18];
        field {
            name = "dsd0uf_clr";
            desc = "SD channel low-bandwidth alarm interrupt.
- 0: No interrupt.
- 1: Interrupt reported.";
            sw = r; hw = w;
            reset = 0x0;
        } dsd0uf_clr[17:17];
        field {
            name = "dsd0vtthd1_clr";
            desc = "SD channel vertical timing interrupt 1.
- 0: No interrupt;
- 1: Interrupt reported.";
            sw = r; hw = w;
            reset = 0x0;
        } dsd0vtthd1_clr[16:16];
        field {
            name = "vdac3_unload_int";
            desc = "DAC3 no-load interrupt.
- 0: No interrupt;
- 1: Interrupt reported.";
            sw = r; hw = w;
            reset = 0x0;
        } vdac3_unload_int[15:15];
        field {
            name = "vdac2_unload_int";
            desc = "DAC2 no-load interrupt.
- 0: No interrupt;
- 1: Interrupt reported.";
            sw = r; hw = w;
            reset = 0x0;
        } vdac2_unload_int[14:14];
        field {
            name = "vdac1_unload_int";
            desc = "DAC1 no-load interrupt.
- 0: No interrupt;
- 1: Interrupt reported.";
            sw = r; hw = w;
            reset = 0x0;
        } vdac1_unload_int[13:13];
        field {
            name = "vdac0_unload_int";
            desc = "DAC0 no-load interrupt.
- 0: No interrupt;
- 1: Interrupt reported.";
            sw = r; hw = w;
            reset = 0x0;
        } vdac0_unload_int[12:12];
        field {
            name = "g4wbc_vte_clr";
            desc = "G4WBC task completion interrupt.
- 0: No interrupt;
- 1: Interrupt reported.";
            sw = r; hw = w;
            reset = 0x0;
        } g4wbc_vte_clr[11:11];
        field {
            name = "g0wbc_vte_clr";
            desc = "G0WBC task complete interrupt.
- 0: No interrupt;
- 1: Interrupt reported.";
            sw = r; hw = w;
            reset = 0x0;
        } g0wbc_vte_clr[10:10];
        field {
            name = "dwbc0_vte_clr";
            desc = "DWBC0 task complete interrupt.
- 0: No interrupt;
- 1: Interrupt reported. (data sheet access type WC)";
            sw = rw; hw = r; onwrite = woclr;
            reset = 0x0;
        } dwbc0_vte_clr[9:9];
        field {
            name = "reserved";
            desc = "Reserved.";
            sw = r; hw = w;
            reset = 0x0;
        } reserved_8_8[8:8];
        field {
            name = "dhd1uf_clr";
            desc = "HD1 channel low bandwidth alarm interrupt.
- 0: No interrupt;
- 1: Interrupt reported. (data sheet access type WC)";
            sw = rw; hw = r; onwrite = woclr;
            reset = 0x0;
        } dhd1uf_clr[7:7];
        field {
            name = "dhd1vtthd3_clr";
            desc = "HD1 channel vertical timing interrupt 3.
- 0: No interrupt;
- 1: Interrupt reported. (data sheet access type WC)";
            sw = rw; hw = r; onwrite = woclr;
            reset = 0x0;
        } dhd1vtthd3_clr[6:6];
        field {
            name = "dhd1vtthd2_clr";
            desc = "HD1 channel vertical timing interrupt 2.
- 0: No interrupt;
- 1: Interrupt reported. (data sheet access type WC)";
            sw = rw; hw = r; onwrite = woclr;
            reset = 0x0;
        } dhd1vtthd2_clr[5:5];
        field {
            name = "dhd1vtthd1_clr";
            desc = "HD1 channel vertical timing interrupt 1.
- 0: No interrupt.
- 1: Interrupt reported. (data sheet access type WC)";
            sw = rw; hw = r; onwrite = woclr;
            reset = 0x0;
        } dhd1vtthd1_clr[4:4];
        field {
            name = "dhd0uf_clr";
            desc = "HD0 channel low-bandwidth alarm interrupt.
- 0: No interrupt;
- 1: Interrupt reported. (data sheet access type WC)";
            sw = rw; hw = r; onwrite = woclr;
            reset = 0x0;
        } dhd0uf_clr[3:3];
        field {
            name = "dhd0vtthd3_clr";
            desc = "HD0 channel vertical timing interrupt 3.
- 0: No interrupt;
- 1: Interrupt reported. (data sheet access type WC)";
            sw = rw; hw = r; onwrite = woclr;
            reset = 0x0;
        } dhd0vtthd3_clr[2:2];
        field {
            name = "dhd0vtthd2_clr";
            desc = "HD0 channel vertical timing interrupt 2.
- 0: No interrupt.
- 1: Interrupt reported. (data sheet access type WC)";
            sw = rw; hw = r; onwrite = woclr;
            reset = 0x0;
        } dhd0vtthd2_clr[1:1];
        field {
            name = "dhd0vtthd1_clr";
            desc = "HD0 channel vertical timing interrupt 1.
- 0: No interrupt;
- 1: Interrupt reported. (data sheet access type WC)";
            sw = rw; hw = r; onwrite = woclr;
            reset = 0x0;
        } dhd0vtthd1_clr[0:0];
    } VOMSKINTSTA @ 0x8;
    reg {
        name = "VOINTMSK";
        desc = "VOINTMSK is the VDP interrupt mask register, corresponding to VOINTSTA. A bit value of 1 means the interrupt is enabled; 0 means the interrupt is masked. VOINTMSK (offset 0x000C, total reset 0x0000_0000; PROVEN: Hi3535 data sheet, PDF page 979, section 11.5).";
        field {
            name = "reserved";
            desc = "Reserved.";
            sw = r; hw = w;
            reset = 0x0;
        } reserved_31_31[31:31];
        field {
            name = "m0_be_intmsk";
            desc = "AXI MASTER 0 bus error interrupt.
- 0: Interrupt masked;
- 1: Interrupt enabled.";
            sw = rw; hw = r;
            reset = 0x0;
        } m0_be_intmsk[30:30];
        field {
            name = "reserved";
            desc = "Reserved.";
            sw = r; hw = w;
            reset = 0x0;
        } reserved_29_27[29:27];
        field {
            name = "g4rr_intmsk";
            desc = "g4 register update interrupt.
- 0: Interrupt masked;
- 1: Interrupt enabled.";
            sw = rw; hw = r;
            reset = 0x0;
        } g4rr_intmsk[26:26];
        field {
            name = "reserved";
            desc = "Reserved.";
            sw = r; hw = w;
            reset = 0x0;
        } reserved_25_25[25:25];
        field {
            name = "g2rr_intmsk";
            desc = "g2 register update interrupt.
- 0: Interrupt masked.
- 1: Interrupt enabled.";
            sw = rw; hw = r;
            reset = 0x0;
        } g2rr_intmsk[24:24];
        field {
            name = "g1rr_intmsk";
            desc = "g1 register update interrupt.
- 0: Interrupt masked.
- 1: Interrupt enabled.";
            sw = rw; hw = r;
            reset = 0x0;
        } g1rr_intmsk[23:23];
        field {
            name = "g0rr_intmsk";
            desc = "g0 register update interrupt.
- 0: Interrupt masked;
- 1: Interrupt enabled.";
            sw = rw; hw = r;
            reset = 0x0;
        } g0rr_intmsk[22:22];
        field {
            name = "reserved";
            desc = "Reserved.";
            sw = r; hw = w;
            reset = 0x0;
        } reserved_21_21[21:21];
        field {
            name = "v4rr_intmsk";
            desc = "v4 register update interrupt.
- 0: Interrupt masked.
- 1: Interrupt enabled.";
            sw = rw; hw = r;
            reset = 0x0;
        } v4rr_intmsk[20:20];
        field {
            name = "v3rr_intmsk";
            desc = "v3 register update interrupt.
- 0: Interrupt masked;
- 1: Interrupt enabled.";
            sw = rw; hw = r;
            reset = 0x0;
        } v3rr_intmsk[19:19];
        field {
            name = "reserved";
            desc = "Reserved.";
            sw = r; hw = w;
            reset = 0x0;
        } reserved_18_18[18:18];
        field {
            name = "dsd0uf_intmsk";
            desc = "SD channel low-bandwidth alarm interrupt.
- 0: Interrupt masked;
- 1: Interrupt enabled.";
            sw = r; hw = w;
            reset = 0x0;
        } dsd0uf_intmsk[17:17];
        field {
            name = "dsd0vtthd1_intmsk";
            desc = "SD channel vertical timing interrupt 1.
- 0: Interrupt masked.
- 1: Interrupt enabled.";
            sw = r; hw = w;
            reset = 0x0;
        } dsd0vtthd1_intmsk[16:16];
        field {
            name = "vdac3_unload_intmsk";
            desc = "DAC3 no-load interrupt.
- 0: Interrupt masked;
- 1: Interrupt enabled.";
            sw = rw; hw = r;
            reset = 0x0;
        } vdac3_unload_intmsk[15:15];
        field {
            name = "vdac2_unload_intmsk";
            desc = "DAC2 no-load interrupt.
- 0: Interrupt masked;
- 1: Interrupt enabled.";
            sw = rw; hw = r;
            reset = 0x0;
        } vdac2_unload_intmsk[14:14];
        field {
            name = "vdac1_unload_intmsk";
            desc = "DAC1 no-load interrupt.
- 0: Interrupt masked;
- 1: Interrupt enabled.";
            sw = rw; hw = r;
            reset = 0x0;
        } vdac1_unload_intmsk[13:13];
        field {
            name = "vdac0_unload_intmsk";
            desc = "DAC0 no-load interrupt.
- 0: Interrupt masked.
- 1: Interrupt enabled.";
            sw = rw; hw = r;
            reset = 0x0;
        } vdac0_unload_intmsk[12:12];
        field {
            name = "g4wbc_vte_intmsk";
            desc = "G4WBC task completion interrupt.
- 0: No interrupt;
- 1: Interrupt reported.";
            sw = rw; hw = r;
            reset = 0x0;
        } g4wbc_vte_intmsk[11:11];
        field {
            name = "g0wbc_vte_intmsk";
            desc = "G0WBC task complete interrupt.
- 0: No interrupt;
- 1: Interrupt reported.";
            sw = rw; hw = r;
            reset = 0x0;
        } g0wbc_vte_intmsk[10:10];
        field {
            name = "dwbc0_vte_intmsk";
            desc = "DWBC0 task completion interrupt.
- 0: Interrupt masked;
- 1: Interrupt enabled.";
            sw = rw; hw = r;
            reset = 0x0;
        } dwbc0_vte_intmsk[9:9];
        field {
            name = "reserved";
            desc = "Reserved.";
            sw = r; hw = w;
            reset = 0x0;
        } reserved_8_8[8:8];
        field {
            name = "dhd1uf_intmsk";
            desc = "HD1 channel low bandwidth alarm interrupt.
- 0: Interrupt masked;
- 1: Interrupt enabled.";
            sw = rw; hw = r;
            reset = 0x0;
        } dhd1uf_intmsk[7:7];
        field {
            name = "dhd1vtthd3_intmsk";
            desc = "HD1 channel vertical timing interrupt 3.
- 0: Interrupt masked;
- 1: Interrupt enabled.";
            sw = rw; hw = r;
            reset = 0x0;
        } dhd1vtthd3_intmsk[6:6];
        field {
            name = "dhd1vtthd2_intmsk";
            desc = "HD1 channel vertical timing interrupt 2.
- 0: Interrupt masked;
- 1: Interrupt enabled.";
            sw = rw; hw = r;
            reset = 0x0;
        } dhd1vtthd2_intmsk[5:5];
        field {
            name = "dhd1vtthd1_intmsk";
            desc = "HD1 channel vertical timing interrupt 1.
- 0: Interrupt masked.
- 1: Interrupt enabled.";
            sw = rw; hw = r;
            reset = 0x0;
        } dhd1vtthd1_intmsk[4:4];
        field {
            name = "dhd0uf_intmsk";
            desc = "HD0 channel low-bandwidth alarm interrupt.
- 0: Interrupt masked.
- 1: Interrupt enabled.";
            sw = rw; hw = r;
            reset = 0x0;
        } dhd0uf_intmsk[3:3];
        field {
            name = "dhd0vtthd3_intmsk";
            desc = "HD0 channel vertical timing interrupt 3.
- 0: Interrupt masked;
- 1: Interrupt enabled.";
            sw = rw; hw = r;
            reset = 0x0;
        } dhd0vtthd3_intmsk[2:2];
        field {
            name = "dhd0vtthd2_intmsk";
            desc = "HD0 channel vertical timing interrupt 2.
- 0: Interrupt masked.
- 1: Interrupt enabled.";
            sw = rw; hw = r;
            reset = 0x0;
        } dhd0vtthd2_intmsk[1:1];
        field {
            name = "dhd0vtthd1_intmsk";
            desc = "HD0 channel vertical timing interrupt 1.
- 0: Interrupt masked;
- 1: Interrupt enabled.";
            sw = rw; hw = r;
            reset = 0x0;
        } dhd0vtthd1_intmsk[0:0];
    } VOINTMSK @ 0xc;
    reg {
        name = "VDPVERSION1";
        desc = "VDPVERSION1 is the VDP version 1 register. VDPVERSION1 (offset 0x0010, total reset 0x7675_6F76; PROVEN: Hi3535 data sheet, PDF page 982, section 11.5).";
        field {
            name = "vdpversion1";
            desc = "VDP version register 1.";
            sw = r; hw = w;
            reset = 0x76756f76;
        } vdpversion1[31:0];
    } VDPVERSION1 @ 0x10;
    reg {
        name = "VDPVERSION2";
        desc = "VDPVERSION2 is VDP version register 2. VDPVERSION2 (offset 0x0014, total reset 0x3031_3134; PROVEN: Hi3535 data sheet, PDF page 982, section 11.5).";
        field {
            name = "vdpversion2";
            desc = "VDP version register 2.";
            sw = r; hw = w;
            reset = 0x30313134;
        } vdpversion2[31:0];
    } VDPVERSION2 @ 0x14;
    reg {
        name = "VOAXICTRL";
        desc = "VOAXICTRL is the VO AXI bus configuration register. VOAXICTRL (offset 0x0034, total reset 0x0111_0111; PROVEN: Hi3535 data sheet, PDF page 982, section 11.5).";
        field {
            name = "reserved";
            desc = "Reserved.";
            sw = r; hw = w;
            reset = 0x1110;
        } reserved_31_12[31:12];
        field {
            name = "m0_wr_ostd";
            desc = "axi master 0 write ID outstanding configuration, range 0 to 7.";
            sw = rw; hw = r;
            reset = 0x1;
        } m0_wr_ostd[11:8];
        field {
            name = "reserved";
            desc = "Reserved.";
            sw = r; hw = w;
            reset = 0x1;
        } reserved_7_4[7:4];
        field {
            name = "m0_outstd_rid0";
            desc = "axi master 0 read ID0 outstanding configuration, range 0 to 7.";
            sw = rw; hw = r;
            reset = 0x1;
        } m0_outstd_rid0[3:0];
    } VOAXICTRL @ 0x34;
    reg {
        name = "VOUFSTA";
        desc = "VOUFSTA is the VO layer-level low-bandwidth status register. VOUFSTA (offset 0x0040, total reset 0x0000_0000; PROVEN: Hi3535 data sheet, PDF page 983, section 11.5).";
        field {
            name = "reserved";
            desc = "Reserved.";
            sw = r; hw = w;
            reset = 0x0;
        } reserved_31_13[31:13];
        field {
            name = "g4_uf_sta";
            desc = "G4 low-bandwidth status.";
            sw = r; hw = w;
            reset = 0x0;
        } g4_uf_sta[12:12];
        field {
            name = "reserved";
            desc = "Reserved.";
            sw = r; hw = w;
            reset = 0x0;
        } reserved_11_11[11:11];
        field {
            name = "g2_uf_sta";
            desc = "G2 low bandwidth status.";
            sw = r; hw = w;
            reset = 0x0;
        } g2_uf_sta[10:10];
        field {
            name = "g1_uf_sta";
            desc = "G1 low bandwidth status.";
            sw = r; hw = w;
            reset = 0x0;
        } g1_uf_sta[9:9];
        field {
            name = "g0_uf_sta";
            desc = "G0 low bandwidth status.";
            sw = r; hw = w;
            reset = 0x0;
        } g0_uf_sta[8:8];
        field {
            name = "reserved";
            desc = "Reserved.";
            sw = r; hw = w;
            reset = 0x0;
        } reserved_7_4[7:4];
        field {
            name = "v3_uf_sta";
            desc = "V3 low bandwidth status.";
            sw = r; hw = w;
            reset = 0x0;
        } v3_uf_sta[3:3];
        field {
            name = "reserved";
            desc = "Reserved.";
            sw = r; hw = w;
            reset = 0x0;
        } reserved_2_2[2:2];
        field {
            name = "v1_uf_sta";
            desc = "V1 low bandwidth status.";
            sw = r; hw = w;
            reset = 0x0;
        } v1_uf_sta[1:1];
        field {
            name = "v0_uf_sta";
            desc = "V0 low-bandwidth status.";
            sw = r; hw = w;
            reset = 0x0;
        } v0_uf_sta[0:0];
    } VOUFSTA @ 0x40;
    reg {
        name = "VOUFCLR";
        desc = "VOUFCLR is the VO-level low-bandwidth status clear register. VOUFCLR (offset 0x0044, total reset 0x0000_0000; PROVEN: Hi3535 data sheet, PDF page 984, section 11.5).";
        field {
            name = "reserved";
            desc = "Reserved.";
            sw = r; hw = w;
            reset = 0x0;
        } reserved_31_13[31:13];
        field {
            name = "g4_uf_clr";
            desc = "G4 low bandwidth status clear.";
            sw = rw; hw = r;
            reset = 0x0;
        } g4_uf_clr[12:12];
        field {
            name = "reserved";
            desc = "Reserved.";
            sw = r; hw = w;
            reset = 0x0;
        } reserved_11_11[11:11];
        field {
            name = "g2_uf_clr";
            desc = "G2 low bandwidth status clear.";
            sw = rw; hw = r;
            reset = 0x0;
        } g2_uf_clr[10:10];
        field {
            name = "g1_uf_clr";
            desc = "G1 low-bandwidth status clear.";
            sw = rw; hw = r;
            reset = 0x0;
        } g1_uf_clr[9:9];
        field {
            name = "g0_uf_clr";
            desc = "G0 low-bandwidth status clear.";
            sw = rw; hw = r;
            reset = 0x0;
        } g0_uf_clr[8:8];
        field {
            name = "reserved";
            desc = "Reserved.";
            sw = r; hw = w;
            reset = 0x0;
        } reserved_7_4[7:4];
        field {
            name = "v3_uf_clr";
            desc = "V3 low bandwidth status clear.";
            sw = rw; hw = r;
            reset = 0x0;
        } v3_uf_clr[3:3];
        field {
            name = "reserved";
            desc = "Reserved.";
            sw = r; hw = w;
            reset = 0x0;
        } reserved_2_2[2:2];
        field {
            name = "v1_uf_clr";
            desc = "V1 low bandwidth status clear.";
            sw = rw; hw = r;
            reset = 0x0;
        } v1_uf_clr[1:1];
        field {
            name = "v0_uf_clr";
            desc = "V0 low-bandwidth status clear.";
            sw = rw; hw = r;
            reset = 0x0;
        } v0_uf_clr[0:0];
    } VOUFCLR @ 0x44;
    reg {
        name = "VO_MUX";
        desc = "VO_MUX is the VO output interface multiplexing register. VO_MUX (offset 0x0100, total reset 0x0000_0001; PROVEN: Hi3535 data sheet, PDF page 984, section 11.5).";
        field {
            name = "reserved";
            desc = "Reserved.";
            sw = r; hw = w;
            reset = 0x0;
        } reserved_31_24[31:24];
        field {
            name = "bt1120_sel";
            desc = "BT.1120 data selection (default 0).
- 0: DHD0 BT.1120;
- 1: DHD1 BT.1120.";
            sw = rw; hw = r;
            reset = 0x0;
        } bt1120_sel[23:20];
        field {
            name = "reserved";
            desc = "Reserved.";
            sw = r; hw = w;
            reset = 0x0;
        } reserved_19_16[19:16];
        field {
            name = "hdmi_sel";
            desc = "HDMI data select (default 0).
- 0: DHD0 HDMI;
- 1: DHD1 HDMI.";
            sw = rw; hw = r;
            reset = 0x0;
        } hdmi_sel[15:12];
        field {
            name = "vga_sel";
            desc = "VGA data select (default 0).
- 0: DHD0 VGA;
- 1: DHD1 VGA.";
            sw = rw; hw = r;
            reset = 0x0;
        } vga_sel[11:8];
        field {
            name = "reserved";
            desc = "Reserved.";
            sw = r; hw = w;
            reset = 0x1;
        } reserved_7_0[7:0];
    } VO_MUX @ 0x100;
    reg {
        name = "VO_MUX_DAC";
        desc = "VO_MUX_DAC is the VO DAC output interface multiplexing register. VO_MUX_DAC (offset 0x0104, total reset 0x0000_6540; PROVEN: Hi3535 data sheet, PDF page 985, section 11.5).";
        field {
            name = "reserved";
            desc = "Reserved.";
            sw = r; hw = w;
            reset = 0x0;
        } reserved_31_16[31:16];
        field {
            name = "dac3_sel";
            desc = "DAC3 output select (default 0x0).
- 0x0: DAC3 outputs CVBS video (SDATE).
- 0x1: DAC3 outputs the Y/R component of standard-definition analog video (SDATE).
- 0x2: DAC3 outputs the Cb/G component of standard-definition analog video (SDATE).
- 0x3: DAC3 outputs the Cr/B component of standard-definition analog video (SDATE).
- 0x4: DAC3 outputs the Y/R component of high-definition analog video (HDATE).
- 0x5: DAC3 outputs the Cb/G component of high-definition analog video (HDATE).
- 0x6: DAC3 outputs the Cr/B component of high-definition analog video (HDATE).
- 0x7: DAC3 outputs the R component of VGA video.
- 0x8: DAC3 outputs the G component of VGA video.
- 0x9: DAC3 outputs the B component of VGA video.";
            sw = rw; hw = r;
            reset = 0x6;
        } dac3_sel[15:12];
        field {
            name = "dac2_sel";
            desc = "DAC2 output selection (default 0x0).
- 0x0: DAC2 outputs CVBS video (SDATE);
- 0x1: DAC2 outputs the standard-definition analog video Y/R component (SDATE);
- 0x2: DAC2 outputs the standard-definition analog video Cb/G component (SDATE);
- 0x3: DAC2 outputs the standard-definition analog video Cr/B component (SDATE);
- 0x4: DAC2 outputs the high-definition analog video Y/R component (HDATE);
- 0x5: DAC2 outputs the high-definition analog video Cb/G component (HDATE);
- 0x6: DAC2 outputs the high-definition analog video Cr/B component (HDATE);
- 0x7: DAC2 outputs the VGA video R component;
- 0x8: DAC2 outputs the VGA video G component;
- 0x9: DAC2 outputs the VGA video B component.";
            sw = rw; hw = r;
            reset = 0x5;
        } dac2_sel[11:8];
        field {
            name = "dac1_sel";
            desc = "DAC1 output select (default 0x0).
- 0x0: DAC1 outputs CVBS video (SDATE);
- 0x1: DAC1 outputs standard-definition analog video Y/R component (SDATE);
- 0x2: DAC1 outputs standard-definition analog video Cb/G component (SDATE);
- 0x3: DAC1 outputs standard-definition analog video Cr/B component (SDATE);
- 0x4: DAC1 outputs high-definition analog video Y/R component (HDATE);
- 0x5: DAC1 outputs high-definition analog video Cb/G component (HDATE);
- 0x6: DAC1 outputs high-definition analog video Cr/B component (HDATE);
- 0x7: DAC1 outputs VGA video R component;
- 0x8: DAC1 outputs VGA video G component;
- 0x9: DAC1 outputs VGA video B component.";
            sw = rw; hw = r;
            reset = 0x4;
        } dac1_sel[7:4];
        field {
            name = "dac0_sel";
            desc = "DAC0 output select (default 0x0).
- 0x0: DAC0 outputs CVBS video (SDATE).
- 0x1: DAC0 outputs the standard-definition analog video Y/R component (SDATE).
- 0x2: DAC0 outputs the standard-definition analog video Cb/G component (SDATE).
- 0x3: DAC0 outputs the standard-definition analog video Cr/B component (SDATE).
- 0x4: DAC0 outputs the high-definition analog video Y/R component (HDATE).
- 0x5: DAC0 outputs the high-definition analog video Cb/G component (HDATE).
- 0x6: DAC0 outputs the high-definition analog video Cr/B component (HDATE).
- 0x7: DAC0 outputs the VGA video R component.
- 0x8: DAC0 outputs the VGA video G component.
- 0x9: DAC0 outputs the VGA video B component.";
            sw = rw; hw = r;
            reset = 0x0;
        } dac0_sel[3:0];
    } VO_MUX_DAC @ 0x104;
    reg {
        name = "VO_MUX_TESTSYNC";
        desc = "VO_MUX_TESTSYNC is the VO output interface test register. (VOPINTEST) VO_MUX_TESTSYNC (offset 0x0108, total reset 0x0000_0000; PROVEN: Hi3535 data sheet, PDF page 987, section 11.5).";
        field {
            name = "vo_test_en";
            desc = "VDP output interface test mode enable.
- 0: Disable.
- 1: Enable.";
            sw = rw; hw = r;
            reset = 0x0;
        } vo_test_en[31:31];
        field {
            name = "reserved";
            desc = "Reserved.";
            sw = r; hw = w;
            reset = 0x0;
        } reserved_30_4[30:4];
        field {
            name = "test_field";
            desc = "Field signal test value.";
            sw = rw; hw = r;
            reset = 0x0;
        } test_field[3:3];
        field {
            name = "test_vsync";
            desc = "vsync signal test value.";
            sw = rw; hw = r;
            reset = 0x0;
        } test_vsync[2:2];
        field {
            name = "test_hsync";
            desc = "hsync signal test value.";
            sw = rw; hw = r;
            reset = 0x0;
        } test_hsync[1:1];
        field {
            name = "test_dv";
            desc = "dv signal test value.";
            sw = rw; hw = r;
            reset = 0x0;
        } test_dv[0:0];
    } VO_MUX_TESTSYNC @ 0x108;
    reg {
        name = "VO_MUX_TESTDATA";
        desc = "VO_MUX_TESTDATA is the VO output interface test data register. (VOPINTEST) VO_MUX_TESTDATA (offset 0x010C, total reset 0x0000_0000; PROVEN: Hi3535 data sheet, PDF page 987, section 11.5).";
        field {
            name = "reserved";
            desc = "Reserved.";
            sw = r; hw = w;
            reset = 0x0;
        } reserved_31_30[31:30];
        field {
            name = "test_data";
            desc = "Data output value register in test mode. The DAC0~3 channels output the low 10 bits of the register, the BT.1120 channel outputs the low 16 bits of the register, the LCD channel outputs bits {29~22,19~12,9~2} of the register, and other channels output the register value, in the order from high to low of RGB or YUV.";
            sw = rw; hw = r;
            reset = 0x0;
        } test_data[29:0];
    } VO_MUX_TESTDATA @ 0x10c;
    reg {
        name = "VO_DAC_CTRL";
        desc = "VO_DAC_CTRL is the VO DAC control register. VO_DAC_CTRL (offset 0x0120, total reset 0x0000_0000; PROVEN: Hi3535 data sheet, PDF page 988, section 11.5).";
        field {
            name = "envbg";
            desc = "DAC internal bandgap power-up enable.
- 0: Disable;
- 1: Enable.";
            sw = rw; hw = r;
            reset = 0x0;
        } envbg[31:31];
        field {
            name = "enextref";
            desc = "The DAC internal bandgap is supplied by pin \"vbg\".
- 0: vbg is high-impedance;
- 1: The bandgap is connected directly to vbg.";
            sw = rw; hw = r;
            reset = 0x0;
        } enextref[30:30];
        field {
            name = "reserved";
            desc = "Reserved.";
            sw = r; hw = w;
            reset = 0x0;
        } reserved_29_19[29:19];
        field {
            name = "enctr";
            desc = "DAC0 analog biasing enable; normal operation is 3'b000.";
            sw = rw; hw = r;
            reset = 0x0;
        } enctr[18:16];
        field {
            name = "reserved";
            desc = "Reserved.";
            sw = r; hw = w;
            reset = 0x0;
        } reserved_15_0[15:0];
    } VO_DAC_CTRL @ 0x120;
    reg {
        name = "VO_DAC_C_CTRL";
        desc = "VO_DAC_C_CTRL is the VO DAC C channel control register. VO_DAC_C_CTRL (offset 0x0130, total reset 0x0000_0000; PROVEN: Hi3535 data sheet, PDF page 989, section 11.5).";
        field {
            name = "endac";
            desc = "DAC enable.
- 0: Disable;
- 1: Enable.";
            sw = rw; hw = r;
            reset = 0x0;
        } endac[31:31];
        field {
            name = "reserved";
            desc = "Reserved.";
            sw = r; hw = w;
            reset = 0x0;
        } reserved_30_21[30:21];
        field {
            name = "dacgc";
            desc = "DAC0 gain setting.";
            sw = rw; hw = r;
            reset = 0x0;
        } dacgc[20:15];
        field {
            name = "reserved";
            desc = "Reserved.";
            sw = r; hw = w;
            reset = 0x0;
        } reserved_14_0[14:0];
    } VO_DAC_C_CTRL @ 0x130;
    reg {
        name = "VO_DAC_R_CTRL";
        desc = "VO_DAC_R_CTRL is the VO DAC R channel control register. VO_DAC_R_CTRL (offset 0x0134, total reset 0x0000_0000; PROVEN: Hi3535 data sheet, PDF page 989, section 11.5).";
        field {
            name = "endac";
            desc = "DAC enable.
- 0: Disable;
- 1: Enable.";
            sw = rw; hw = r;
            reset = 0x0;
        } endac[31:31];
        field {
            name = "reserved";
            desc = "Reserved.";
            sw = r; hw = w;
            reset = 0x0;
        } reserved_30_21[30:21];
        field {
            name = "dacgc";
            desc = "DAC0 gain setting.";
            sw = rw; hw = r;
            reset = 0x0;
        } dacgc[20:15];
        field {
            name = "reserved";
            desc = "Reserved.";
            sw = r; hw = w;
            reset = 0x0;
        } reserved_14_0[14:0];
    } VO_DAC_R_CTRL @ 0x134;
    reg {
        name = "VO_DAC_G_CTRL";
        desc = "VO_DAC_G_CTRL is the VO DAC G channel control register. VO_DAC_G_CTRL (offset 0x0138, total reset 0x0000_0000; PROVEN: Hi3535 data sheet, PDF page 990, section 11.5).";
        field {
            name = "endac";
            desc = "DAC enable.
- 0: Disable;
- 1: Enable.";
            sw = rw; hw = r;
            reset = 0x0;
        } endac[31:31];
        field {
            name = "reserved";
            desc = "Reserved.";
            sw = r; hw = w;
            reset = 0x0;
        } reserved_30_21[30:21];
        field {
            name = "dacgc";
            desc = "DAC0 gain setting.";
            sw = rw; hw = r;
            reset = 0x0;
        } dacgc[20:15];
        field {
            name = "reserved";
            desc = "Reserved.";
            sw = r; hw = w;
            reset = 0x0;
        } reserved_14_0[14:0];
    } VO_DAC_G_CTRL @ 0x138;
    reg {
        name = "VO_DAC_B_CTRL";
        desc = "VO_DAC_B_CTRL is the VO DAC B channel control register. VO_DAC_B_CTRL (offset 0x013C, total reset 0x0000_0000; PROVEN: Hi3535 data sheet, PDF page 990, section 11.5).";
        field {
            name = "endac";
            desc = "DAC enable.
- 0: Disable;
- 1: Enable.";
            sw = rw; hw = r;
            reset = 0x0;
        } endac[31:31];
        field {
            name = "reserved";
            desc = "Reserved.";
            sw = r; hw = w;
            reset = 0x0;
        } reserved_30_21[30:21];
        field {
            name = "dacgc";
            desc = "DAC0 gain setting.";
            sw = rw; hw = r;
            reset = 0x0;
        } dacgc[20:15];
        field {
            name = "reserved";
            desc = "Reserved.";
            sw = r; hw = w;
            reset = 0x0;
        } reserved_14_0[14:0];
    } VO_DAC_B_CTRL @ 0x13c;
    reg {
        name = "VO_DAC_STAT0";
        desc = "VO_DAC_STAT0 is VO DAC status register 0. VO_DAC_STAT0 (offset 0x0140, total reset 0x0000_0000; PROVEN: Hi3535 data sheet, PDF page 991, section 11.5).";
        field {
            name = "reserved";
            desc = "Reserved.";
            sw = r; hw = w;
            reset = 0x0;
        } reserved_31_20[31:20];
        field {
            name = "cableout3";
            desc = "cableout3 feedback signal.";
            sw = r; hw = w;
            reset = 0x0;
        } cableout3[19:19];
        field {
            name = "cableout2";
            desc = "cableout2 feedback signal.";
            sw = r; hw = w;
            reset = 0x0;
        } cableout2[18:18];
        field {
            name = "cableout1";
            desc = "cableout1 feedback signal.";
            sw = r; hw = w;
            reset = 0x0;
        } cableout1[17:17];
        field {
            name = "cableout0";
            desc = "cableout0 feedback signal.";
            sw = r; hw = w;
            reset = 0x0;
        } cableout0[16:16];
        field {
            name = "reserved";
            desc = "Reserved.";
            sw = r; hw = w;
            reset = 0x0;
        } reserved_15_0[15:0];
    } VO_DAC_STAT0 @ 0x140;
    reg {
        name = "GDC_CORRESP";
        desc = "GDC_CORRESP is the graphics layer binding relationship register. GDC_CORRESP (offset 0x030C, total reset 0x0001_1101; PROVEN: Hi3535 data sheet, PDF page 991, section 11.5).";
        field {
            name = "reserved";
            desc = "Reserved.";
            sw = r; hw = w;
            reset = 0x11;
        } reserved_31_12[31:12];
        field {
            name = "g2_corresp";
            desc = "g2 layer binding register.
- 0010: g2 is bound to CBM MIX1 or MIX2, and the output channel is selected by priority;
- 0100: g2 is bound to MIXSD and displayed through DSD.
Other values: reserved.";
            sw = rw; hw = r;
            reset = 0x1;
        } g2_corresp[11:8];
        field {
            name = "reserved";
            desc = "Reserved.";
            sw = r; hw = w;
            reset = 0x1;
        } reserved_7_0[7:0];
    } GDC_CORRESP @ 0x30c;
    reg {
        name = "WBC_CORRESP";
        desc = "WBC_CORRESP is the WBC write-back point binding register. WBC_CORRESP (offset 0x0310, total reset 0x0000_0001; PROVEN: Hi3535 data sheet, PDF page 992, section 11.5).";
        field {
            name = "reserved";
            desc = "Reserved.";
            sw = r; hw = w;
            reset = 0x0;
        } reserved_31_6[31:6];
        field {
            name = "wbc_corresp";
            desc = "WBC_DHD write-back point binding register.
- 0x1: WBC_DHD is bound to the write-back point at the CBM MIX1 output;
- 0x2: WBC_DHD is bound to the write-back point at the CBM MIX2 output;
- 0x4: WBC_DHD is bound to the write-back point at the MIXSD output;
- 0x8: WBC_DHD is bound to the write-back point at the V0 output;
- 0x10: WBC_DHD is bound to the write-back point at the V3 output;
- 0x20: WBC_DHD is bound to the write-back point at the V4 output.";
            sw = rw; hw = r;
            reset = 0x1;
        } wbc_corresp[5:0];
    } WBC_CORRESP @ 0x310;
    reg {
        name = "COEF_DATA";
        desc = "COEF_DATA is a virtual coefficient register. All coefficients in the VDP are read from this register; the specific coefficient is selected by the PARARD read enable registers below. COEF_DATA (offset 0x0400, total reset 0x0000_0000; PROVEN: Hi3535 data sheet, PDF page 993, section 11.5).";
        field {
            name = "coef_data";
            desc = "Coefficient value.";
            sw = r; hw = w;
            reset = 0x0;
        } coef_data[31:0];
    } COEF_DATA @ 0x400;
    reg {
        name = "V0_PARARD";
        desc = "V0_PARARD is the V0 coefficient read flag register. V0_PARARD (offset 0x0410, total reset 0x0000_0000; PROVEN: Hi3535 data sheet, PDF page 993, section 11.5).";
        field {
            name = "reserved";
            desc = "Reserved.";
            sw = r; hw = w;
            reset = 0x0;
        } reserved_31_4[31:4];
        field {
            name = "v0_vccoef_rd";
            desc = "v0 vertical chroma filter coefficient read enable.
- 0: Disable;
- 1: Enable.";
            sw = rw; hw = r;
            reset = 0x0;
        } v0_vccoef_rd[3:3];
        field {
            name = "v0_vlcoef_rd";
            desc = "v0 vertical luma filter coefficient read enable.
- 0: Disable;
- 1: Enable.";
            sw = rw; hw = r;
            reset = 0x0;
        } v0_vlcoef_rd[2:2];
        field {
            name = "v0_hccoef_rd";
            desc = "v0 horizontal chroma filter coefficient read enable.
- 0: Disable;
- 1: Enable.";
            sw = rw; hw = r;
            reset = 0x0;
        } v0_hccoef_rd[1:1];
        field {
            name = "v0_hlcoef_rd";
            desc = "v0 horizontal luminance filter coefficient read enable.
- 0: Disable.
- 1: Enable.";
            sw = rw; hw = r;
            reset = 0x0;
        } v0_hlcoef_rd[0:0];
    } V0_PARARD @ 0x410;
    reg {
        name = "V1_PARARD";
        desc = "V1_PARARD is the V1 coefficient read flag register. V1_PARARD (offset 0x0414, total reset 0x0000_0000; PROVEN: Hi3535 data sheet, PDF page 994, section 11.5).";
        field {
            name = "reserved";
            desc = "Reserved.";
            sw = r; hw = w;
            reset = 0x0;
        } reserved_31_4[31:4];
        field {
            name = "v1_vccoef_rd";
            desc = "V1 vertical chroma filter coefficient read enable.
- 0: Disable;
- 1: Enable.";
            sw = rw; hw = r;
            reset = 0x0;
        } v1_vccoef_rd[3:3];
        field {
            name = "v1_vlcoef_rd";
            desc = "V1 vertical luminance filter coefficient read enable.
- 0: Disable.
- 1: Enable.";
            sw = rw; hw = r;
            reset = 0x0;
        } v1_vlcoef_rd[2:2];
        field {
            name = "v1_hccoef_rd";
            desc = "V1 horizontal chrominance filter coefficient read enable.
- 0: Disable.
- 1: Enable.";
            sw = rw; hw = r;
            reset = 0x0;
        } v1_hccoef_rd[1:1];
        field {
            name = "v1_hlcoef_rd";
            desc = "V1 horizontal luma filter coefficient read enable.
- 0: Disable;
- 1: Enable.";
            sw = rw; hw = r;
            reset = 0x0;
        } v1_hlcoef_rd[0:0];
    } V1_PARARD @ 0x414;
    reg {
        name = "V3_PARARD";
        desc = "V3_PARARD is the V3 coefficient read flag register. V3_PARARD (offset 0x041C, total reset 0x0000_0000; PROVEN: Hi3535 data sheet, PDF page 995, section 11.5).";
        field {
            name = "reserved";
            desc = "Reserved.";
            sw = r; hw = w;
            reset = 0x0;
        } reserved_31_4[31:4];
        field {
            name = "v3_vccoef_rd";
            desc = "V3 vertical chroma filter coefficient read enable.
- 0: Disable;
- 1: Enable.";
            sw = rw; hw = r;
            reset = 0x0;
        } v3_vccoef_rd[3:3];
        field {
            name = "v3_vlcoef_rd";
            desc = "V3 vertical luma filter coefficient read enable.
- 0: Disable;
- 1: Enable.";
            sw = rw; hw = r;
            reset = 0x0;
        } v3_vlcoef_rd[2:2];
        field {
            name = "v3_hccoef_rd";
            desc = "V3 horizontal chrominance filter coefficient read enable.
- 0: Disable.
- 1: Enable.";
            sw = rw; hw = r;
            reset = 0x0;
        } v3_hccoef_rd[1:1];
        field {
            name = "v3_hlcoef_rd";
            desc = "V3 horizontal luma filter coefficient read enable.
- 0: Disable;
- 1: Enable.";
            sw = rw; hw = r;
            reset = 0x0;
        } v3_hlcoef_rd[0:0];
    } V3_PARARD @ 0x41c;
    reg {
        name = "WBCDHD_PARARD";
        desc = "WBCDHD_PARARD is the WBC_DHD coefficient read flag register. WBCDHD_PARARD (offset 0x04C0, total reset 0x0000_0000; PROVEN: Hi3535 data sheet, PDF page 996, section 11.5).";
        field {
            name = "reserved";
            desc = "Reserved.";
            sw = r; hw = w;
            reset = 0x0;
        } reserved_31_4[31:4];
        field {
            name = "wbcdhd_vccoef_rd";
            desc = "wbcdhd vertical chroma filter coefficient read enable.
- 0: Disable;
- 1: Enable.";
            sw = rw; hw = r;
            reset = 0x0;
        } wbcdhd_vccoef_rd[3:3];
        field {
            name = "wbcdhd_vlcoef_rd";
            desc = "wbcdhd vertical luma filter coefficient read enable.
- 0: Disable;
- 1: Enable.";
            sw = rw; hw = r;
            reset = 0x0;
        } wbcdhd_vlcoef_rd[2:2];
        field {
            name = "wbcdhd_hccoef_rd";
            desc = "wbcdhd horizontal chroma filter coefficient read enable.
- 0: Disable.
- 1: Enable.";
            sw = rw; hw = r;
            reset = 0x0;
        } wbcdhd_hccoef_rd[1:1];
        field {
            name = "wbcdhd_hlcoef_rd";
            desc = "wbcdhd horizontal luminance filter coefficient read enable.
- 0: Disable.
- 1: Enable.";
            sw = rw; hw = r;
            reset = 0x0;
        } wbcdhd_hlcoef_rd[0:0];
    } WBCDHD_PARARD @ 0x4c0;
    reg {
        name = "V0_CTRL";
        desc = "V0_CTRL is a register for configuring layer-related information; non-immediate register. V0_CTRL (offset 0x0800, total reset 0x0000_0000; PROVEN: Hi3535 data sheet, PDF page 997, section 11.5).";
        field {
            name = "surface_en";
            desc = "surface enable. Not an immediate register.
- 0: Disable.
- 1: Enable.";
            sw = rw; hw = r;
            reset = 0x0;
        } surface_en[31:31];
        field {
            name = "reserved";
            desc = "Reserved.";
            sw = r; hw = w;
            reset = 0x0;
        } reserved_30_28[30:28];
        field {
            name = "mute_en";
            desc = "Mute enable of V0, not an immediate register.
- 0: Disable;
- 1: Enable.";
            sw = rw; hw = r;
            reset = 0x0;
        } mute_en[27:27];
        field {
            name = "reserved";
            desc = "Reserved.";
            sw = r; hw = w;
            reset = 0x0;
        } reserved_26_20[26:20];
        field {
            name = "ifir_mode";
            desc = "Horizontal chroma IFIR mode.
- 00: Reserved.
- 01: Chroma IFIR copy mode.
- 10: Bilinear interpolation.
- 11: 16-tap half-band filter.";
            sw = rw; hw = r;
            reset = 0x0;
        } ifir_mode[19:18];
        field {
            name = "vup_mode";
            desc = "V0 coefficient update mode.
- 0: Frame update.
- 1: Field update.";
            sw = rw; hw = r;
            reset = 0x0;
        } vup_mode[17:17];
        field {
            name = "reserved";
            desc = "Reserved.";
            sw = r; hw = w;
            reset = 0x0;
        } reserved_16_16[16:16];
        field {
            name = "lm_rmode";
            desc = "Luma progressive/interlaced read mode.
- 00: The read mode is bound to the interface.
- 01: Read frame buffer data progressively.
- 10: For interlaced reading, read the top field.
- 11: For interlaced reading, read the bottom field.";
            sw = rw; hw = r;
            reset = 0x0;
        } lm_rmode[15:14];
        field {
            name = "chm_rmode";
            desc = "Chroma progressive/interlaced read mode.
- 00: The read mode is tied to the interface;
- 01: Read the frame buffer data progressively;
- 10: Read the top field when reading interlaced;
- 11: Read the bottom field when reading interlaced.";
            sw = rw; hw = r;
            reset = 0x0;
        } chm_rmode[13:12];
        field {
            name = "reserved";
            desc = "Reserved.";
            sw = r; hw = w;
            reset = 0x0;
        } reserved_11_9[11:9];
        field {
            name = "dcmp_en";
            desc = "Decompression enable";
            sw = rw; hw = r;
            reset = 0x0;
        } dcmp_en[8:8];
        field {
            name = "time_out";
            desc = "Time Out value.";
            sw = rw; hw = r;
            reset = 0x0;
        } time_out[7:5];
        field {
            name = "reserved";
            desc = "Reserved.";
            sw = r; hw = w;
            reset = 0x0;
        } reserved_4_4[4:4];
        field {
            name = "ifmt";
            desc = "Input data format.
- 0x1: SPYCbCr400;
- 0x3: SPYCbCr420;
- 0x4: SPYCbCr422;
Others: Reserved.";
            sw = rw; hw = r;
            reset = 0x0;
        } ifmt[3:0];
    } V0_CTRL @ 0x800;
    reg {
        name = "V0_UPD";
        desc = "V0_UPD is the V0 channel update enable register. V0_UPD (offset 0x0804, total reset 0x0000_0000; PROVEN: Hi3535 data sheet, PDF page 998, section 11.5).";
        field {
            name = "reserved";
            desc = "Reserved.";
            sw = r; hw = w;
            reset = 0x0;
        } reserved_31_1[31:1];
        field {
            name = "regup";
            desc = "Surface register update. After software finishes configuring the registers of this layer, write 1 to update; hardware clears the bit automatically when the update completes. (data sheet access type WC)";
            sw = rw; hw = r; onwrite = woclr;
            reset = 0x0;
        } regup[0:0];
    } V0_UPD @ 0x804;
    reg {
        name = "V0_IRESO";
        desc = "V0_IRESO is the input resolution register; non-immediate register. V0_IRESO (offset 0x0828, total reset 0x0000_0000; PROVEN: Hi3535 data sheet, PDF page 999, section 11.5).";
        field {
            name = "reserved";
            desc = "Reserved.";
            sw = r; hw = w;
            reset = 0x0;
        } reserved_31_24[31:24];
        field {
            name = "ih";
            desc = "Height, in lines. Actual height minus 1. Relative to the frame height, in lines.";
            sw = rw; hw = r;
            reset = 0x0;
        } ih[23:12];
        field {
            name = "iw";
            desc = "Width, in pixels. Actual width minus 1.";
            sw = rw; hw = r;
            reset = 0x0;
        } iw[11:0];
    } V0_IRESO @ 0x828;
    reg {
        name = "V0_ORESO";
        desc = "V0_ORESO is the output resolution register, a non-immediate register. V0_ORESO (offset 0x082C, total reset 0x0000_0000; PROVEN: Hi3535 data sheet, PDF page 999, section 11.5).";
        field {
            name = "reserved";
            desc = "Reserved.";
            sw = r; hw = w;
            reset = 0x0;
        } reserved_31_24[31:24];
        field {
            name = "oh";
            desc = "Height, in lines. Actual height minus 1. Relative to the frame height, in lines.";
            sw = rw; hw = r;
            reset = 0x0;
        } oh[23:12];
        field {
            name = "ow";
            desc = "Width, in pixels. Actual width minus 1.";
            sw = rw; hw = r;
            reset = 0x0;
        } ow[11:0];
    } V0_ORESO @ 0x82c;
    reg {
        name = "V0_CBMPARA";
        desc = "V0_CBMPARA holds overlay-related parameters; not an immediate register. V0_CBMPARA (offset 0x0838, total reset 0x0000_0000; PROVEN: Hi3535 data sheet, PDF page 1000, section 11.5).";
        field {
            name = "reserved";
            desc = "Reserved.";
            sw = r; hw = w;
            reset = 0x0;
        } reserved_31_8[31:8];
        field {
            name = "galpha";
            desc = "Overlay global alpha value. Range 0 to 255; 255 is fully opaque and 0 is fully transparent.";
            sw = rw; hw = r;
            reset = 0x0;
        } galpha[7:0];
    } V0_CBMPARA @ 0x838;
    reg {
        name = "V0_PARAUP";
        desc = "V0_PARAUP is the update enable register for V0 coefficient-related registers. The VDP scaling coefficients are configured through the AXI Master; software uses the Slave to configure the start address and the flag indicating that parameters need to be updated. V0_PARAUP (offset 0x0840, total reset 0x0000_0000; PROVEN: Hi3535 data sheet, PDF page 1000, section 11.5).";
        field {
            name = "reserved";
            desc = "Reserved.";
            sw = r; hw = w;
            reset = 0x0;
        } reserved_31_4[31:4];
        field {
            name = "v0_vccoef_upd";
            desc = "Whether the V0 vertical chroma filter coefficients need to be updated. Cleared automatically by hardware after the update.
- 0: No update;
- 1: Update.";
            sw = rw; hw = r;
            reset = 0x0;
        } v0_vccoef_upd[3:3];
        field {
            name = "v0_vlcoef_upd";
            desc = "Whether the V0 vertical luminance filter coefficients need to be updated. Cleared automatically after the hardware update.
- 0: Do not update.
- 1: Update.";
            sw = rw; hw = r;
            reset = 0x0;
        } v0_vlcoef_upd[2:2];
        field {
            name = "v0_hccoef_upd";
            desc = "Whether the V0 horizontal chroma filter coefficients need to be updated. Cleared automatically after the hardware update.
- 0: No update.
- 1: Update.";
            sw = rw; hw = r;
            reset = 0x0;
        } v0_hccoef_upd[1:1];
        field {
            name = "v0_hlcoef_upd";
            desc = "Whether the V0 horizontal luma filter coefficients need to be updated. Cleared automatically after the hardware update.
- 0: Do not update;
- 1: Update.";
            sw = rw; hw = r;
            reset = 0x0;
        } v0_hlcoef_upd[0:0];
    } V0_PARAUP @ 0x840;
    reg {
        name = "V0_HLCOEFAD";
        desc = "V0_HLCOEFAD is the V0 horizontal luma filter coefficient address register. V0_HLCOEFAD (offset 0x0850, total reset 0x0000_0000; PROVEN: Hi3535 data sheet, PDF page 1001, section 11.5).";
        field {
            name = "coef_addr";
            desc = "Start address in Local Memory where the coefficients are placed.";
            sw = rw; hw = r;
            reset = 0x0;
        } coef_addr[31:0];
    } V0_HLCOEFAD @ 0x850;
    reg {
        name = "V0_HCCOEFAD";
        desc = "V0_HCCOEFAD is the V0 horizontal chrominance filter coefficient address register. V0_HCCOEFAD (offset 0x0854, total reset 0x0000_0000; PROVEN: Hi3535 data sheet, PDF page 1001, section 11.5).";
        field {
            name = "coef_addr";
            desc = "Start address in Local Memory where the coefficients are placed.";
            sw = rw; hw = r;
            reset = 0x0;
        } coef_addr[31:0];
    } V0_HCCOEFAD @ 0x854;
    reg {
        name = "V0_VLCOEFAD";
        desc = "V0_VLCOEFAD is the V0 vertical luma filter coefficient address register. V0_VLCOEFAD (offset 0x0858, total reset 0x0000_0000; PROVEN: Hi3535 data sheet, PDF page 1002, section 11.5).";
        field {
            name = "coef_addr";
            desc = "Start address in Local Memory where the coefficients are placed.";
            sw = rw; hw = r;
            reset = 0x0;
        } coef_addr[31:0];
    } V0_VLCOEFAD @ 0x858;
    reg {
        name = "V0_VCCOEFAD";
        desc = "V0_VCCOEFAD is the V0 vertical chroma filter coefficient address register. V0_VCCOEFAD (offset 0x085C, total reset 0x0000_0000; PROVEN: Hi3535 data sheet, PDF page 1002, section 11.5).";
        field {
            name = "coef_addr";
            desc = "Start address in Local Memory where the coefficients are placed.";
            sw = rw; hw = r;
            reset = 0x0;
        } coef_addr[31:0];
    } V0_VCCOEFAD @ 0x85c;
    reg {
        name = "V0_DFPOS";
        desc = "V0_DFPOS is the start position (First Position) of the Surface in the display window, a non-immediate register. V0_DFPOS (offset 0x0860, total reset 0x0000_0000; PROVEN: Hi3535 data sheet, PDF page 1002, section 11.5).";
        field {
            name = "reserved";
            desc = "Reserved.";
            sw = r; hw = w;
            reset = 0x0;
        } reserved_31_24[31:24];
        field {
            name = "disp_yfpos";
            desc = "Display column start coordinate, relative to the frame height, in lines.";
            sw = rw; hw = r;
            reset = 0x0;
        } disp_yfpos[23:12];
        field {
            name = "disp_xfpos";
            desc = "Display line start coordinate.";
            sw = rw; hw = r;
            reset = 0x0;
        } disp_xfpos[11:0];
    } V0_DFPOS @ 0x860;
    reg {
        name = "V0_DLPOS";
        desc = "V0_DLPOS is the end position (Last Position) of the Surface in the display window, in pixels, a non-immediate register. V0_DLPOS (offset 0x0864, total reset 0x0000_0000; PROVEN: Hi3535 data sheet, PDF page 1003, section 11.5).";
        field {
            name = "reserved";
            desc = "Reserved.";
            sw = r; hw = w;
            reset = 0x0;
        } reserved_31_24[31:24];
        field {
            name = "disp_ylpos";
            desc = "Display column end coordinate. Relative to the frame height, in lines.";
            sw = rw; hw = r;
            reset = 0x0;
        } disp_ylpos[23:12];
        field {
            name = "disp_xlpos";
            desc = "Display line end coordinate.";
            sw = rw; hw = r;
            reset = 0x0;
        } disp_xlpos[11:0];
    } V0_DLPOS @ 0x864;
    reg {
        name = "V0_VFPOS";
        desc = "V0_VFPOS is the start position (First Position) of the actual Surface content in the display window, in pixels, a non-immediate register. V0_VFPOS (offset 0x0868, total reset 0x0000_0000; PROVEN: Hi3535 data sheet, PDF page 1003, section 11.5).";
        field {
            name = "reserved";
            desc = "Reserved.";
            sw = r; hw = w;
            reset = 0x0;
        } reserved_31_24[31:24];
        field {
            name = "video_yfpos";
            desc = "Start coordinate of the video content column. Referenced to the frame height, in lines.";
            sw = rw; hw = r;
            reset = 0x0;
        } video_yfpos[23:12];
        field {
            name = "video_xfpos";
            desc = "Video content line start coordinate.";
            sw = rw; hw = r;
            reset = 0x0;
        } video_xfpos[11:0];
    } V0_VFPOS @ 0x868;
    reg {
        name = "V0_VLPOS";
        desc = "V0_VLPOS is the end position (Last Position) of the actual surface content in the display window, in pixels; not an immediate register. V0_VLPOS (offset 0x086C, total reset 0x0000_0000; PROVEN: Hi3535 data sheet, PDF page 1004, section 11.5).";
        field {
            name = "reserved";
            desc = "Reserved.";
            sw = r; hw = w;
            reset = 0x0;
        } reserved_31_24[31:24];
        field {
            name = "video_ylpos";
            desc = "Video content column end coordinate. Referenced to the frame height, in lines.";
            sw = rw; hw = r;
            reset = 0x0;
        } video_ylpos[23:12];
        field {
            name = "video_xlpos";
            desc = "Video content line end coordinate.";
            sw = rw; hw = r;
            reset = 0x0;
        } video_xlpos[11:0];
    } V0_VLPOS @ 0x86c;
    reg {
        name = "V0_BK";
        desc = "V0_BK is the background color register of the video layer. V0_BK (offset 0x0870, total reset 0x0000_0000; PROVEN: Hi3535 data sheet, PDF page 1004, section 11.5).";
        field {
            name = "reserved";
            desc = "Reserved.";
            sw = r; hw = w;
            reset = 0x0;
        } reserved_31_30[31:30];
        field {
            name = "vbk_y";
            desc = "Y component.";
            sw = rw; hw = r;
            reset = 0x0;
        } vbk_y[29:20];
        field {
            name = "vbk_cb";
            desc = "Cb component.";
            sw = rw; hw = r;
            reset = 0x0;
        } vbk_cb[19:10];
        field {
            name = "vbk_cr";
            desc = "Cr component.";
            sw = rw; hw = r;
            reset = 0x0;
        } vbk_cr[9:0];
    } V0_BK @ 0x870;
    reg {
        name = "V0_ALPHA";
        desc = "V0_ALPHA is the background fill color ALPHA register of the video layer. V0_ALPHA (offset 0x0874, total reset 0x0000_0000; PROVEN: Hi3535 data sheet, PDF page 1005, section 11.5).";
        field {
            name = "reserved";
            desc = "Reserved.";
            sw = r; hw = w;
            reset = 0x0;
        } reserved_31_8[31:8];
        field {
            name = "vbk_alpha";
            desc = "Background fill color of the video layer, levels 0 to 255.";
            sw = rw; hw = r;
            reset = 0x0;
        } vbk_alpha[7:0];
    } V0_ALPHA @ 0x874;
    reg {
        name = "V0_CSC_IDC";
        desc = "V0_CSC_IDC is the color space conversion input DC component register, an immediate register. V0_CSC_IDC (offset 0x0880, total reset 0x0000_0000; PROVEN: Hi3535 data sheet, PDF page 1005, section 11.5).";
        field {
            name = "reserved";
            desc = "Reserved.";
            sw = r; hw = w;
            reset = 0x0;
        } reserved_31_23[31:23];
        field {
            name = "csc_en";
            desc = "CSC enable control signal.
- 0: CSC disabled;
- 1: CSC enabled.";
            sw = rw; hw = r;
            reset = 0x0;
        } csc_en[22:22];
        field {
            name = "cscidc1";
            desc = "Input U/G component DC parameter, MSB is the sign bit. Two's complement representation.";
            sw = rw; hw = r;
            reset = 0x0;
        } cscidc1[21:11];
        field {
            name = "cscidc0";
            desc = "Input V/B component DC parameter, the MSB is the sign bit. Two's complement representation.";
            sw = rw; hw = r;
            reset = 0x0;
        } cscidc0[10:0];
    } V0_CSC_IDC @ 0x880;
    reg {
        name = "V0_CSC_ODC";
        desc = "V0_CSC_ODC is the color space conversion output DC component register, an immediate register. V0_CSC_ODC (offset 0x0884, total reset 0x0000_0000; PROVEN: Hi3535 data sheet, PDF page 1006, section 11.5).";
        field {
            name = "reserved";
            desc = "Reserved.";
            sw = r; hw = w;
            reset = 0x0;
        } reserved_31_23[31:23];
        field {
            name = "csc_sign_mode";
            desc = "CSC output mode control signal.
- 0: CSC outputs 10-bit unsigned numbers.
- 1: CSC outputs 12-bit signed numbers.";
            sw = rw; hw = r;
            reset = 0x0;
        } csc_sign_mode[22:22];
        field {
            name = "cscodc1";
            desc = "Output U/G component DC parameter, MSB is the sign bit. Two's complement representation.";
            sw = rw; hw = r;
            reset = 0x0;
        } cscodc1[21:11];
        field {
            name = "cscodc0";
            desc = "Output Y/R component DC parameter, MSB is the sign bit. Two's complement representation.";
            sw = rw; hw = r;
            reset = 0x0;
        } cscodc0[10:0];
    } V0_CSC_ODC @ 0x884;
    reg {
        name = "V0_CSC_IODC";
        desc = "V0_CSC_IODC is the color space conversion input/output DC component register, an immediate register. V0_CSC_IODC (offset 0x0888, total reset 0x0000_0000; PROVEN: Hi3535 data sheet, PDF page 1006, section 11.5).";
        field {
            name = "reserved";
            desc = "Reserved.";
            sw = r; hw = w;
            reset = 0x0;
        } reserved_31_22[31:22];
        field {
            name = "cscodc2";
            desc = "Output V/B component DC parameter, MSB is the sign bit. Two's complement representation.";
            sw = rw; hw = r;
            reset = 0x0;
        } cscodc2[21:11];
        field {
            name = "cscidc2";
            desc = "Input Y/R component DC parameter; the MSB is the sign bit. Two's complement representation.";
            sw = rw; hw = r;
            reset = 0x0;
        } cscidc2[10:0];
    } V0_CSC_IODC @ 0x888;
    reg {
        name = "V0_CSC_P0";
        desc = "V0_CSC_P0 is color space conversion parameter 0. It is an immediate register. V0_CSC_P0 (offset 0x088C, total reset 0x0000_0000; PROVEN: Hi3535 data sheet, PDF page 1007, section 11.5).";
        field {
            name = "reserved";
            desc = "Reserved.";
            sw = r; hw = w;
            reset = 0x0;
        } reserved_31_31[31:31];
        field {
            name = "cscp01";
            desc = "5.10 data format: 1-bit sign, 4-bit integer part, 10-bit fraction. Two's complement representation.";
            sw = rw; hw = r;
            reset = 0x0;
        } cscp01[30:16];
        field {
            name = "reserved";
            desc = "Reserved.";
            sw = r; hw = w;
            reset = 0x0;
        } reserved_15_15[15:15];
        field {
            name = "cscp00";
            desc = "5.10 data format: 1-bit sign, 4-bit integer part, 10-bit fraction. Two's complement representation.";
            sw = rw; hw = r;
            reset = 0x0;
        } cscp00[14:0];
    } V0_CSC_P0 @ 0x88c;
    reg {
        name = "V0_CSC_P1";
        desc = "V0_CSC_P1 is color space conversion parameter 1; immediate register. V0_CSC_P1 (offset 0x0890, total reset 0x0000_0000; PROVEN: Hi3535 data sheet, PDF page 1007, section 5.10).";
        field {
            name = "reserved";
            desc = "Reserved.";
            sw = r; hw = w;
            reset = 0x0;
        } reserved_31_31[31:31];
        field {
            name = "cscp10";
            desc = "5.10 data format: 1-bit sign, 4-bit integer part, 10-bit fraction. Two's complement representation.";
            sw = rw; hw = r;
            reset = 0x0;
        } cscp10[30:16];
        field {
            name = "reserved";
            desc = "Reserved.";
            sw = r; hw = w;
            reset = 0x0;
        } reserved_15_15[15:15];
        field {
            name = "cscp02";
            desc = "5.10 data format: 1-bit sign, 4-bit integer part, 10-bit fraction. Two's complement representation.";
            sw = rw; hw = r;
            reset = 0x0;
        } cscp02[14:0];
    } V0_CSC_P1 @ 0x890;
    reg {
        name = "V0_CSC_P2";
        desc = "V0_CSC_P2 is color space conversion parameter 2; an immediate register. V0_CSC_P2 (offset 0x0894, total reset 0x0000_0000; PROVEN: Hi3535 data sheet, PDF page 1008, section 5.10).";
        field {
            name = "reserved";
            desc = "Reserved.";
            sw = r; hw = w;
            reset = 0x0;
        } reserved_31_31[31:31];
        field {
            name = "cscp12";
            desc = "5.10 data format: 1-bit sign, 4-bit integer part, 10-bit fraction. Two's complement representation.";
            sw = rw; hw = r;
            reset = 0x0;
        } cscp12[30:16];
        field {
            name = "reserved";
            desc = "Reserved.";
            sw = r; hw = w;
            reset = 0x0;
        } reserved_15_15[15:15];
        field {
            name = "cscp11";
            desc = "5.10 data format: 1-bit sign, 4-bit integer part, 10-bit fraction. Two's complement representation.";
            sw = rw; hw = r;
            reset = 0x0;
        } cscp11[14:0];
    } V0_CSC_P2 @ 0x894;
    reg {
        name = "V0_CSC_P3";
        desc = "V0_CSC_P3 is color space conversion parameter 3, an immediate register. V0_CSC_P3 (offset 0x0898, total reset 0x0000_0000; PROVEN: Hi3535 data sheet, PDF page 1008, section 5.10).";
        field {
            name = "reserved";
            desc = "Reserved.";
            sw = r; hw = w;
            reset = 0x0;
        } reserved_31_31[31:31];
        field {
            name = "cscp21";
            desc = "5.10 data format: 1-bit sign, 4-bit integer part, 10-bit fraction. Two's complement representation.";
            sw = rw; hw = r;
            reset = 0x0;
        } cscp21[30:16];
        field {
            name = "reserved";
            desc = "Reserved.";
            sw = r; hw = w;
            reset = 0x0;
        } reserved_15_15[15:15];
        field {
            name = "cscp20";
            desc = "5.10 data format: 1-bit sign, 4-bit integer part, 10-bit fraction. Two's complement representation.";
            sw = rw; hw = r;
            reset = 0x0;
        } cscp20[14:0];
    } V0_CSC_P3 @ 0x898;
    reg {
        name = "V0_CSC_P4";
        desc = "V0_CSC_P4 is color space conversion parameter 4. It is an immediate register. V0_CSC_P4 (offset 0x089C, total reset 0x0000_0000; PROVEN: Hi3535 data sheet, PDF page 1009, section 5.10).";
        field {
            name = "reserved";
            desc = "Reserved.";
            sw = r; hw = w;
            reset = 0x0;
        } reserved_31_15[31:15];
        field {
            name = "cscp22";
            desc = "5.10 data format: 1-bit sign, 4-bit integer part, 10-bit fraction. Two's complement representation.";
            sw = rw; hw = r;
            reset = 0x0;
        } cscp22[14:0];
    } V0_CSC_P4 @ 0x89c;
    reg {
        name = "V0_HSP";
        desc = "V0_HSP is the horizontal scaling parameter configuration (horizontal Scaling Parameter) register. Not an immediate register. Scaling ratio = input width / output width. V0_HSP (offset 0x08C0, total reset 0x0010_0000; PROVEN: Hi3535 data sheet, PDF page 1009, section 5.10).";
        field {
            name = "hlmsc_en";
            desc = "Horizontal luma scaling enable.
- 0: Disable;
- 1: Enable.";
            sw = rw; hw = r;
            reset = 0x0;
        } hlmsc_en[31:31];
        field {
            name = "hchmsc_en";
            desc = "Horizontal chrominance scaling enable.
- 0: Disable.
- 1: Enable.";
            sw = rw; hw = r;
            reset = 0x0;
        } hchmsc_en[30:30];
        field {
            name = "hlmid_en";
            desc = "Horizontal luma scaling median filter enable (this bit has no effect when hlfir_en is inactive).
- 0: Disable;
- 1: Enable.";
            sw = rw; hw = r;
            reset = 0x0;
        } hlmid_en[29:29];
        field {
            name = "hchmid_en";
            desc = "Horizontal chroma scaling median filter enable (this bit has no effect when hchfir_en is inactive).
- 0: Disable;
- 1: Enable.";
            sw = rw; hw = r;
            reset = 0x0;
        } hchmid_en[28:28];
        field {
            name = "reserved";
            desc = "Reserved.";
            sw = r; hw = w;
            reset = 0x0;
        } reserved_27_27[27:27];
        field {
            name = "hlfir_en";
            desc = "Horizontal luma scaling mode.
- 0: Copy mode (filtering disabled);
- 1: Filter mode (filtering enabled).";
            sw = rw; hw = r;
            reset = 0x0;
        } hlfir_en[26:26];
        field {
            name = "hchfir_en";
            desc = "Horizontal chroma scaling mode.
- 0: Copy mode (filtering disabled);
- 1: Filter mode (filtering enabled).";
            sw = rw; hw = r;
            reset = 0x0;
        } hchfir_en[25:25];
        field {
            name = "hfir_order";
            desc = "Horizontal scaling position.
- 0: Horizontal scaling precedes vertical scaling;
- 1: Horizontal scaling follows vertical scaling.";
            sw = rw; hw = r;
            reset = 0x0;
        } hfir_order[24:24];
        field {
            name = "hratio";
            desc = "Horizontal scaling factor, (u,4,20) format.";
            sw = rw; hw = r;
            reset = 0x100000;
        } hratio[23:0];
    } V0_HSP @ 0x8c0;
    reg {
        name = "V0_HLOFFSET";
        desc = "V0_HLOFFSET is the luma horizontal position offset register. Used for pan-scan. Non-immediate register. V0_HLOFFSET (offset 0x08C4, total reset 0x0000_0000; PROVEN: Hi3535 data sheet, PDF page 1010, section 5.10).";
        field {
            name = "reserved";
            desc = "Reserved.";
            sw = r; hw = w;
            reset = 0x0;
        } reserved_31_28[31:28];
        field {
            name = "hor_loffset";
            desc = "Horizontal luma position offset, (s,8,20) format. Two's complement representation.";
            sw = rw; hw = r;
            reset = 0x0;
        } hor_loffset[27:0];
    } V0_HLOFFSET @ 0x8c4;
    reg {
        name = "V0_HCOFFSET";
        desc = "V0_HCOFFSET is the chroma horizontal position offset register. Used for pan-scan. Not an immediate register. V0_HCOFFSET (offset 0x08C8, total reset 0x0000_0000; PROVEN: Hi3535 data sheet, PDF page 1011, section 5.10).";
        field {
            name = "reserved";
            desc = "Reserved.";
            sw = r; hw = w;
            reset = 0x0;
        } reserved_31_28[31:28];
        field {
            name = "hor_coffset";
            desc = "Horizontal chrominance position offset, (s,8,20) format. Two's complement representation.";
            sw = rw; hw = r;
            reset = 0x0;
        } hor_coffset[27:0];
    } V0_HCOFFSET @ 0x8c8;
    reg {
        name = "V0_VSP";
        desc = "V0_VSP is the vertical scaling parameter (vertical Scaling Parameter) register. V0_VSP (offset 0x08D8, total reset 0x0000_0000; PROVEN: Hi3535 data sheet, PDF page 1011, section 5.10).";
        field {
            name = "vlmsc_en";
            desc = "Vertical luma scaling enable.
- 0: Disable;
- 1: Enable.";
            sw = rw; hw = r;
            reset = 0x0;
        } vlmsc_en[31:31];
        field {
            name = "vchmsc_en";
            desc = "Vertical chroma scaling enable.
- 0: Disable;
- 1: Enable.";
            sw = rw; hw = r;
            reset = 0x0;
        } vchmsc_en[30:30];
        field {
            name = "vlmid_en";
            desc = "Vertical luma scaling median filter enable (this bit has no effect when vlfir_en is inactive).
- 0: Disable.
- 1: Enable.";
            sw = rw; hw = r;
            reset = 0x0;
        } vlmid_en[29:29];
        field {
            name = "vchmid_en";
            desc = "Vertical chroma scaling median filter enable (this bit has no effect when vchfir_en is inactive).
- 0: Disable;
- 1: Enable.";
            sw = rw; hw = r;
            reset = 0x0;
        } vchmid_en[28:28];
        field {
            name = "reserved";
            desc = "Reserved.";
            sw = r; hw = w;
            reset = 0x0;
        } reserved_27_25[27:25];
        field {
            name = "vlfir_en";
            desc = "Vertical luminance scaling mode.
- 0: Copy mode (filtering disabled).
- 1: Filter mode (filtering enabled).";
            sw = rw; hw = r;
            reset = 0x0;
        } vlfir_en[24:24];
        field {
            name = "vchfir_en";
            desc = "Vertical chroma scaling mode.
- 0: Copy mode (filtering disabled);
- 1: Filter mode (filtering enabled).";
            sw = rw; hw = r;
            reset = 0x0;
        } vchfir_en[23:23];
        field {
            name = "zme_out_fmt";
            desc = "Scaling output data format.
- 0: 422;
- 1: 420.";
            sw = rw; hw = r;
            reset = 0x0;
        } zme_out_fmt[22:21];
        field {
            name = "zme_in_fmt";
            desc = "Scaling input data format.
- 0: 422;
- 1: 420.";
            sw = rw; hw = r;
            reset = 0x0;
        } zme_in_fmt[20:19];
        field {
            name = "reserved";
            desc = "Reserved.";
            sw = r; hw = w;
            reset = 0x0;
        } reserved_18_0[18:0];
    } V0_VSP @ 0x8d8;
    reg {
        name = "V0_VSR";
        desc = "V0_VSR is the vertical scaling ratio (Luma Vertical Scaling Ratio) register. Scaling ratio = input height / output height. Not an immediate register. V0_VSR (offset 0x08DC, total reset 0x0000_1000; PROVEN: Hi3535 data sheet, PDF page 1012, section 5.10).";
        field {
            name = "reserved";
            desc = "Reserved.";
            sw = r; hw = w;
            reset = 0x0;
        } reserved_31_16[31:16];
        field {
            name = "vratio";
            desc = "Vertical scaling factor, (u,4,12) format.";
            sw = rw; hw = r;
            reset = 0x1000;
        } vratio[15:0];
    } V0_VSR @ 0x8dc;
    reg {
        name = "V0_VOFFSET";
        desc = "V0_VOFFSET is the Vertical Scaling Offset register. The vertical scaling offset is affected by two factors: pan-scan and the field offset when frames are repeated. When there is no field offset, vluma_offset is the lowest integer bit plus the fractional bits of offset_pan-scan; in YCbCr422 format vchroma_offset equals vluma_offset; in YCbCr420 format, vchroma_offset = scaling_chroma/2-0.25. When a field offset is needed (for example for a still frame or a repeated frame), assuming the bottom field is repeated, the vluma_offset and vchroma_offset configured for the top field are the same as in the no-offset case above, and the bottom field configuration must take the field offset into account. V0_VOFFSET (offset 0x08E0, total reset 0x0000_0000; PROVEN: Hi3535 data sheet, PDF page 1013, section 5.10).";
        field {
            name = "vluma_offset";
            desc = "Vertical luma offset, two's complement representation, (s,4,12) format.";
            sw = rw; hw = r;
            reset = 0x0;
        } vluma_offset[31:16];
        field {
            name = "vchroma_offset";
            desc = "Vertical chroma offset, two's complement, (s,4,12) format.";
            sw = rw; hw = r;
            reset = 0x0;
        } vchroma_offset[15:0];
    } V0_VOFFSET @ 0x8e0;
    reg {
        name = "V0_VBOFFSET";
        desc = "V0_VBOFFSET is the bottom field vertical scaling offset (Vertical Scaling Offset) register. The vertical scaling offset is affected by two factors: pan-scan and the field offset when frames are repeated. When there is no field offset, vluma_offset is the lowest integer bit plus the fraction bits of offset_pan-scan; in YCbCr422 format, vchroma_offset equals vluma_offset; in YCbCr420 format, vchroma_offset = scaling_chroma/2-0.25. When a field offset is needed (for example for a still frame or repeated frame), assuming the bottom field is repeated, the vluma_offset and vchroma_offset configured for the top field are the same as in the no-offset case above, and the bottom field configuration must take the field offset into account. V0_VBOFFSET (offset 0x08E4, total reset 0x0000_0000; PROVEN: Hi3535 data sheet, PDF page 1013, section 5.10).";
        field {
            name = "vbluma_offset";
            desc = "Vertical luma offset, two's complement representation, (s,4,12) format.";
            sw = rw; hw = r;
            reset = 0x0;
        } vbluma_offset[31:16];
        field {
            name = "vbchroma_offset";
            desc = "Vertical chroma offset, two's complement, (s,4,12) format.";
            sw = rw; hw = r;
            reset = 0x0;
        } vbchroma_offset[15:0];
    } V0_VBOFFSET @ 0x8e4;
    reg {
        name = "V0_IFIRCOEF01";
        desc = "V0_IFIRCOEF01 is the IFIR filter coefficient 01 register. V0_IFIRCOEF01 (offset 0x0980, total reset 0x000F_03F5; PROVEN: Hi3535 data sheet, PDF page 1014, section 5.10).";
        field {
            name = "reserved";
            desc = "Reserved.";
            sw = r; hw = w;
            reset = 0x0;
        } reserved_31_26[31:26];
        field {
            name = "coef1";
            desc = "IFIR filter coefficient 1.";
            sw = rw; hw = r;
            reset = 0xf;
        } coef1[25:16];
        field {
            name = "reserved";
            desc = "Reserved.";
            sw = r; hw = w;
            reset = 0x0;
        } reserved_15_10[15:10];
        field {
            name = "coef0";
            desc = "IFIR filter coefficient 0.";
            sw = rw; hw = r;
            reset = 0x3f5;
        } coef0[9:0];
    } V0_IFIRCOEF01 @ 0x980;
    reg {
        name = "V0_IFIRCOEF23";
        desc = "V0_IFIRCOEF23 is IFIR filter coefficient 23 register. V0_IFIRCOEF23 (offset 0x0984, total reset 0x001C_03EC; PROVEN: Hi3535 data sheet, PDF page 1014, section 5.10).";
        field {
            name = "reserved";
            desc = "Reserved.";
            sw = r; hw = w;
            reset = 0x0;
        } reserved_31_26[31:26];
        field {
            name = "coef3";
            desc = "IFIR filter coefficient 3.";
            sw = rw; hw = r;
            reset = 0x1c;
        } coef3[25:16];
        field {
            name = "reserved";
            desc = "Reserved.";
            sw = r; hw = w;
            reset = 0x0;
        } reserved_15_10[15:10];
        field {
            name = "coef2";
            desc = "IFIR filter coefficient 2.";
            sw = rw; hw = r;
            reset = 0x3ec;
        } coef2[9:0];
    } V0_IFIRCOEF23 @ 0x984;
    reg {
        name = "V0_IFIRCOEF45";
        desc = "V0_IFIRCOEF45 is the IFIR filter coefficient 45 register. V0_IFIRCOEF45 (offset 0x0988, total reset 0x003D_03D8; PROVEN: Hi3535 data sheet, PDF page 1015, section 5.10).";
        field {
            name = "reserved";
            desc = "Reserved.";
            sw = r; hw = w;
            reset = 0x0;
        } reserved_31_26[31:26];
        field {
            name = "coef5";
            desc = "IFIR filter coefficient 5.";
            sw = rw; hw = r;
            reset = 0x3d;
        } coef5[25:16];
        field {
            name = "reserved";
            desc = "Reserved.";
            sw = r; hw = w;
            reset = 0x0;
        } reserved_15_10[15:10];
        field {
            name = "coef4";
            desc = "IFIR filter coefficient 4.";
            sw = rw; hw = r;
            reset = 0x3d8;
        } coef4[9:0];
    } V0_IFIRCOEF45 @ 0x988;
    reg {
        name = "V0_IFIRCOEF67";
        desc = "V0_IFIRCOEF67 is IFIR filter coefficient 67 register. V0_IFIRCOEF67 (offset 0x098C, total reset 0x014A_0395; PROVEN: Hi3535 data sheet, PDF page 1015, section 5.10).";
        field {
            name = "reserved";
            desc = "Reserved.";
            sw = r; hw = w;
            reset = 0x0;
        } reserved_31_26[31:26];
        field {
            name = "coef7";
            desc = "IFIR filter coefficient 7.";
            sw = rw; hw = r;
            reset = 0x14a;
        } coef7[25:16];
        field {
            name = "reserved";
            desc = "Reserved.";
            sw = r; hw = w;
            reset = 0x0;
        } reserved_15_10[15:10];
        field {
            name = "coef6";
            desc = "IFIR filter coefficient 6.";
            sw = rw; hw = r;
            reset = 0x395;
        } coef6[9:0];
    } V0_IFIRCOEF67 @ 0x98c;
    reg {
        name = "V0_P0RESO";
        desc = "V0_P0RESO is the resolution register of video layer partition 0; non-immediate register. Video layers V0/V3 support multiple regions and these registers are configurable. V1/V4 do not support them and these registers are not configurable. V0_P0RESO (offset 0x0A00, total reset 0x0000_0000; PROVEN: Hi3535 data sheet, PDF page 1016, section 5.10).";
        field {
            name = "reserved";
            desc = "Reserved.";
            sw = rw; hw = r;
            reset = 0x0;
        } reserved_31_12[31:12];
        field {
            name = "w";
            desc = "Width, in pixels. Actual width minus 1. Note: The actual width must be even.";
            sw = rw; hw = r;
            reset = 0x0;
        } w_[11:0];
    } V0_P0RESO @ 0xa00;
    reg {
        name = "V0_P0LADDR";
        desc = "V0_P0LADDR is the luma address register of video layer region 0. V0_P0LADDR (offset 0x0A04, total reset 0x0000_0000; PROVEN: Hi3535 data sheet, PDF page 1016, section 5.10).";
        field {
            name = "surface_addr";
            desc = "Start address register of video layer partition 0.";
            sw = rw; hw = r;
            reset = 0x0;
        } surface_addr[31:0];
    } V0_P0LADDR @ 0xa04;
    reg {
        name = "V0_P0CADDR";
        desc = "V0_P0CADDR is the chroma address register of video layer region 0. V0_P0CADDR (offset 0x0A08, total reset 0x0000_0000; PROVEN: Hi3535 data sheet, PDF page 1016, section 5.10).";
        field {
            name = "surface_addr";
            desc = "Chroma start address register of video layer partition 0.";
            sw = rw; hw = r;
            reset = 0x0;
        } surface_addr[31:0];
    } V0_P0CADDR @ 0xa08;
    reg {
        name = "V0_P0STRIDE";
        desc = "V0_P0STRIDE is the stride register of video layer partition 0. V0_P0STRIDE (offset 0x0A0C, total reset 0x0000_0000; PROVEN: Hi3535 data sheet, PDF page 1017, section 5.10).";
        field {
            name = "surface_cstride";
            desc = "Stride of the chroma buffer of video layer region 0 (useful for the semi-planar format), 128-bit aligned.";
            sw = rw; hw = r;
            reset = 0x0;
        } surface_cstride[31:16];
        field {
            name = "surface_stride";
            desc = "Stride of the video layer region 0 buffer (for semi-planar formats, the luma stride), 128-bit aligned.";
            sw = rw; hw = r;
            reset = 0x0;
        } surface_stride[15:0];
    } V0_P0STRIDE @ 0xa0c;
    reg {
        name = "V0_P0VFPOS";
        desc = "V0_P0VFPOS is the start position (First Position) of video layer partition 0 in the video content, in pixels, a non-immediate register. V0_P0VFPOS (offset 0x0A10, total reset 0x0000_0000; PROVEN: Hi3535 data sheet, PDF page 1017, section 5.10).";
        field {
            name = "reserved";
            desc = "Reserved.";
            sw = r; hw = w;
            reset = 0x0;
        } reserved_31_24[31:24];
        field {
            name = "video_yfpos";
            desc = "Start coordinate of the video content column. Referenced to the frame height, in lines.";
            sw = rw; hw = r;
            reset = 0x0;
        } video_yfpos[23:12];
        field {
            name = "video_xfpos";
            desc = "Video content line start coordinate.";
            sw = rw; hw = r;
            reset = 0x0;
        } video_xfpos[11:0];
    } V0_P0VFPOS @ 0xa10;
    reg {
        name = "V0_P0VLPOS";
        desc = "V0_P0VLPOS is the end position (First Position) of video layer partition 0 in the video content, in pixels, a non-immediate register. V0_P0VLPOS (offset 0x0A14, total reset 0x0000_0000; PROVEN: Hi3535 data sheet, PDF page 1018, section 5.10).";
        field {
            name = "reserved";
            desc = "Reserved.";
            sw = r; hw = w;
            reset = 0x0;
        } reserved_31_24[31:24];
        field {
            name = "video_ylpos";
            desc = "Start coordinate of the video content column. Referenced to the frame height, in lines.";
            sw = rw; hw = r;
            reset = 0x0;
        } video_ylpos[23:12];
        field {
            name = "video_xlpos";
            desc = "Video content line start coordinate.";
            sw = rw; hw = r;
            reset = 0x0;
        } video_xlpos[11:0];
    } V0_P0VLPOS @ 0xa14;
    reg {
        name = "V0_P1RESO";
        desc = "V0_P1RESO is the resolution register of video layer partition 1, a non-immediate register. V0_P1RESO (offset 0x0A20, total reset 0x0000_0000; PROVEN: Hi3535 data sheet, PDF page 1018, section 5.10).";
        field {
            name = "reserved";
            desc = "Reserved.";
            sw = r; hw = w;
            reset = 0x0;
        } reserved_31_12[31:12];
        field {
            name = "w";
            desc = "Width, in pixels. Actual width minus 1. Note: The actual width must be even.";
            sw = rw; hw = r;
            reset = 0x0;
        } w_[11:0];
    } V0_P1RESO @ 0xa20;
    reg {
        name = "V0_P1LADDR";
        desc = "V0_P1LADDR is the luma address register of video layer region 1. V0_P1LADDR (offset 0x0A24, total reset 0x0000_0000; PROVEN: Hi3535 data sheet, PDF page 1019, section 5.10).";
        field {
            name = "surface_addr";
            desc = "Luma start address register of video layer partition 1.";
            sw = rw; hw = r;
            reset = 0x0;
        } surface_addr[31:0];
    } V0_P1LADDR @ 0xa24;
    reg {
        name = "V0_P1CADDR";
        desc = "V0_P1CADDR is the chroma address register of video layer partition 1. V0_P1CADDR (offset 0x0A28, total reset 0x0000_0000; PROVEN: Hi3535 data sheet, PDF page 1019, section 5.10).";
        field {
            name = "surface_addr";
            desc = "Chrominance start address register of video layer partition 1.";
            sw = rw; hw = r;
            reset = 0x0;
        } surface_addr[31:0];
    } V0_P1CADDR @ 0xa28;
    reg {
        name = "V0_P1STRIDE";
        desc = "V0_P1STRIDE is the stride register of video layer partition 1. V0_P1STRIDE (offset 0x0A2C, total reset 0x0000_0000; PROVEN: Hi3535 data sheet, PDF page 1019, section 5.10).";
        field {
            name = "surface_cstride";
            desc = "Stride of the chroma buffer of video layer partition 1 (useful for the semi-planar format), 128-bit aligned.";
            sw = rw; hw = r;
            reset = 0x0;
        } surface_cstride[31:16];
        field {
            name = "surface_stride";
            desc = "Stride of the video layer partition 1 buffer (the luma stride for the semi-planar format), 128-bit aligned.";
            sw = rw; hw = r;
            reset = 0x0;
        } surface_stride[15:0];
    } V0_P1STRIDE @ 0xa2c;
    reg {
        name = "V0_P1VFPOS";
        desc = "V0_P1VFPOS is the start position (First Position) of video layer partition 1 in the video content, in pixels; non-immediate register. V0_P1VFPOS (offset 0x0A30, total reset 0x0000_0000; PROVEN: Hi3535 data sheet, PDF page 1020, section 5.10).";
        field {
            name = "reserved";
            desc = "Reserved.";
            sw = r; hw = w;
            reset = 0x0;
        } reserved_31_24[31:24];
        field {
            name = "video_yfpos";
            desc = "Start coordinate of the video content column. Referenced to the frame height, in lines.";
            sw = rw; hw = r;
            reset = 0x0;
        } video_yfpos[23:12];
        field {
            name = "video_xfpos";
            desc = "Video content line start coordinate.";
            sw = rw; hw = r;
            reset = 0x0;
        } video_xfpos[11:0];
    } V0_P1VFPOS @ 0xa30;
    reg {
        name = "V0_P1VLPOS";
        desc = "V0_P1VLPOS is the end position (Last Position) of video layer region 1 within the video content, in pixels. It is a non-immediate register. V0_P1VLPOS (offset 0x0A34, total reset 0x0000_0000; PROVEN: Hi3535 data sheet, PDF page 1020, section 5.10).";
        field {
            name = "reserved";
            desc = "Reserved.";
            sw = r; hw = w;
            reset = 0x0;
        } reserved_31_24[31:24];
        field {
            name = "video_ylpos";
            desc = "Start coordinate of the video content column. Referenced to the frame height, in lines.";
            sw = rw; hw = r;
            reset = 0x0;
        } video_ylpos[23:12];
        field {
            name = "video_xlpos";
            desc = "Video content line start coordinate.";
            sw = rw; hw = r;
            reset = 0x0;
        } video_xlpos[11:0];
    } V0_P1VLPOS @ 0xa34;
    reg {
        name = "V0_P2RESO";
        desc = "V0_P2RESO is the resolution register of video layer region 2, not an immediate register. V0_P2RESO (offset 0x0A40, total reset 0x0000_0000; PROVEN: Hi3535 data sheet, PDF page 1021, section 5.10).";
        field {
            name = "reserved";
            desc = "Reserved.";
            sw = r; hw = w;
            reset = 0x0;
        } reserved_31_12[31:12];
        field {
            name = "w";
            desc = "Width, in pixels. Actual width minus 1. Note: The actual width must be even.";
            sw = rw; hw = r;
            reset = 0x0;
        } w_[11:0];
    } V0_P2RESO @ 0xa40;
    reg {
        name = "V0_P2LADDR";
        desc = "V0_P2LADDR is the luma address register of video layer partition 2. V0_P2LADDR (offset 0x0A44, total reset 0x0000_0000; PROVEN: Hi3535 data sheet, PDF page 1021, section 5.10).";
        field {
            name = "surface_addr";
            desc = "Luma start address register of video layer partition 2.";
            sw = rw; hw = r;
            reset = 0x0;
        } surface_addr[31:0];
    } V0_P2LADDR @ 0xa44;
    reg {
        name = "V0_P2CADDR";
        desc = "V0_P2CADDR is the chroma address register of video layer partition 2. V0_P2CADDR (offset 0x0A48, total reset 0x0000_0000; PROVEN: Hi3535 data sheet, PDF page 1021, section 5.10).";
        field {
            name = "surface_addr";
            desc = "Chroma start address register of video layer partition 2.";
            sw = rw; hw = r;
            reset = 0x0;
        } surface_addr[31:0];
    } V0_P2CADDR @ 0xa48;
    reg {
        name = "V0_P2STRIDE";
        desc = "V0_P2STRIDE is the stride register of video layer partition 2. V0_P2STRIDE (offset 0x0A4C, total reset 0x0000_0000; PROVEN: Hi3535 data sheet, PDF page 1022, section 5.10).";
        field {
            name = "surface_cstride";
            desc = "Stride of the chroma buffer of video layer region 2 (useful for the semi-planar format), 128-bit aligned.";
            sw = rw; hw = r;
            reset = 0x0;
        } surface_cstride[31:16];
        field {
            name = "surface_stride";
            desc = "Stride of the video layer region 2 buffer (for semi-planar formats, the luma stride), 128-bit aligned.";
            sw = rw; hw = r;
            reset = 0x0;
        } surface_stride[15:0];
    } V0_P2STRIDE @ 0xa4c;
    reg {
        name = "V0_P2VFPOS";
        desc = "V0_P2VFPOS is the start position (First Position) of video layer partition 2 in the video content, in pixels, a non-immediate register. V0_P2VFPOS (offset 0x0A50, total reset 0x0000_0000; PROVEN: Hi3535 data sheet, PDF page 1022, section 5.10).";
        field {
            name = "reserved";
            desc = "Reserved.";
            sw = r; hw = w;
            reset = 0x0;
        } reserved_31_24[31:24];
        field {
            name = "video_yfpos";
            desc = "Start coordinate of the video content column. Referenced to the frame height, in lines.";
            sw = rw; hw = r;
            reset = 0x0;
        } video_yfpos[23:12];
        field {
            name = "video_xfpos";
            desc = "Video content line start coordinate.";
            sw = rw; hw = r;
            reset = 0x0;
        } video_xfpos[11:0];
    } V0_P2VFPOS @ 0xa50;
    reg {
        name = "V0_P2VLPOS";
        desc = "V0_P2VLPOS is the end position (Last Position) of video layer partition 2 in the video content, in pixels, a non-immediate register. V0_P2VLPOS (offset 0x0A54, total reset 0x0000_0000; PROVEN: Hi3535 data sheet, PDF page 1023, section 5.10).";
        field {
            name = "reserved";
            desc = "Reserved.";
            sw = r; hw = w;
            reset = 0x0;
        } reserved_31_24[31:24];
        field {
            name = "video_ylpos";
            desc = "Start coordinate of the video content column. Referenced to the frame height, in lines.";
            sw = rw; hw = r;
            reset = 0x0;
        } video_ylpos[23:12];
        field {
            name = "video_xlpos";
            desc = "Video content line start coordinate.";
            sw = rw; hw = r;
            reset = 0x0;
        } video_xlpos[11:0];
    } V0_P2VLPOS @ 0xa54;
    reg {
        name = "V0_P3RESO";
        desc = "V0_P3RESO is the resolution register of video layer partition 3; non-immediate register. V0_P3RESO (offset 0x0A60, total reset 0x0000_0000; PROVEN: Hi3535 data sheet, PDF page 1023, section 5.10).";
        field {
            name = "reserved";
            desc = "Reserved.";
            sw = r; hw = w;
            reset = 0x0;
        } reserved_31_12[31:12];
        field {
            name = "w";
            desc = "Width, in pixels. Actual width minus 1. Note: The actual width must be even.";
            sw = rw; hw = r;
            reset = 0x0;
        } w_[11:0];
    } V0_P3RESO @ 0xa60;
    reg {
        name = "V0_P3LADDR";
        desc = "V0_P3LADDR is the luma address register of video layer region 3. V0_P3LADDR (offset 0x0A64, total reset 0x0000_0000; PROVEN: Hi3535 data sheet, PDF page 1024, section 5.10).";
        field {
            name = "surface_addr";
            desc = "Luma start address register of video layer partition 3.";
            sw = rw; hw = r;
            reset = 0x0;
        } surface_addr[31:0];
    } V0_P3LADDR @ 0xa64;
    reg {
        name = "V0_P3CADDR";
        desc = "V0_P3CADDR is the chrominance address register of video layer partition 3. V0_P3CADDR (offset 0x0A68, total reset 0x0000_0000; PROVEN: Hi3535 data sheet, PDF page 1024, section 5.10).";
        field {
            name = "surface_addr";
            desc = "Chrominance start address register of video layer partition 3.";
            sw = rw; hw = r;
            reset = 0x0;
        } surface_addr[31:0];
    } V0_P3CADDR @ 0xa68;
    reg {
        name = "V0_P3STRIDE";
        desc = "V0_P3STRIDE is the stride register of video layer region 3. V0_P3STRIDE (offset 0x0A6C, total reset 0x0000_0000; PROVEN: Hi3535 data sheet, PDF page 1024, section 5.10).";
        field {
            name = "surface_cstride";
            desc = "Stride of the video layer partition 3 chroma buffer (used for the semi-planar format), 128-bit aligned.";
            sw = rw; hw = r;
            reset = 0x0;
        } surface_cstride[31:16];
        field {
            name = "surface_stride";
            desc = "Stride of the buffer of video layer partition 3 (for the semi-planar format, the luma stride), 128-bit aligned.";
            sw = rw; hw = r;
            reset = 0x0;
        } surface_stride[15:0];
    } V0_P3STRIDE @ 0xa6c;
    reg {
        name = "V0_P3VFPOS";
        desc = "V0_P3VFPOS is the start position (First Position) of video layer partition 3 in the video content, in pixels; not an immediate register. V0_P3VFPOS (offset 0x0A70, total reset 0x0000_0000; PROVEN: Hi3535 data sheet, PDF page 1025, section 5.10).";
        field {
            name = "reserved";
            desc = "Reserved.";
            sw = r; hw = w;
            reset = 0x0;
        } reserved_31_24[31:24];
        field {
            name = "video_yfpos";
            desc = "Start coordinate of the video content column. Referenced to the frame height, in lines.";
            sw = rw; hw = r;
            reset = 0x0;
        } video_yfpos[23:12];
        field {
            name = "video_xfpos";
            desc = "Video content line start coordinate.";
            sw = rw; hw = r;
            reset = 0x0;
        } video_xfpos[11:0];
    } V0_P3VFPOS @ 0xa70;
    reg {
        name = "V0_P3VLPOS";
        desc = "V0_P3VLPOS is the end position (Last Position) of video layer region 3 in the video content, in pixels, not an immediate register. V0_P3VLPOS (offset 0x0A74, total reset 0x0000_0000; PROVEN: Hi3535 data sheet, PDF page 1025, section 5.10).";
        field {
            name = "reserved";
            desc = "Reserved.";
            sw = r; hw = w;
            reset = 0x0;
        } reserved_31_24[31:24];
        field {
            name = "video_ylpos";
            desc = "Start coordinate of the video content column. Referenced to the frame height, in lines.";
            sw = rw; hw = r;
            reset = 0x0;
        } video_ylpos[23:12];
        field {
            name = "video_xlpos";
            desc = "Video content line start coordinate.";
            sw = rw; hw = r;
            reset = 0x0;
        } video_xlpos[11:0];
    } V0_P3VLPOS @ 0xa74;
    reg {
        name = "V0_P4RESO";
        desc = "V0_P4RESO is the resolution register of video layer partition 4, a non-immediate register. V0_P4RESO (offset 0x0A80, total reset 0x0000_0000; PROVEN: Hi3535 data sheet, PDF page 1026, section 5.10).";
        field {
            name = "reserved";
            desc = "Reserved.";
            sw = r; hw = w;
            reset = 0x0;
        } reserved_31_12[31:12];
        field {
            name = "w";
            desc = "Width, in pixels. Actual width minus 1. Note: The actual width must be even.";
            sw = rw; hw = r;
            reset = 0x0;
        } w_[11:0];
    } V0_P4RESO @ 0xa80;
    reg {
        name = "V0_P4LADDR";
        desc = "V0_P4LADDR is the luma address register of video layer partition 4. V0_P4LADDR (offset 0x0A84, total reset 0x0000_0000; PROVEN: Hi3535 data sheet, PDF page 1026, section 5.10).";
        field {
            name = "surface_addr";
            desc = "Luminance start address register of video layer partition 4.";
            sw = rw; hw = r;
            reset = 0x0;
        } surface_addr[31:0];
    } V0_P4LADDR @ 0xa84;
    reg {
        name = "V0_P4CADDR";
        desc = "V0_P4CADDR is the chroma address register of video layer region 4. V0_P4CADDR (offset 0x0A88, total reset 0x0000_0000; PROVEN: Hi3535 data sheet, PDF page 1026, section 5.10).";
        field {
            name = "surface_addr";
            desc = "Chroma start address register of video layer region 4.";
            sw = rw; hw = r;
            reset = 0x0;
        } surface_addr[31:0];
    } V0_P4CADDR @ 0xa88;
    reg {
        name = "V0_P4STRIDE";
        desc = "V0_P4STRIDE is the stride register of video layer partition 4. V0_P4STRIDE (offset 0x0A8C, total reset 0x0000_0000; PROVEN: Hi3535 data sheet, PDF page 1027, section 5.10).";
        field {
            name = "surface_cstride";
            desc = "Stride of the chroma buffer of video layer region 4 (useful for the semi-planar format), 128-bit aligned.";
            sw = rw; hw = r;
            reset = 0x0;
        } surface_cstride[31:16];
        field {
            name = "surface_stride";
            desc = "Stride of the video layer partition 4 buffer (for the semi-planar format, the luma stride), 128-bit aligned.";
            sw = rw; hw = r;
            reset = 0x0;
        } surface_stride[15:0];
    } V0_P4STRIDE @ 0xa8c;
    reg {
        name = "V0_P4VFPOS";
        desc = "V0_P4VFPOS is the start position (First Position) of video layer region 4 within the video content, in pixels. It is a non-immediate register. V0_P4VFPOS (offset 0x0A90, total reset 0x0000_0000; PROVEN: Hi3535 data sheet, PDF page 1027, section 5.10).";
        field {
            name = "reserved";
            desc = "Reserved.";
            sw = r; hw = w;
            reset = 0x0;
        } reserved_31_24[31:24];
        field {
            name = "video_yfpos";
            desc = "Start coordinate of the video content column. Referenced to the frame height, in lines.";
            sw = rw; hw = r;
            reset = 0x0;
        } video_yfpos[23:12];
        field {
            name = "video_xfpos";
            desc = "Video content line start coordinate.";
            sw = rw; hw = r;
            reset = 0x0;
        } video_xfpos[11:0];
    } V0_P4VFPOS @ 0xa90;
    reg {
        name = "V0_P4VLPOS";
        desc = "V0_P4VLPOS is the end position (Last Position) of video layer partition 4 in the video content, in pixels; non-immediate register. V0_P4VLPOS (offset 0x0A94, total reset 0x0000_0000; PROVEN: Hi3535 data sheet, PDF page 1028, section 5.10).";
        field {
            name = "reserved";
            desc = "Reserved.";
            sw = r; hw = w;
            reset = 0x0;
        } reserved_31_24[31:24];
        field {
            name = "video_ylpos";
            desc = "Start coordinate of the video content column. Referenced to the frame height, in lines.";
            sw = rw; hw = r;
            reset = 0x0;
        } video_ylpos[23:12];
        field {
            name = "video_xlpos";
            desc = "Video content line start coordinate.";
            sw = rw; hw = r;
            reset = 0x0;
        } video_xlpos[11:0];
    } V0_P4VLPOS @ 0xa94;
    reg {
        name = "V0_P5RESO";
        desc = "V0_P5RESO is the resolution register of video layer region 5, not an immediate register. V0_P5RESO (offset 0x0AA0, total reset 0x0000_0000; PROVEN: Hi3535 data sheet, PDF page 1028, section 5.10).";
        field {
            name = "reserved";
            desc = "Reserved.";
            sw = r; hw = w;
            reset = 0x0;
        } reserved_31_12[31:12];
        field {
            name = "w";
            desc = "Width, in pixels. Actual width minus 1. Note: The actual width must be even.";
            sw = rw; hw = r;
            reset = 0x0;
        } w_[11:0];
    } V0_P5RESO @ 0xaa0;
    reg {
        name = "V0_P5LADDR";
        desc = "V0_P5LADDR is the luma address register of video layer partition 5. V0_P5LADDR (offset 0x0AA4, total reset 0x0000_0000; PROVEN: Hi3535 data sheet, PDF page 1029, section 5.10).";
        field {
            name = "surface_addr";
            desc = "Luma start address register of video layer region 5.";
            sw = rw; hw = r;
            reset = 0x0;
        } surface_addr[31:0];
    } V0_P5LADDR @ 0xaa4;
    reg {
        name = "V0_P5CADDR";
        desc = "V0_P5CADDR is the chroma address register of video layer partition 5. V0_P5CADDR (offset 0x0AA8, total reset 0x0000_0000; PROVEN: Hi3535 data sheet, PDF page 1029, section 5.10).";
        field {
            name = "surface_addr";
            desc = "Chroma start address register of video layer partition 5.";
            sw = rw; hw = r;
            reset = 0x0;
        } surface_addr[31:0];
    } V0_P5CADDR @ 0xaa8;
    reg {
        name = "V0_P5STRIDE";
        desc = "V0_P5STRIDE is the stride register of video layer partition 5. V0_P5STRIDE (offset 0x0AAC, total reset 0x0000_0000; PROVEN: Hi3535 data sheet, PDF page 1029, section 5.10).";
        field {
            name = "surface_cstride";
            desc = "Stride of the video layer partition 5 chroma buffer (used for the semi-planar format), 128-bit aligned.";
            sw = rw; hw = r;
            reset = 0x0;
        } surface_cstride[31:16];
        field {
            name = "surface_stride";
            desc = "Stride of the video layer partition 5 buffer (for the semi-planar format, the luminance stride), 128-bit aligned.";
            sw = rw; hw = r;
            reset = 0x0;
        } surface_stride[15:0];
    } V0_P5STRIDE @ 0xaac;
    reg {
        name = "V0_P5VFPOS";
        desc = "V0_P5VFPOS is the start position (First Position) of video layer partition 5 in the video content, in pixels, a non-immediate register. V0_P5VFPOS (offset 0x0AB0, total reset 0x0000_0000; PROVEN: Hi3535 data sheet, PDF page 1030, section 5.10).";
        field {
            name = "reserved";
            desc = "Reserved.";
            sw = r; hw = w;
            reset = 0x0;
        } reserved_31_24[31:24];
        field {
            name = "video_yfpos";
            desc = "Start coordinate of the video content column. Referenced to the frame height, in lines.";
            sw = rw; hw = r;
            reset = 0x0;
        } video_yfpos[23:12];
        field {
            name = "video_xfpos";
            desc = "Video content line start coordinate.";
            sw = rw; hw = r;
            reset = 0x0;
        } video_xfpos[11:0];
    } V0_P5VFPOS @ 0xab0;
    reg {
        name = "V0_P5VLPOS";
        desc = "V0_P5VLPOS is the end position (Last Position) of video layer partition 5 in the video content, in pixels, a non-immediate register. V0_P5VLPOS (offset 0x0AB4, total reset 0x0000_0000; PROVEN: Hi3535 data sheet, PDF page 1030, section 5.10).";
        field {
            name = "reserved";
            desc = "Reserved.";
            sw = r; hw = w;
            reset = 0x0;
        } reserved_31_24[31:24];
        field {
            name = "video_ylpos";
            desc = "Start coordinate of the video content column. Referenced to the frame height, in lines.";
            sw = rw; hw = r;
            reset = 0x0;
        } video_ylpos[23:12];
        field {
            name = "video_xlpos";
            desc = "Video content line start coordinate.";
            sw = rw; hw = r;
            reset = 0x0;
        } video_xlpos[11:0];
    } V0_P5VLPOS @ 0xab4;
    reg {
        name = "V0_P6RESO";
        desc = "V0_P6RESO is the resolution register of video layer region 6. It is a non-immediate register. V0_P6RESO (offset 0x0AC0, total reset 0x0000_0000; PROVEN: Hi3535 data sheet, PDF page 1031, section 5.10).";
        field {
            name = "reserved";
            desc = "Reserved.";
            sw = r; hw = w;
            reset = 0x0;
        } reserved_31_12[31:12];
        field {
            name = "w";
            desc = "Width, in pixels. Actual width minus 1. Note: The actual width must be even.";
            sw = rw; hw = r;
            reset = 0x0;
        } w_[11:0];
    } V0_P6RESO @ 0xac0;
    reg {
        name = "V0_P6LADDR";
        desc = "V0_P6LADDR is the luma address register of video layer region 6. V0_P6LADDR (offset 0x0AC4, total reset 0x0000_0000; PROVEN: Hi3535 data sheet, PDF page 1031, section 5.10).";
        field {
            name = "surface_addr";
            desc = "Luma start address register of video layer partition 6.";
            sw = rw; hw = r;
            reset = 0x0;
        } surface_addr[31:0];
    } V0_P6LADDR @ 0xac4;
    reg {
        name = "V0_P6CADDR";
        desc = "V0_P6CADDR is the chrominance address register of video layer partition 6. V0_P6CADDR (offset 0x0AC8, total reset 0x0000_0000; PROVEN: Hi3535 data sheet, PDF page 1031, section 5.10).";
        field {
            name = "surface_addr";
            desc = "Chroma start address register of video layer partition 6.";
            sw = rw; hw = r;
            reset = 0x0;
        } surface_addr[31:0];
    } V0_P6CADDR @ 0xac8;
    reg {
        name = "V0_P6STRIDE";
        desc = "V0_P6STRIDE is the stride register of video layer partition 6. V0_P6STRIDE (offset 0x0ACC, total reset 0x0000_0000; PROVEN: Hi3535 data sheet, PDF page 1032, section 5.10).";
        field {
            name = "surface_cstride";
            desc = "Stride of the chroma buffer of video layer region 6 (useful for the semi-planar format), 128-bit aligned.";
            sw = rw; hw = r;
            reset = 0x0;
        } surface_cstride[31:16];
        field {
            name = "surface_stride";
            desc = "Stride of the video layer region 6 buffer (for semi-planar formats, the luma stride), 128-bit aligned.";
            sw = rw; hw = r;
            reset = 0x0;
        } surface_stride[15:0];
    } V0_P6STRIDE @ 0xacc;
    reg {
        name = "V0_P6VFPOS";
        desc = "V0_P6VFPOS is the start position (First Position) of video layer partition 6 in the video content, in pixels; not an immediate register. V0_P6VFPOS (offset 0x0AD0, total reset 0x0000_0000; PROVEN: Hi3535 data sheet, PDF page 1032, section 5.10).";
        field {
            name = "reserved";
            desc = "Reserved.";
            sw = r; hw = w;
            reset = 0x0;
        } reserved_31_24[31:24];
        field {
            name = "video_yfpos";
            desc = "Start coordinate of the video content column. Referenced to the frame height, in lines.";
            sw = rw; hw = r;
            reset = 0x0;
        } video_yfpos[23:12];
        field {
            name = "video_xfpos";
            desc = "Video content line start coordinate.";
            sw = rw; hw = r;
            reset = 0x0;
        } video_xfpos[11:0];
    } V0_P6VFPOS @ 0xad0;
    reg {
        name = "V0_P6VLPOS";
        desc = "V0_P6VLPOS is the end position (Last Position) of video layer region 6 in the video content, in pixels, not an immediate register. V0_P6VLPOS (offset 0x0AD4, total reset 0x0000_0000; PROVEN: Hi3535 data sheet, PDF page 1033, section 5.10).";
        field {
            name = "reserved";
            desc = "Reserved.";
            sw = r; hw = w;
            reset = 0x0;
        } reserved_31_24[31:24];
        field {
            name = "video_ylpos";
            desc = "Start coordinate of the video content column. Referenced to the frame height, in lines.";
            sw = rw; hw = r;
            reset = 0x0;
        } video_ylpos[23:12];
        field {
            name = "video_xlpos";
            desc = "Video content line start coordinate.";
            sw = rw; hw = r;
            reset = 0x0;
        } video_xlpos[11:0];
    } V0_P6VLPOS @ 0xad4;
    reg {
        name = "V0_P7RESO";
        desc = "V0_P7RESO is the resolution register of video layer partition 7, a non-immediate register. V0_P7RESO (offset 0x0AE0, total reset 0x0000_0000; PROVEN: Hi3535 data sheet, PDF page 1033, section 5.10).";
        field {
            name = "reserved";
            desc = "Reserved.";
            sw = r; hw = w;
            reset = 0x0;
        } reserved_31_12[31:12];
        field {
            name = "w";
            desc = "Width, in pixels. Actual width minus 1. Note: The actual width must be even.";
            sw = rw; hw = r;
            reset = 0x0;
        } w_[11:0];
    } V0_P7RESO @ 0xae0;
    reg {
        name = "V0_P7LADDR";
        desc = "V0_P7LADDR is the luma address register of video layer region 7. V0_P7LADDR (offset 0x0AE4, total reset 0x0000_0000; PROVEN: Hi3535 data sheet, PDF page 1034, section 5.10).";
        field {
            name = "surface_addr";
            desc = "Luma start address register of video layer partition 7.";
            sw = rw; hw = r;
            reset = 0x0;
        } surface_addr[31:0];
    } V0_P7LADDR @ 0xae4;
    reg {
        name = "V0_P7CADDR";
        desc = "V0_P7CADDR is the chroma address register of video layer partition 7. V0_P7CADDR (offset 0x0AE8, total reset 0x0000_0000; PROVEN: Hi3535 data sheet, PDF page 1034, section 5.10).";
        field {
            name = "surface_addr";
            desc = "Chrominance start address register of video layer partition 7.";
            sw = rw; hw = r;
            reset = 0x0;
        } surface_addr[31:0];
    } V0_P7CADDR @ 0xae8;
    reg {
        name = "V0_P7STRIDE";
        desc = "V0_P7STRIDE is the stride register of video layer partition 7. V0_P7STRIDE (offset 0x0AEC, total reset 0x0000_0000; PROVEN: Hi3535 data sheet, PDF page 1034, section 5.10).";
        field {
            name = "surface_cstride";
            desc = "Stride of the video layer partition 7 chroma buffer (used for the semi-planar format), 128-bit aligned.";
            sw = rw; hw = r;
            reset = 0x0;
        } surface_cstride[31:16];
        field {
            name = "surface_stride";
            desc = "Stride of the buffer of video layer partition 7 (for the semi-planar format, the luma stride), 128-bit aligned.";
            sw = rw; hw = r;
            reset = 0x0;
        } surface_stride[15:0];
    } V0_P7STRIDE @ 0xaec;
    reg {
        name = "V0_P7VFPOS";
        desc = "V0_P7VFPOS is the start position (First Position) of video layer partition 7 in the video content, in pixels; non-immediate register. V0_P7VFPOS (offset 0x0AF0, total reset 0x0000_0000; PROVEN: Hi3535 data sheet, PDF page 1035, section 5.10).";
        field {
            name = "reserved";
            desc = "Reserved.";
            sw = r; hw = w;
            reset = 0x0;
        } reserved_31_24[31:24];
        field {
            name = "video_yfpos";
            desc = "Start coordinate of the video content column. Referenced to the frame height, in lines.";
            sw = rw; hw = r;
            reset = 0x0;
        } video_yfpos[23:12];
        field {
            name = "video_xfpos";
            desc = "Video content line start coordinate.";
            sw = rw; hw = r;
            reset = 0x0;
        } video_xfpos[11:0];
    } V0_P7VFPOS @ 0xaf0;
    reg {
        name = "V0_P7VLPOS";
        desc = "V0_P7VLPOS is the end position (Last Position) of video layer region 7 within the video content, in pixels. It is a non-immediate register. V0_P7VLPOS (offset 0x0AF4, total reset 0x0000_0000; PROVEN: Hi3535 data sheet, PDF page 1035, section 5.10).";
        field {
            name = "reserved";
            desc = "Reserved.";
            sw = rw; hw = r;
            reset = 0x0;
        } reserved_31_24[31:24];
        field {
            name = "video_ylpos";
            desc = "Start coordinate of the video content column. Referenced to the frame height, in lines.";
            sw = rw; hw = r;
            reset = 0x0;
        } video_ylpos[23:12];
        field {
            name = "video_xlpos";
            desc = "Video content line start coordinate.";
            sw = rw; hw = r;
            reset = 0x0;
        } video_xlpos[11:0];
    } V0_P7VLPOS @ 0xaf4;
    reg {
        name = "V0_P8RESO";
        desc = "V0_P8RESO is the resolution register of video layer partition 8; not an immediate register. V0_P8RESO (offset 0x0B00, total reset 0x0000_0000; PROVEN: Hi3535 data sheet, PDF page 1036, section 5.10).";
        field {
            name = "reserved";
            desc = "Reserved.";
            sw = rw; hw = r;
            reset = 0x0;
        } reserved_31_12[31:12];
        field {
            name = "w";
            desc = "Width, in pixels. Actual width minus 1. Note: The actual width must be even.";
            sw = rw; hw = r;
            reset = 0x0;
        } w_[11:0];
    } V0_P8RESO @ 0xb00;
    reg {
        name = "V0_P8LADDR";
        desc = "V0_P8LADDR is the luma address register of video layer partition 8. V0_P8LADDR (offset 0x0B04, total reset 0x0000_0000; PROVEN: Hi3535 data sheet, PDF page 1036, section 5.10).";
        field {
            name = "surface_addr";
            desc = "Luminance start address register of video layer partition 8.";
            sw = rw; hw = r;
            reset = 0x0;
        } surface_addr[31:0];
    } V0_P8LADDR @ 0xb04;
    reg {
        name = "V0_P8CADDR";
        desc = "V0_P8CADDR is the chroma address register of video layer partition 8. V0_P8CADDR (offset 0x0B08, total reset 0x0000_0000; PROVEN: Hi3535 data sheet, PDF page 1036, section 5.10).";
        field {
            name = "surface_addr";
            desc = "Chroma start address register of video layer region 8.";
            sw = rw; hw = r;
            reset = 0x0;
        } surface_addr[31:0];
    } V0_P8CADDR @ 0xb08;
    reg {
        name = "V0_P8STRIDE";
        desc = "V0_P8STRIDE is the stride register of video layer region 8. V0_P8STRIDE (offset 0x0B0C, total reset 0x0000_0000; PROVEN: Hi3535 data sheet, PDF page 1037, section 5.10).";
        field {
            name = "surface_cstride";
            desc = "Stride of the video layer partition 8 chrominance buffer (useful for the semi-planar format), 128-bit aligned.";
            sw = rw; hw = r;
            reset = 0x0;
        } surface_cstride[31:16];
        field {
            name = "surface_stride";
            desc = "Stride of the video layer partition 8 buffer (for the semi-planar format, the luma stride), 128-bit aligned.";
            sw = rw; hw = r;
            reset = 0x0;
        } surface_stride[15:0];
    } V0_P8STRIDE @ 0xb0c;
    reg {
        name = "V0_P8VFPOS";
        desc = "V0_P8VFPOS is the start position (First Position) of video layer partition 8 in the video content, in pixels, a non-immediate register. V0_P8VFPOS (offset 0x0B10, total reset 0x0000_0000; PROVEN: Hi3535 data sheet, PDF page 1037, section 5.10).";
        field {
            name = "reserved";
            desc = "Reserved.";
            sw = rw; hw = r;
            reset = 0x0;
        } reserved_31_24[31:24];
        field {
            name = "video_yfpos";
            desc = "Start coordinate of the video content column. Referenced to the frame height, in lines.";
            sw = rw; hw = r;
            reset = 0x0;
        } video_yfpos[23:12];
        field {
            name = "video_xfpos";
            desc = "Video content line start coordinate.";
            sw = rw; hw = r;
            reset = 0x0;
        } video_xfpos[11:0];
    } V0_P8VFPOS @ 0xb10;
    reg {
        name = "V0_P8VLPOS";
        desc = "V0_P8VLPOS is the end position (Last Position) of video layer partition 8 in the video content, in pixels, a non-immediate register. V0_P8VLPOS (offset 0x0B14, total reset 0x0000_0000; PROVEN: Hi3535 data sheet, PDF page 1038, section 5.10).";
        field {
            name = "reserved";
            desc = "Reserved.";
            sw = rw; hw = r;
            reset = 0x0;
        } reserved_31_24[31:24];
        field {
            name = "video_ylpos";
            desc = "Start coordinate of the video content column. Referenced to the frame height, in lines.";
            sw = rw; hw = r;
            reset = 0x0;
        } video_ylpos[23:12];
        field {
            name = "video_xlpos";
            desc = "Video content line start coordinate.";
            sw = rw; hw = r;
            reset = 0x0;
        } video_xlpos[11:0];
    } V0_P8VLPOS @ 0xb14;
    reg {
        name = "V0_P9RESO";
        desc = "V0_P9RESO is the resolution register of video layer partition 9; non-immediate register. V0_P9RESO (offset 0x0B20, total reset 0x0000_0000; PROVEN: Hi3535 data sheet, PDF page 1038, section 5.10).";
        field {
            name = "reserved";
            desc = "Reserved.";
            sw = rw; hw = r;
            reset = 0x0;
        } reserved_31_12[31:12];
        field {
            name = "w";
            desc = "Width, in pixels. Actual width minus 1. Note: The actual width must be even.";
            sw = rw; hw = r;
            reset = 0x0;
        } w_[11:0];
    } V0_P9RESO @ 0xb20;
    reg {
        name = "V0_P9LADDR";
        desc = "V0_P9LADDR is the luminance address register of video layer partition 9. V0_P9LADDR (offset 0x0B24, total reset 0x0000_0000; PROVEN: Hi3535 data sheet, PDF page 1039, section 5.10).";
        field {
            name = "surface_addr";
            desc = "Luma start address register of video layer region 9.";
            sw = rw; hw = r;
            reset = 0x0;
        } surface_addr[31:0];
    } V0_P9LADDR @ 0xb24;
    reg {
        name = "V0_P9CADDR";
        desc = "V0_P9CADDR is the chroma address register of video layer region 9. V0_P9CADDR (offset 0x0B28, total reset 0x0000_0000; PROVEN: Hi3535 data sheet, PDF page 1039, section 5.10).";
        field {
            name = "surface_addr";
            desc = "Chroma start address register of video layer partition 9.";
            sw = rw; hw = r;
            reset = 0x0;
        } surface_addr[31:0];
    } V0_P9CADDR @ 0xb28;
    reg {
        name = "V0_P9STRIDE";
        desc = "V0_P9STRIDE is the stride register of video layer region 9. V0_P9STRIDE (offset 0x0B2C, total reset 0x0000_0000; PROVEN: Hi3535 data sheet, PDF page 1039, section 5.10).";
        field {
            name = "surface_cstride";
            desc = "Stride of the video layer partition 9 chroma buffer (used for the semi-planar format), 128-bit aligned.";
            sw = rw; hw = r;
            reset = 0x0;
        } surface_cstride[31:16];
        field {
            name = "surface_stride";
            desc = "Stride of the buffer of video layer region 9 (for the semi-planar format, the luma stride), 128-bit aligned.";
            sw = rw; hw = r;
            reset = 0x0;
        } surface_stride[15:0];
    } V0_P9STRIDE @ 0xb2c;
    reg {
        name = "V0_P9VFPOS";
        desc = "V0_P9VFPOS is the start position (First Position) of video layer region 9 in the video content, in pixels, not an immediate register. V0_P9VFPOS (offset 0x0B30, total reset 0x0000_0000; PROVEN: Hi3535 data sheet, PDF page 1040, section 5.10).";
        field {
            name = "reserved";
            desc = "Reserved.";
            sw = rw; hw = r;
            reset = 0x0;
        } reserved_31_24[31:24];
        field {
            name = "video_yfpos";
            desc = "Start coordinate of the video content column. Referenced to the frame height, in lines.";
            sw = rw; hw = r;
            reset = 0x0;
        } video_yfpos[23:12];
        field {
            name = "video_xfpos";
            desc = "Video content line start coordinate.";
            sw = rw; hw = r;
            reset = 0x0;
        } video_xfpos[11:0];
    } V0_P9VFPOS @ 0xb30;
    reg {
        name = "V0_P9VLPOS";
        desc = "V0_P9VLPOS is the end position (Last Position) of video layer partition 9 in the video content, in pixels; not an immediate register. V0_P9VLPOS (offset 0x0B34, total reset 0x0000_0000; PROVEN: Hi3535 data sheet, PDF page 1040, section 5.10).";
        field {
            name = "reserved";
            desc = "Reserved.";
            sw = rw; hw = r;
            reset = 0x0;
        } reserved_31_24[31:24];
        field {
            name = "video_ylpos";
            desc = "Start coordinate of the video content column. Referenced to the frame height, in lines.";
            sw = rw; hw = r;
            reset = 0x0;
        } video_ylpos[23:12];
        field {
            name = "video_xlpos";
            desc = "Video content line start coordinate.";
            sw = rw; hw = r;
            reset = 0x0;
        } video_xlpos[11:0];
    } V0_P9VLPOS @ 0xb34;
    reg {
        name = "V0_P10RESO";
        desc = "V0_P10RESO is the resolution register of video layer partition 10; not an immediate register. V0_P10RESO (offset 0x0B40, total reset 0x0000_0000; PROVEN: Hi3535 data sheet, PDF page 1041, section 5.10).";
        field {
            name = "reserved";
            desc = "Reserved.";
            sw = rw; hw = r;
            reset = 0x0;
        } reserved_31_12[31:12];
        field {
            name = "w";
            desc = "Width, in pixels. Actual width minus 1. Note: The actual width must be even.";
            sw = rw; hw = r;
            reset = 0x0;
        } w_[11:0];
    } V0_P10RESO @ 0xb40;
    reg {
        name = "V0_P10LADDR";
        desc = "V0_P10LADDR is the luma address register of video layer region 10. V0_P10LADDR (offset 0x0B44, total reset 0x0000_0000; PROVEN: Hi3535 data sheet, PDF page 1041, section 5.10).";
        field {
            name = "surface_addr";
            desc = "Luminance start address register of video layer partition 10.";
            sw = rw; hw = r;
            reset = 0x0;
        } surface_addr[31:0];
    } V0_P10LADDR @ 0xb44;
    reg {
        name = "V0_P10CADDR";
        desc = "V0_P10CADDR is the chroma address register of video layer region 10. V0_P10CADDR (offset 0x0B48, total reset 0x0000_0000; PROVEN: Hi3535 data sheet, PDF page 1041, section 5.10).";
        field {
            name = "surface_addr";
            desc = "Chroma start address register of video layer region 10.";
            sw = rw; hw = r;
            reset = 0x0;
        } surface_addr[31:0];
    } V0_P10CADDR @ 0xb48;
    reg {
        name = "V0_P10STRIDE";
        desc = "V0_P10STRIDE is the stride register of video layer region 10. V0_P10STRIDE (offset 0x0B4C, total reset 0x0000_0000; PROVEN: Hi3535 data sheet, PDF page 1042, section 5.10).";
        field {
            name = "surface_cstride";
            desc = "Stride of the chroma buffer of video layer region 10 (useful for the semi-planar format), 128-bit aligned.";
            sw = rw; hw = r;
            reset = 0x0;
        } surface_cstride[31:16];
        field {
            name = "surface_stride";
            desc = "Stride of the video layer partition 10 buffer (for the semi-planar format, the luma stride), 128-bit aligned.";
            sw = rw; hw = r;
            reset = 0x0;
        } surface_stride[15:0];
    } V0_P10STRIDE @ 0xb4c;
    reg {
        name = "V0_P10VFPOS";
        desc = "V0_P10VFPOS is the start position (First Position) of video layer region 10 in the video content, in pixels, not an immediate register. V0_P10VFPOS (offset 0x0B50, total reset 0x0000_0000; PROVEN: Hi3535 data sheet, PDF page 1042, section 5.10).";
        field {
            name = "reserved";
            desc = "Reserved.";
            sw = rw; hw = r;
            reset = 0x0;
        } reserved_31_24[31:24];
        field {
            name = "video_yfpos";
            desc = "Start coordinate of the video content column. Referenced to the frame height, in lines.";
            sw = rw; hw = r;
            reset = 0x0;
        } video_yfpos[23:12];
        field {
            name = "video_xfpos";
            desc = "Video content line start coordinate.";
            sw = rw; hw = r;
            reset = 0x0;
        } video_xfpos[11:0];
    } V0_P10VFPOS @ 0xb50;
    reg {
        name = "V0_P10VLPOS";
        desc = "V0_P10VLPOS is the end position (Last Position) of video layer partition 10 in the video content, in pixels; non-immediate register. V0_P10VLPOS (offset 0x0B54, total reset 0x0000_0000; PROVEN: Hi3535 data sheet, PDF page 1043, section 5.10).";
        field {
            name = "reserved";
            desc = "Reserved.";
            sw = rw; hw = r;
            reset = 0x0;
        } reserved_31_24[31:24];
        field {
            name = "video_ylpos";
            desc = "Start coordinate of the video content column. Referenced to the frame height, in lines.";
            sw = rw; hw = r;
            reset = 0x0;
        } video_ylpos[23:12];
        field {
            name = "video_xlpos";
            desc = "Video content line start coordinate.";
            sw = rw; hw = r;
            reset = 0x0;
        } video_xlpos[11:0];
    } V0_P10VLPOS @ 0xb54;
    reg {
        name = "V0_P11RESO";
        desc = "V0_P11RESO is the resolution register of video layer partition 11; not an immediate register. V0_P11RESO (offset 0x0B60, total reset 0x0000_0000; PROVEN: Hi3535 data sheet, PDF page 1043, section 5.10).";
        field {
            name = "reserved";
            desc = "Reserved.";
            sw = rw; hw = r;
            reset = 0x0;
        } reserved_31_12[31:12];
        field {
            name = "w";
            desc = "Width, in pixels. Actual width minus 1. Note: The actual width must be even.";
            sw = rw; hw = r;
            reset = 0x0;
        } w_[11:0];
    } V0_P11RESO @ 0xb60;
    reg {
        name = "V0_P11LADDR";
        desc = "V0_P11LADDR is the luma address register of video layer partition 11. V0_P11LADDR (offset 0x0B64, total reset 0x0000_0000; PROVEN: Hi3535 data sheet, PDF page 1044, section 5.10).";
        field {
            name = "surface_addr";
            desc = "Luma start address register of video layer region 11.";
            sw = rw; hw = r;
            reset = 0x0;
        } surface_addr[31:0];
    } V0_P11LADDR @ 0xb64;
    reg {
        name = "V0_P11CADDR";
        desc = "V0_P11CADDR is the chroma address register of video layer partition 11. V0_P11CADDR (offset 0x0B68, total reset 0x0000_0000; PROVEN: Hi3535 data sheet, PDF page 1044, section 5.10).";
        field {
            name = "surface_addr";
            desc = "Chroma start address register of video layer partition 11.";
            sw = rw; hw = r;
            reset = 0x0;
        } surface_addr[31:0];
    } V0_P11CADDR @ 0xb68;
    reg {
        name = "V0_P11STRIDE";
        desc = "V0_P11STRIDE is the stride register of video layer region 11. V0_P11STRIDE (offset 0x0B6C, total reset 0x0000_0000; PROVEN: Hi3535 data sheet, PDF page 1044, section 5.10).";
        field {
            name = "surface_cstride";
            desc = "Stride of the video layer partition 11 chroma buffer (used for the semi-planar format), 128-bit aligned.";
            sw = rw; hw = r;
            reset = 0x0;
        } surface_cstride[31:16];
        field {
            name = "surface_stride";
            desc = "Stride of the video layer partition 11 buffer (for the semi-planar format, the luminance stride), 128-bit aligned.";
            sw = rw; hw = r;
            reset = 0x0;
        } surface_stride[15:0];
    } V0_P11STRIDE @ 0xb6c;
    reg {
        name = "V0_P11VFPOS";
        desc = "V0_P11VFPOS is the start position (First Position) of video layer partition 11 in the video content, in pixels, a non-immediate register. V0_P11VFPOS (offset 0x0B70, total reset 0x0000_0000; PROVEN: Hi3535 data sheet, PDF page 1045, section 5.10).";
        field {
            name = "reserved";
            desc = "Reserved.";
            sw = rw; hw = r;
            reset = 0x0;
        } reserved_31_24[31:24];
        field {
            name = "video_yfpos";
            desc = "Start coordinate of the video content column. Referenced to the frame height, in lines.";
            sw = rw; hw = r;
            reset = 0x0;
        } video_yfpos[23:12];
        field {
            name = "video_xfpos";
            desc = "Video content line start coordinate.";
            sw = rw; hw = r;
            reset = 0x0;
        } video_xfpos[11:0];
    } V0_P11VFPOS @ 0xb70;
    reg {
        name = "V0_P11VLPOS";
        desc = "V0_P11VLPOS is the end position (Last Position) of video layer partition 11 in the video content, in pixels, a non-immediate register. V0_P11VLPOS (offset 0x0B74, total reset 0x0000_0000; PROVEN: Hi3535 data sheet, PDF page 1045, section 5.10).";
        field {
            name = "reserved";
            desc = "Reserved.";
            sw = rw; hw = r;
            reset = 0x0;
        } reserved_31_24[31:24];
        field {
            name = "video_ylpos";
            desc = "Start coordinate of the video content column. Referenced to the frame height, in lines.";
            sw = rw; hw = r;
            reset = 0x0;
        } video_ylpos[23:12];
        field {
            name = "video_xlpos";
            desc = "Video content line start coordinate.";
            sw = rw; hw = r;
            reset = 0x0;
        } video_xlpos[11:0];
    } V0_P11VLPOS @ 0xb74;
    reg {
        name = "V0_P12RESO";
        desc = "V0_P12RESO is the resolution register of video layer region 12. It is a non-immediate register. V0_P12RESO (offset 0x0B80, total reset 0x0000_0000; PROVEN: Hi3535 data sheet, PDF page 1046, section 5.10).";
        field {
            name = "reserved";
            desc = "Reserved.";
            sw = rw; hw = r;
            reset = 0x0;
        } reserved_31_12[31:12];
        field {
            name = "w";
            desc = "Width, in pixels. Actual width minus 1. Note: The actual width must be even.";
            sw = rw; hw = r;
            reset = 0x0;
        } w_[11:0];
    } V0_P12RESO @ 0xb80;
    reg {
        name = "V0_P12LADDR";
        desc = "V0_P12LADDR is the luminance address register of video layer partition 12. V0_P12LADDR (offset 0x0B84, total reset 0x0000_0000; PROVEN: Hi3535 data sheet, PDF page 1046, section 5.10).";
        field {
            name = "surface_addr";
            desc = "Luma start address register of video layer partition 12.";
            sw = rw; hw = r;
            reset = 0x0;
        } surface_addr[31:0];
    } V0_P12LADDR @ 0xb84;
    reg {
        name = "V0_P12CADDR";
        desc = "V0_P12CADDR is the chroma address register of video layer region 12. V0_P12CADDR (offset 0x0B88, total reset 0x0000_0000; PROVEN: Hi3535 data sheet, PDF page 1046, section 5.10).";
        field {
            name = "surface_addr";
            desc = "Chroma start address register of video layer partition 12.";
            sw = rw; hw = r;
            reset = 0x0;
        } surface_addr[31:0];
    } V0_P12CADDR @ 0xb88;
    reg {
        name = "V0_P12STRIDE";
        desc = "V0_P12STRIDE is the stride register of video layer partition 12. V0_P12STRIDE (offset 0x0B8C, total reset 0x0000_0000; PROVEN: Hi3535 data sheet, PDF page 1047, section 5.10).";
        field {
            name = "surface_cstride";
            desc = "Stride of the chroma buffer of video layer region 12 (useful for the semi-planar format), 128-bit aligned.";
            sw = rw; hw = r;
            reset = 0x0;
        } surface_cstride[31:16];
        field {
            name = "surface_stride";
            desc = "Stride of the video layer region 12 buffer (for semi-planar formats, the luma stride), 128-bit aligned.";
            sw = rw; hw = r;
            reset = 0x0;
        } surface_stride[15:0];
    } V0_P12STRIDE @ 0xb8c;
    reg {
        name = "V0_P12VFPOS";
        desc = "V0_P12VFPOS is the start position (First Position) of video layer region 12 in the video content, in pixels, not an immediate register. V0_P12VFPOS (offset 0x0B90, total reset 0x0000_0000; PROVEN: Hi3535 data sheet, PDF page 1047, section 5.10).";
        field {
            name = "reserved";
            desc = "Reserved.";
            sw = rw; hw = r;
            reset = 0x0;
        } reserved_31_24[31:24];
        field {
            name = "video_yfpos";
            desc = "Start coordinate of the video content column. Referenced to the frame height, in lines.";
            sw = rw; hw = r;
            reset = 0x0;
        } video_yfpos[23:12];
        field {
            name = "video_xfpos";
            desc = "Video content line start coordinate.";
            sw = rw; hw = r;
            reset = 0x0;
        } video_xfpos[11:0];
    } V0_P12VFPOS @ 0xb90;
    reg {
        name = "V0_P12VLPOS";
        desc = "V0_P12VLPOS is the end position (Last Position) of video layer partition 12 in the video content, in pixels; not an immediate register. V0_P12VLPOS (offset 0x0B94, total reset 0x0000_0000; PROVEN: Hi3535 data sheet, PDF page 1048, section 5.10).";
        field {
            name = "reserved";
            desc = "Reserved.";
            sw = rw; hw = r;
            reset = 0x0;
        } reserved_31_24[31:24];
        field {
            name = "video_ylpos";
            desc = "Start coordinate of the video content column. Referenced to the frame height, in lines.";
            sw = rw; hw = r;
            reset = 0x0;
        } video_ylpos[23:12];
        field {
            name = "video_xlpos";
            desc = "Video content line start coordinate.";
            sw = rw; hw = r;
            reset = 0x0;
        } video_xlpos[11:0];
    } V0_P12VLPOS @ 0xb94;
    reg {
        name = "V0_P13RESO";
        desc = "V0_P13RESO is the resolution register of video layer partition 13, a non-immediate register. V0_P13RESO (offset 0x0BA0, total reset 0x0000_0000; PROVEN: Hi3535 data sheet, PDF page 1048, section 5.10).";
        field {
            name = "reserved";
            desc = "Reserved.";
            sw = rw; hw = r;
            reset = 0x0;
        } reserved_31_12[31:12];
        field {
            name = "w";
            desc = "Width, in pixels. Actual width minus 1. Note: The actual width must be even.";
            sw = rw; hw = r;
            reset = 0x0;
        } w_[11:0];
    } V0_P13RESO @ 0xba0;
    reg {
        name = "V0_P13LADDR";
        desc = "V0_P13LADDR is the luma address register of video layer partition 13. V0_P13LADDR (offset 0x0BA4, total reset 0x0000_0000; PROVEN: Hi3535 data sheet, PDF page 1049, section 5.10).";
        field {
            name = "surface_addr";
            desc = "Luma start address register of video layer partition 13.";
            sw = rw; hw = r;
            reset = 0x0;
        } surface_addr[31:0];
    } V0_P13LADDR @ 0xba4;
    reg {
        name = "V0_P13CADDR";
        desc = "V0_P13CADDR is the chroma address register of video layer region 13. V0_P13CADDR (offset 0x0BA8, total reset 0x0000_0000; PROVEN: Hi3535 data sheet, PDF page 1049, section 5.10).";
        field {
            name = "surface_addr";
            desc = "Chrominance start address register of video layer partition 13.";
            sw = rw; hw = r;
            reset = 0x0;
        } surface_addr[31:0];
    } V0_P13CADDR @ 0xba8;
    reg {
        name = "V0_P13STRIDE";
        desc = "V0_P13STRIDE is the stride register of video layer partition 13. V0_P13STRIDE (offset 0x0BAC, total reset 0x0000_0000; PROVEN: Hi3535 data sheet, PDF page 1049, section 5.10).";
        field {
            name = "surface_cstride";
            desc = "Stride of the video layer partition 13 chroma buffer (used for the semi-planar format), 128-bit aligned.";
            sw = rw; hw = r;
            reset = 0x0;
        } surface_cstride[31:16];
        field {
            name = "surface_stride";
            desc = "Stride of the buffer of video layer partition 13 (for the semi-planar format, the luma stride), 128-bit aligned.";
            sw = rw; hw = r;
            reset = 0x0;
        } surface_stride[15:0];
    } V0_P13STRIDE @ 0xbac;
    reg {
        name = "V0_P13VFPOS";
        desc = "V0_P13VFPOS is the start position (First Position) of video layer region 13 within the video content, in pixels. It is a non-immediate register. V0_P13VFPOS (offset 0x0BB0, total reset 0x0000_0000; PROVEN: Hi3535 data sheet, PDF page 1050, section 5.10).";
        field {
            name = "reserved";
            desc = "Reserved.";
            sw = rw; hw = r;
            reset = 0x0;
        } reserved_31_24[31:24];
        field {
            name = "video_yfpos";
            desc = "Start coordinate of the video content column. Referenced to the frame height, in lines.";
            sw = rw; hw = r;
            reset = 0x0;
        } video_yfpos[23:12];
        field {
            name = "video_xfpos";
            desc = "Video content line start coordinate.";
            sw = rw; hw = r;
            reset = 0x0;
        } video_xfpos[11:0];
    } V0_P13VFPOS @ 0xbb0;
    reg {
        name = "V0_P13VLPOS";
        desc = "V0_P13VLPOS is the end position (Last Position) of video layer partition 13 in the video content, in pixels; non-immediate register. V0_P13VLPOS (offset 0x0BB4, total reset 0x0000_0000; PROVEN: Hi3535 data sheet, PDF page 1050, section 5.10).";
        field {
            name = "reserved";
            desc = "Reserved.";
            sw = rw; hw = r;
            reset = 0x0;
        } reserved_31_24[31:24];
        field {
            name = "video_ylpos";
            desc = "Start coordinate of the video content column. Referenced to the frame height, in lines.";
            sw = rw; hw = r;
            reset = 0x0;
        } video_ylpos[23:12];
        field {
            name = "video_xlpos";
            desc = "Video content line start coordinate.";
            sw = rw; hw = r;
            reset = 0x0;
        } video_xlpos[11:0];
    } V0_P13VLPOS @ 0xbb4;
    reg {
        name = "V0_P14RESO";
        desc = "V0_P14RESO is the resolution register of video layer region 14, not an immediate register. V0_P14RESO (offset 0x0BC0, total reset 0x0000_0000; PROVEN: Hi3535 data sheet, PDF page 1051, section 5.10).";
        field {
            name = "reserved";
            desc = "Reserved";
            sw = rw; hw = r;
            reset = 0x0;
        } reserved_31_12[31:12];
        field {
            name = "w";
            desc = "Width, in pixels. Actual width minus 1. Note: The actual width must be even.";
            sw = rw; hw = r;
            reset = 0x0;
        } w_[11:0];
    } V0_P14RESO @ 0xbc0;
    reg {
        name = "V0_P14LADDR";
        desc = "V0_P14LADDR is the luma address register of video layer partition 14. V0_P14LADDR (offset 0x0BC4, total reset 0x0000_0000; PROVEN: Hi3535 data sheet, PDF page 1051, section 5.10).";
        field {
            name = "surface_addr";
            desc = "Luminance start address register of video layer partition 14.";
            sw = rw; hw = r;
            reset = 0x0;
        } surface_addr[31:0];
    } V0_P14LADDR @ 0xbc4;
    reg {
        name = "V0_P14CADDR";
        desc = "V0_P14CADDR is the chroma address register of video layer partition 14. V0_P14CADDR (offset 0x0BC8, total reset 0x0000_0000; PROVEN: Hi3535 data sheet, PDF page 1051, section 5.10).";
        field {
            name = "surface_addr";
            desc = "Chroma start address register of video layer region 14.";
            sw = rw; hw = r;
            reset = 0x0;
        } surface_addr[31:0];
    } V0_P14CADDR @ 0xbc8;
    reg {
        name = "V0_P14STRIDE";
        desc = "V0_P14STRIDE is the stride register of video layer partition 14. V0_P14STRIDE (offset 0x0BCC, total reset 0x0000_0000; PROVEN: Hi3535 data sheet, PDF page 1052, section 5.10).";
        field {
            name = "surface_cstride";
            desc = "Stride of the chroma buffer of video layer region 14 (useful for the semi-planar format), 128-bit aligned.";
            sw = rw; hw = r;
            reset = 0x0;
        } surface_cstride[31:16];
        field {
            name = "surface_stride";
            desc = "Stride of the video layer partition 14 buffer (for the semi-planar format, the luma stride), 128-bit aligned.";
            sw = rw; hw = r;
            reset = 0x0;
        } surface_stride[15:0];
    } V0_P14STRIDE @ 0xbcc;
    reg {
        name = "V0_P14VFPOS";
        desc = "V0_P14VFPOS is the start position (First Position) of video layer partition 14 in the video content, in pixels, a non-immediate register. V0_P14VFPOS (offset 0x0BD0, total reset 0x0000_0000; PROVEN: Hi3535 data sheet, PDF page 1052, section 5.10).";
        field {
            name = "reserved";
            desc = "Reserved.";
            sw = rw; hw = r;
            reset = 0x0;
        } reserved_31_24[31:24];
        field {
            name = "video_yfpos";
            desc = "Start coordinate of the video content column. Referenced to the frame height, in lines.";
            sw = rw; hw = r;
            reset = 0x0;
        } video_yfpos[23:12];
        field {
            name = "video_xfpos";
            desc = "Video content line start coordinate.";
            sw = rw; hw = r;
            reset = 0x0;
        } video_xfpos[11:0];
    } V0_P14VFPOS @ 0xbd0;
    reg {
        name = "V0_P14VLPOS";
        desc = "V0_P14VLPOS is the end position (Last Position) of video layer partition 14 in the video content, in pixels, a non-immediate register. V0_P14VLPOS (offset 0x0BD4, total reset 0x0000_0000; PROVEN: Hi3535 data sheet, PDF page 1053, section 5.10).";
        field {
            name = "reserved";
            desc = "Reserved.";
            sw = rw; hw = r;
            reset = 0x0;
        } reserved_31_24[31:24];
        field {
            name = "video_ylpos";
            desc = "Start coordinate of the video content column. Referenced to the frame height, in lines.";
            sw = rw; hw = r;
            reset = 0x0;
        } video_ylpos[23:12];
        field {
            name = "video_xlpos";
            desc = "Video content line start coordinate.";
            sw = rw; hw = r;
            reset = 0x0;
        } video_xlpos[11:0];
    } V0_P14VLPOS @ 0xbd4;
    reg {
        name = "V0_P15RESO";
        desc = "V0_P15RESO is the resolution register of video layer region 15. It is a non-immediate register. V0_P15RESO (offset 0x0BE0, total reset 0x0000_0000; PROVEN: Hi3535 data sheet, PDF page 1053, section 5.10).";
        field {
            name = "reserved";
            desc = "Reserved.";
            sw = rw; hw = r;
            reset = 0x0;
        } reserved_31_12[31:12];
        field {
            name = "w";
            desc = "Width, in pixels. Actual width minus 1. Note: The actual width must be even.";
            sw = rw; hw = r;
            reset = 0x0;
        } w_[11:0];
    } V0_P15RESO @ 0xbe0;
    reg {
        name = "V0_P15LADDR";
        desc = "V0_P15LADDR is the luminance address register of video layer partition 15. V0_P15LADDR (offset 0x0BE4, total reset 0x0000_0000; PROVEN: Hi3535 data sheet, PDF page 1054, section 5.10).";
        field {
            name = "surface_addr";
            desc = "Luma start address register of video layer region 15.";
            sw = rw; hw = r;
            reset = 0x0;
        } surface_addr[31:0];
    } V0_P15LADDR @ 0xbe4;
    reg {
        name = "V0_P15CADDR";
        desc = "V0_P15CADDR is the chroma address register of video layer region 15. V0_P15CADDR (offset 0x0BE8, total reset 0x0000_0000; PROVEN: Hi3535 data sheet, PDF page 1054, section 5.10).";
        field {
            name = "surface_addr";
            desc = "Chroma start address register of video layer partition 15.";
            sw = rw; hw = r;
            reset = 0x0;
        } surface_addr[31:0];
    } V0_P15CADDR @ 0xbe8;
    reg {
        name = "V0_P15STRIDE";
        desc = "V0_P15STRIDE is the stride register of video layer partition 15. V0_P15STRIDE (offset 0x0BEC, total reset 0x0000_0000; PROVEN: Hi3535 data sheet, PDF page 1054, section 5.10).";
        field {
            name = "surface_cstride";
            desc = "Stride of the video layer partition 15 chroma buffer (used for the semi-planar format), 128-bit aligned.";
            sw = rw; hw = r;
            reset = 0x0;
        } surface_cstride[31:16];
        field {
            name = "surface_stride";
            desc = "Stride of the video layer partition 15 buffer (for the semi-planar format, the luminance stride), 128-bit aligned.";
            sw = rw; hw = r;
            reset = 0x0;
        } surface_stride[15:0];
    } V0_P15STRIDE @ 0xbec;
    reg {
        name = "V0_P15VFPOS";
        desc = "V0_P15VFPOS is the start position (First Position) of video layer region 15 in the video content, in pixels, not an immediate register. V0_P15VFPOS (offset 0x0BF0, total reset 0x0000_0000; PROVEN: Hi3535 data sheet, PDF page 1055, section 5.10).";
        field {
            name = "reserved";
            desc = "Reserved.";
            sw = rw; hw = r;
            reset = 0x0;
        } reserved_31_24[31:24];
        field {
            name = "video_yfpos";
            desc = "Start coordinate of the video content column. Referenced to the frame height, in lines.";
            sw = rw; hw = r;
            reset = 0x0;
        } video_yfpos[23:12];
        field {
            name = "video_xfpos";
            desc = "Video content line start coordinate.";
            sw = rw; hw = r;
            reset = 0x0;
        } video_xfpos[11:0];
    } V0_P15VFPOS @ 0xbf0;
    reg {
        name = "V0_P15VLPOS";
        desc = "V0_P15VLPOS is the end position (Last Position) of video layer partition 15 in the video content, in pixels; not an immediate register. V0_P15VLPOS (offset 0x0BF4, total reset 0x0000_0000; PROVEN: Hi3535 data sheet, PDF page 1055, section 5.10).";
        field {
            name = "reserved";
            desc = "Reserved.";
            sw = rw; hw = r;
            reset = 0x0;
        } reserved_31_24[31:24];
        field {
            name = "video_ylpos";
            desc = "Start coordinate of the video content column. Referenced to the frame height, in lines.";
            sw = rw; hw = r;
            reset = 0x0;
        } video_ylpos[23:12];
        field {
            name = "video_xlpos";
            desc = "Video content line start coordinate.";
            sw = rw; hw = r;
            reset = 0x0;
        } video_xlpos[11:0];
    } V0_P15VLPOS @ 0xbf4;
    reg {
        name = "V0_MULTI_MODE";
        desc = "V0_MULTI_MODE is the multi-region mode enable signal register. It must be enabled when multi-region is used. V0_MULTI_MODE (offset 0x0E30, total reset 0x0000_0001; PROVEN: Hi3535 data sheet, PDF page 1056, section 5.10).";
        field {
            name = "reserved";
            desc = "Reserved";
            sw = rw; hw = r;
            reset = 0x0;
        } reserved_31_1[31:1];
        field {
            name = "mrg_mode";
            desc = "Multi-region mode enable switch, valid only for V0/V3.
- 0: Single-region mode, with LBOX;
- 1: Multi-region mode, without LBOX.";
            sw = rw; hw = r;
            reset = 0x1;
        } mrg_mode[0:0];
    } V0_MULTI_MODE @ 0xe30;
    reg {
        name = "V0_16REGIONENL";
        desc = "V0_16REGIONENL is the video layer 16-region enable register. It is a non-immediate register. V0_16REGIONENL (offset 0x0F00, total reset 0x0000_0000; PROVEN: Hi3535 data sheet, PDF page 1056, section 5.10).";
        field {
            name = "reserved";
            desc = "Reserved.";
            sw = rw; hw = r;
            reset = 0x0;
        } reserved_31_16[31:16];
        field {
            name = "p15_en";
            desc = "Enable signal of partition 15.
- 0: Disable.
- 1: Enable.";
            sw = rw; hw = r;
            reset = 0x0;
        } p15_en[15:15];
        field {
            name = "p14_en";
            desc = "Enable signal of partition 14.
- 0: Disable;
- 1: Enable.";
            sw = rw; hw = r;
            reset = 0x0;
        } p14_en[14:14];
        field {
            name = "p13_en";
            desc = "Enable signal of partition 13.
- 0: Disable.
- 1: Enable.";
            sw = rw; hw = r;
            reset = 0x0;
        } p13_en[13:13];
        field {
            name = "p12_en";
            desc = "Enable signal of region 12.
- 0: Disable;
- 1: Enable.";
            sw = rw; hw = r;
            reset = 0x0;
        } p12_en[12:12];
        field {
            name = "p11_en";
            desc = "Enable signal of partition 11.
- 0: Disable.
- 1: Enable.";
            sw = rw; hw = r;
            reset = 0x0;
        } p11_en[11:11];
        field {
            name = "p10_en";
            desc = "Enable signal of partition 10.
- 0: Disable;
- 1: Enable.";
            sw = rw; hw = r;
            reset = 0x0;
        } p10_en[10:10];
        field {
            name = "p9_en";
            desc = "Enable signal of partition 9.
- 0: Disable;
- 1: Enable.";
            sw = rw; hw = r;
            reset = 0x0;
        } p9_en[9:9];
        field {
            name = "p8_en";
            desc = "Enable signal of region 8.
- 0: Disable;
- 1: Enable.";
            sw = rw; hw = r;
            reset = 0x0;
        } p8_en[8:8];
        field {
            name = "p7_en";
            desc = "Enable signal of partition 7.
- 0: Disable.
- 1: Enable.";
            sw = rw; hw = r;
            reset = 0x0;
        } p7_en[7:7];
        field {
            name = "p6_en";
            desc = "Enable signal of partition 6.
- 0: Disable;
- 1: Enable.";
            sw = rw; hw = r;
            reset = 0x0;
        } p6_en[6:6];
        field {
            name = "p5_en";
            desc = "Enable signal of region 5.
- 0: Disable;
- 1: Enable.";
            sw = rw; hw = r;
            reset = 0x0;
        } p5_en[5:5];
        field {
            name = "p4_en";
            desc = "Enable signal of partition 4.
- 0: Disable;
- 1: Enable.";
            sw = rw; hw = r;
            reset = 0x0;
        } p4_en[4:4];
        field {
            name = "p3_en";
            desc = "Enable signal of partition 3.
- 0: Disable.
- 1: Enable.";
            sw = rw; hw = r;
            reset = 0x0;
        } p3_en[3:3];
        field {
            name = "p2_en";
            desc = "Enable signal of region 2.
- 0: Disable;
- 1: Enable.";
            sw = rw; hw = r;
            reset = 0x0;
        } p2_en[2:2];
        field {
            name = "p1_en";
            desc = "Enable signal of partition 1.
- 0: Disable.
- 1: Enable.";
            sw = rw; hw = r;
            reset = 0x0;
        } p1_en[1:1];
        field {
            name = "p0_en";
            desc = "Enable signal of partition 0.
- 0: Disable;
- 1: Enable.";
            sw = rw; hw = r;
            reset = 0x0;
        } p0_en[0:0];
    } V0_16REGIONENL @ 0xf00;
    reg {
        name = "V0_16MUTE";
        desc = "V0_16MUTE is the 16-partition MUTE enable register of the video layer, a non-immediate register. V0_16MUTE (offset 0x0F08, total reset 0x0000_0000; PROVEN: Hi3535 data sheet, PDF page 1058, section 5.10).";
        field {
            name = "reserved";
            desc = "Reserved.";
            sw = r; hw = w;
            reset = 0x0;
        } reserved_31_16[31:16];
        field {
            name = "p15_mute_en";
            desc = "Mute enable signal of region 15.
- 0: Disable;
- 1: Enable.";
            sw = rw; hw = r;
            reset = 0x0;
        } p15_mute_en[15:15];
        field {
            name = "p14_mute_en";
            desc = "Mute enable signal of region 14.
- 0: Disable;
- 1: Enable.";
            sw = rw; hw = r;
            reset = 0x0;
        } p14_mute_en[14:14];
        field {
            name = "p13_mute_en";
            desc = "Mute enable signal of region 13.
- 0: Disable;
- 1: Enable.";
            sw = rw; hw = r;
            reset = 0x0;
        } p13_mute_en[13:13];
        field {
            name = "p12_mute_en";
            desc = "Mute enable signal of partition 12.
- 0: Disable;
- 1: Enable.";
            sw = rw; hw = r;
            reset = 0x0;
        } p12_mute_en[12:12];
        field {
            name = "p11_mute_en";
            desc = "Mute enable signal of region 11.
- 0: Disable;
- 1: Enable.";
            sw = rw; hw = r;
            reset = 0x0;
        } p11_mute_en[11:11];
        field {
            name = "p10_mute_en";
            desc = "Mute enable signal of region 10.
- 0: Disable;
- 1: Enable.";
            sw = rw; hw = r;
            reset = 0x0;
        } p10_mute_en[10:10];
        field {
            name = "p9_mute_en";
            desc = "Mute enable signal of partition 9.
- 0: Disable.
- 1: Enable.";
            sw = rw; hw = r;
            reset = 0x0;
        } p9_mute_en[9:9];
        field {
            name = "p8_mute_en";
            desc = "Mute enable signal of partition 8.
- 0: Disable;
- 1: Enable.";
            sw = rw; hw = r;
            reset = 0x0;
        } p8_mute_en[8:8];
        field {
            name = "p7_mute_en";
            desc = "Mute enable signal of region 7.
- 0: Disable;
- 1: Enable.";
            sw = rw; hw = r;
            reset = 0x0;
        } p7_mute_en[7:7];
        field {
            name = "p6_mute_en";
            desc = "Mute enable signal of partition 6.
- 0: Disable.
- 1: Enable.";
            sw = rw; hw = r;
            reset = 0x0;
        } p6_mute_en[6:6];
        field {
            name = "p5_mute_en";
            desc = "Mute enable signal of partition 5.
- 0: Disable;
- 1: Enable.";
            sw = rw; hw = r;
            reset = 0x0;
        } p5_mute_en[5:5];
        field {
            name = "p4_mute_en";
            desc = "Mute enable signal of region 4.
- 0: Disable;
- 1: Enable.";
            sw = rw; hw = r;
            reset = 0x0;
        } p4_mute_en[4:4];
        field {
            name = "p3_mute_en";
            desc = "Mute enable signal of region 3.
- 0: Disable;
- 1: Enable.";
            sw = rw; hw = r;
            reset = 0x0;
        } p3_mute_en[3:3];
        field {
            name = "p2_mute_en";
            desc = "Mute enable signal of partition 2.
- 0: Disable;
- 1: Enable.";
            sw = rw; hw = r;
            reset = 0x0;
        } p2_mute_en[2:2];
        field {
            name = "p1_mute_en";
            desc = "Mute enable signal of region 1.
- 0: Disable;
- 1: Enable.";
            sw = rw; hw = r;
            reset = 0x0;
        } p1_mute_en[1:1];
        field {
            name = "p0_mute_en";
            desc = "Mute enable signal of region 0.
- 0: Disable;
- 1: Enable.";
            sw = rw; hw = r;
            reset = 0x0;
        } p0_mute_en[0:0];
    } V0_16MUTE @ 0xf08;
    reg {
        name = "G0_CTRL";
        desc = "G0_CTRL is the register that configures layer-related information. It is not an immediate register. G0_CTRL (offset 0x6000, total reset 0x0000_0000; PROVEN: Hi3535 data sheet, PDF page 1060, section 5.10).";
        field {
            name = "surface_en";
            desc = "surface enable. Not an immediate register.
- 0: Disable.
- 1: Enable.";
            sw = rw; hw = r;
            reset = 0x0;
        } surface_en[31:31];
        field {
            name = "reserved";
            desc = "Reserved.";
            sw = r; hw = w;
            reset = 0x0;
        } reserved_30_29[30:29];
        field {
            name = "mute_en";
            desc = "G0 mute enable, non-immediate register.
- 0: Disable;
- 1: Enable.";
            sw = rw; hw = r;
            reset = 0x0;
        } mute_en[28:28];
        field {
            name = "upd_mode";
            desc = "Update mode.
- 0: Frame update;
- 1: Field update.";
            sw = rw; hw = r;
            reset = 0x0;
        } upd_mode[27:27];
        field {
            name = "read_mode";
            desc = "Data read mode.
- 0: Selected automatically according to the interface read method (progressive read for progressive display, interlaced read for interlaced display).
- 1: Force progressive read.";
            sw = rw; hw = r;
            reset = 0x0;
        } read_mode[26:26];
        field {
            name = "dcmp_en";
            desc = "Decompression enable.
- 0: Decompression disabled.
- 1: Decompression enabled.";
            sw = rw; hw = r;
            reset = 0x0;
        } dcmp_en[25:25];
        field {
            name = "reserved";
            desc = "Reserved.";
            sw = r; hw = w;
            reset = 0x0;
        } reserved_24_10[24:10];
        field {
            name = "bitext";
            desc = "Layer input bitmap bit extension mode.
- 00: Extend the low bits with 0;
- 01: Reserved;
- 10: Extend the low bits with the most significant bit;
- 11: Extend the low bits with several of the most significant bits.";
            sw = rw; hw = r;
            reset = 0x0;
        } bitext[9:8];
        field {
            name = "ifmt";
            desc = "Input data format.
- 0x48: ARGB4444;
- 0x49: ARGB1555;
- 0x68: ARGB8888; Others: Reserved.";
            sw = rw; hw = r;
            reset = 0x0;
        } ifmt[7:0];
    } G0_CTRL @ 0x6000;
    reg {
        name = "G0_UPD";
        desc = "G0_UPD is the graphics layer update enable register. G0_UPD (offset 0x6004, total reset 0x0000_0000; PROVEN: Hi3535 data sheet, PDF page 1061, section 5.10).";
        field {
            name = "reserved";
            desc = "Reserved.";
            sw = r; hw = w;
            reset = 0x0;
        } reserved_31_1[31:1];
        field {
            name = "regup";
            desc = "Register update of the surface. After software finishes configuring the registers of this layer, write 1 to update; hardware clears it automatically when the update completes.";
            sw = rw; hw = r;
            reset = 0x0;
        } regup[0:0];
    } G0_UPD @ 0x6004;
    reg {
        name = "G0_ADDR";
        desc = "G0_ADDR is the graphics layer address register. When there is a horizontal pixel offset, see the G0SFPOS description for the address calculation. G0_ADDR (offset 0x6010, total reset 0x0000_0000; PROVEN: Hi3535 data sheet, PDF page 1062, section 5.10).";
        field {
            name = "surface_addr";
            desc = "surface frame buffer address.";
            sw = rw; hw = r;
            reset = 0x0;
        } surface_addr[31:0];
    } G0_ADDR @ 0x6010;
    reg {
        name = "G0_STRIDE";
        desc = "G0_STRIDE is the graphics layer stride register. G0_STRIDE (offset 0x601C, total reset 0x0000_0000; PROVEN: Hi3535 data sheet, PDF page 1062, section 5.10).";
        field {
            name = "reserved";
            desc = "Reserved;";
            sw = r; hw = w;
            reset = 0x0;
        } reserved_31_16[31:16];
        field {
            name = "surface_stride";
            desc = "Stride of the frame buffer.";
            sw = rw; hw = r;
            reset = 0x0;
        } surface_stride[15:0];
    } G0_STRIDE @ 0x601c;
    reg {
        name = "G0_IRESO";
        desc = "G0_IRESO is the input resolution register. It is a non-immediate register. G0_IRESO (offset 0x6020, total reset 0x0000_0000; PROVEN: Hi3535 data sheet, PDF page 1062, section 5.10).";
        field {
            name = "reserved";
            desc = "Reserved.";
            sw = r; hw = w;
            reset = 0x0;
        } reserved_31_24[31:24];
        field {
            name = "ih";
            desc = "Height, in lines. Actual height minus 1. Note: For interlaced output, the actual height of the layer must be even. Progressive output has no such restriction.";
            sw = rw; hw = r;
            reset = 0x0;
        } ih[23:12];
        field {
            name = "iw";
            desc = "Width in pixels. Actual width minus 1. Note: the actual width of the layer must be an even number.";
            sw = rw; hw = r;
            reset = 0x0;
        } iw[11:0];
    } G0_IRESO @ 0x6020;
    reg {
        name = "G0_SFPOS";
        desc = "G0_SFPOS is the start position, in the source bitmap, of the data that the surface needs to read; not an immediate register. When the read position is not 128-bit-word aligned, this register indicates the number of pixels needed to complete the whole 128-bit-word. Note: The start position offset must not exceed one 128-bit-word; the part beyond a 128-bit-word is represented by the address. The calculation is as follows. Let the start address of the original graphics layer be addr_ori, the graphics layer address configured to the logic be addr_offset, the offset of the graphics layer be offsetp pixels, and the data format of the graphics layer be bpp (for example, bpp=32 for ARGB8888). Then G0ADDR=addr_offset = addr_ori + int(offsetp*bpp/128); G0SFPOS=offset%128; where int denotes the integer (truncation) operation and % denotes the modulo operation. G0_SFPOS (offset 0x6024, total reset 0x0000_0000; PROVEN: Hi3535 data sheet, PDF page 1063, section 5.10).";
        field {
            name = "reserved";
            desc = "Reserved.";
            sw = r; hw = w;
            reset = 0x0;
        } reserved_31_7[31:7];
        field {
            name = "src_xfpos";
            desc = "Source start X coordinate; 0 is the first pixel of a line.";
            sw = rw; hw = r;
            reset = 0x0;
        } src_xfpos[6:0];
    } G0_SFPOS @ 0x6024;
    reg {
        name = "G0_CBMPARA";
        desc = "G0_CBMPARA holds overlay-related parameters. It is a non-immediate register. G0_CBMPARA (offset 0x6030, total reset 0x0000_0000; PROVEN: Hi3535 data sheet, PDF page 1064, section 5.10).";
        field {
            name = "reserved";
            desc = "Reserved.";
            sw = r; hw = w;
            reset = 0x0;
        } reserved_31_16[31:16];
        field {
            name = "key_mode";
            desc = "Color key mode;
- 0: Pixels satisfying Keymin<=Pixel<=Keymax are treated as the key color;
- 1: Pixels satisfying Pixel<=Keymin or Pixel>=Keymax are treated as the key color.";
            sw = rw; hw = r;
            reset = 0x0;
        } key_mode[15:15];
        field {
            name = "key_en";
            desc = "color key enable.
- 0: Disable.
- 1: Enable.";
            sw = rw; hw = r;
            reset = 0x0;
        } key_en[14:14];
        field {
            name = "premult_en";
            desc = "The input bitmap is premultiplied.
- 0: Not premultiplied.
- 1: Premultiplied.";
            sw = rw; hw = r;
            reset = 0x0;
        } premult_en[13:13];
        field {
            name = "palpha_en";
            desc = "Pixel alpha enable.
- 0: Disable;
- 1: Enable.";
            sw = rw; hw = r;
            reset = 0x0;
        } palpha_en[12:12];
        field {
            name = "reserved";
            desc = "Reserved.";
            sw = r; hw = w;
            reset = 0x0;
        } reserved_11_8[11:8];
        field {
            name = "galpha";
            desc = "Overlay global alpha value. Range 0 to 255; 255 is fully opaque and 0 is fully transparent.";
            sw = rw; hw = r;
            reset = 0x0;
        } galpha[7:0];
    } G0_CBMPARA @ 0x6030;
    reg {
        name = "G0_CKEYMAX";
        desc = "G0_CKEYMAX is the maximum color key value; non-immediate register. G0_CKEYMAX (offset 0x6034, total reset 0x0000_0000; PROVEN: Hi3535 data sheet, PDF page 1065, section 5.10).";
        field {
            name = "va0";
            desc = "alpha0 value. When the data format is alphaRGB1555 and the alpha value is 0, this value is used as the replacement.";
            sw = rw; hw = r;
            reset = 0x0;
        } va0[31:24];
        field {
            name = "keyr_max";
            desc = "colry key R component maximum value.";
            sw = rw; hw = r;
            reset = 0x0;
        } keyr_max[23:16];
        field {
            name = "keyg_max";
            desc = "Maximum value of the color key G component.";
            sw = rw; hw = r;
            reset = 0x0;
        } keyg_max[15:8];
        field {
            name = "keyb_max";
            desc = "Maximum value of the color key B component.";
            sw = rw; hw = r;
            reset = 0x0;
        } keyb_max[7:0];
    } G0_CKEYMAX @ 0x6034;
    reg {
        name = "G0_CKEYMIN";
        desc = "G0_CKEYMIN is the color key minimum value, a non-immediate register. G0_CKEYMIN (offset 0x6038, total reset 0x0000_0000; PROVEN: Hi3535 data sheet, PDF page 1065, section 5.10).";
        field {
            name = "va1";
            desc = "alpha1 value. When the data format is alphaRGB1555 and the alpha value is 1, this value is used as the replacement.";
            sw = rw; hw = r;
            reset = 0x0;
        } va1[31:24];
        field {
            name = "keyr_min";
            desc = "Minimum value of the color key R component.";
            sw = rw; hw = r;
            reset = 0x0;
        } keyr_min[23:16];
        field {
            name = "keyg_min";
            desc = "Minimum value of the color key G component.";
            sw = rw; hw = r;
            reset = 0x0;
        } keyg_min[15:8];
        field {
            name = "keyb_min";
            desc = "color key B component minimum value.";
            sw = rw; hw = r;
            reset = 0x0;
        } keyb_min[7:0];
    } G0_CKEYMIN @ 0x6038;
    reg {
        name = "G0_CMASK";
        desc = "G0_CMASK is the color key mask value. It is a non-immediate register. A bit set to 1 means the corresponding pixel bit is kept unchanged during the Key comparison; a bit set to 0 means the corresponding pixel bit is forced to 0, whether it is 0 or 1, during the Key comparison. G0_CMASK (offset 0x603C, total reset 0xFFFF_FFFF; PROVEN: Hi3535 data sheet, PDF page 1066, section 5.10).";
        field {
            name = "reserved";
            desc = "Reserved.";
            sw = r; hw = w;
            reset = 0xff;
        } reserved_31_24[31:24];
        field {
            name = "kmsk_r";
            desc = "R component of the colry key mask.";
            sw = rw; hw = r;
            reset = 0xff;
        } kmsk_r[23:16];
        field {
            name = "kmsk_g";
            desc = "G component of the color key mask.";
            sw = rw; hw = r;
            reset = 0xff;
        } kmsk_g[15:8];
        field {
            name = "kmsk_b";
            desc = "B component of the colry key mask.";
            sw = rw; hw = r;
            reset = 0xff;
        } kmsk_b[7:0];
    } G0_CMASK @ 0x603c;
    reg {
        name = "G0_PARAADDR";
        desc = "G0_PARAADDR is the graphics layer LUT coefficient address register. G0_PARAADDR (offset 0x6040, total reset 0x0000_0000; PROVEN: Hi3535 data sheet, PDF page 1066, section 5.10).";
        field {
            name = "surface_addr";
            desc = "surface lut coefficient address.";
            sw = rw; hw = r;
            reset = 0x0;
        } surface_addr[31:0];
    } G0_PARAADDR @ 0x6040;
    reg {
        name = "G0_PARAUP";
        desc = "G0_PARAUP is the graphics layer LUT coefficient update register. G0_PARAUP (offset 0x6044, total reset 0x0000_0000; PROVEN: Hi3535 data sheet, PDF page 1067, section 5.10).";
        field {
            name = "reserved";
            desc = "Reserved.";
            sw = r; hw = w;
            reset = 0x0;
        } reserved_31_1[31:1];
        field {
            name = "gdc_paraup";
            desc = "LUT coefficient update.
- 0: No update;
- 1: Update.";
            sw = rw; hw = r;
            reset = 0x0;
        } gdc_paraup[0:0];
    } G0_PARAUP @ 0x6044;
    reg {
        name = "G0_DCMP_ADDR";
        desc = "G0_DCMP_ADDR is the graphics layer compression address register. When there is a horizontal pixel offset, see the G0SFPOS description for the address calculation. G0_DCMP_ADDR (offset 0x6050, total reset 0x0000_0000; PROVEN: Hi3535 data sheet, PDF page 1067, section 5.10).";
        field {
            name = "surface_addr";
            desc = "surface frame buffer address.";
            sw = rw; hw = r;
            reset = 0x0;
        } surface_addr[31:0];
    } G0_DCMP_ADDR @ 0x6050;
    reg {
        name = "G0_DCMP_OFFSET";
        desc = "G0_DCMP_OFFSET is the graphics layer compression header information offset register. G0_DCMP_OFFSET (offset 0x6058, total reset 0x0000_0000; PROVEN: Hi3535 data sheet, PDF page 1068, section 5.10).";
        field {
            name = "offset";
            desc = "Header information offset, in bytes, 128-bit aligned.";
            sw = rw; hw = r;
            reset = 0x0;
        } offset[31:0];
    } G0_DCMP_OFFSET @ 0x6058;
    reg {
        name = "G0_DFPOS";
        desc = "G0_DFPOS is the start position (First Position) of the Surface in the display window, in pixels; non-immediate register. G0_DFPOS (offset 0x6080, total reset 0x0000_0000; PROVEN: Hi3535 data sheet, PDF page 1068, section 5.10).";
        field {
            name = "reserved";
            desc = "Reserved.";
            sw = r; hw = w;
            reset = 0x0;
        } reserved_31_24[31:24];
        field {
            name = "disp_yfpos";
            desc = "Column start coordinate.";
            sw = rw; hw = r;
            reset = 0x0;
        } disp_yfpos[23:12];
        field {
            name = "disp_xfpos";
            desc = "Line start coordinate.";
            sw = rw; hw = r;
            reset = 0x0;
        } disp_xfpos[11:0];
    } G0_DFPOS @ 0x6080;
    reg {
        name = "G0_DLPOS";
        desc = "G0_DLPOS is the end position (Last Position) of the surface in the display window, in pixels. It is not an immediate register. G0_DLPOS (offset 0x6084, total reset 0x0000_0000; PROVEN: Hi3535 data sheet, PDF page 1068, section 5.10).";
        field {
            name = "reserved";
            desc = "Reserved.";
            sw = r; hw = w;
            reset = 0x0;
        } reserved_31_24[31:24];
        field {
            name = "disp_ylpos";
            desc = "Column end coordinate.";
            sw = rw; hw = r;
            reset = 0x0;
        } disp_ylpos[23:12];
        field {
            name = "disp_xlpos";
            desc = "Line end coordinate.";
            sw = rw; hw = r;
            reset = 0x0;
        } disp_xlpos[11:0];
    } G0_DLPOS @ 0x6084;
    reg {
        name = "G0_VFPOS";
        desc = "G0_VFPOS is the start position (First Position) of the actual Surface content in the display window, in pixels, a non-immediate register. G0_VFPOS (offset 0x6088, total reset 0x0000_0000; PROVEN: Hi3535 data sheet, PDF page 1069, section 5.10).";
        field {
            name = "reserved";
            desc = "Reserved.";
            sw = r; hw = w;
            reset = 0x0;
        } reserved_31_24[31:24];
        field {
            name = "video_yfpos";
            desc = "Start coordinate of the video content column. Referenced to the frame height, in lines.";
            sw = rw; hw = r;
            reset = 0x0;
        } video_yfpos[23:12];
        field {
            name = "video_xfpos";
            desc = "Video content line start coordinate.";
            sw = rw; hw = r;
            reset = 0x0;
        } video_xfpos[11:0];
    } G0_VFPOS @ 0x6088;
    reg {
        name = "G0_VLPOS";
        desc = "G0_VLPOS is the end position (Last Position) of the real Surface content in the display window, in pixels, a non-immediate register. G0_VLPOS (offset 0x608C, total reset 0x0000_0000; PROVEN: Hi3535 data sheet, PDF page 1069, section 5.10).";
        field {
            name = "reserved";
            desc = "Reserved.";
            sw = r; hw = w;
            reset = 0x0;
        } reserved_31_24[31:24];
        field {
            name = "video_ylpos";
            desc = "Video content column end coordinate. Referenced to the frame height, in lines.";
            sw = rw; hw = r;
            reset = 0x0;
        } video_ylpos[23:12];
        field {
            name = "video_xlpos";
            desc = "Video content line end coordinate.";
            sw = rw; hw = r;
            reset = 0x0;
        } video_xlpos[11:0];
    } G0_VLPOS @ 0x608c;
    reg {
        name = "G0_BK";
        desc = "G0_BK is the background color register of the graphics layer. G0_BK (offset 0x6090, total reset 0x0000_0000; PROVEN: Hi3535 data sheet, PDF page 1070, section 5.10).";
        field {
            name = "reserved";
            desc = "Reserved.";
            sw = r; hw = w;
            reset = 0x0;
        } reserved_31_30[31:30];
        field {
            name = "vbk_y";
            desc = "Y component.";
            sw = rw; hw = r;
            reset = 0x0;
        } vbk_y[29:20];
        field {
            name = "vbk_cb";
            desc = "Cb component.";
            sw = rw; hw = r;
            reset = 0x0;
        } vbk_cb[19:10];
        field {
            name = "vbk_cr";
            desc = "Cr component.";
            sw = rw; hw = r;
            reset = 0x0;
        } vbk_cr[9:0];
    } G0_BK @ 0x6090;
    reg {
        name = "G0_ALPHA";
        desc = "G0_ALPHA is the ALPHA register of the background fill color of the graphics layer. G0_ALPHA (offset 0x6094, total reset 0x0000_0000; PROVEN: Hi3535 data sheet, PDF page 1070, section 5.10).";
        field {
            name = "reserved";
            desc = "Reserved.";
            sw = r; hw = w;
            reset = 0x0;
        } reserved_31_8[31:8];
        field {
            name = "vbk_alpha";
            desc = "Background fill color of the graphics layer, levels 0 to 128.";
            sw = rw; hw = r;
            reset = 0x0;
        } vbk_alpha[7:0];
    } G0_ALPHA @ 0x6094;
    reg {
        name = "G0_CSC_IDC";
        desc = "G0_CSC_IDC is the color space conversion input DC component register, an immediate register. G0_CSC_IDC (offset 0x60C0, total reset 0x0000_0000; PROVEN: Hi3535 data sheet, PDF page 1071, section 5.10).";
        field {
            name = "reserved";
            desc = "Reserved.";
            sw = r; hw = w;
            reset = 0x0;
        } reserved_31_26[31:26];
        field {
            name = "csc_mode";
            desc = "Valid only when the G2 layer CSC coefficients are fixed.
- 000: reserved;
- 001: YUV2YUV;
- 010: YUV601_RGB;
- 011: YUV709_RGB;
- 100: YUV2YUV_709_601;
- 101: YUV2YUV_601_709;
- 110: RGB2YUV_601;
- 111: RGB2YUV_709.";
            sw = rw; hw = r;
            reset = 0x0;
        } csc_mode[25:23];
        field {
            name = "csc_en";
            desc = "CSC enable control signal.
- 0: CSC disabled;
- 1: CSC enabled.";
            sw = rw; hw = r;
            reset = 0x0;
        } csc_en[22:22];
        field {
            name = "cscidc1";
            desc = "Input U/G component DC parameter, MSB is the sign bit. Two's complement representation.";
            sw = rw; hw = r;
            reset = 0x0;
        } cscidc1[21:11];
        field {
            name = "cscidc0";
            desc = "Input V/B component DC parameter, the MSB is the sign bit. Two's complement representation.";
            sw = rw; hw = r;
            reset = 0x0;
        } cscidc0[10:0];
    } G0_CSC_IDC @ 0x60c0;
    reg {
        name = "G0_CSC_ODC";
        desc = "G0_CSC_ODC is the color space conversion output DC component register; immediate register. G0_CSC_ODC (offset 0x60C4, total reset 0x0000_0000; PROVEN: Hi3535 data sheet, PDF page 1072, section 5.10).";
        field {
            name = "reserved";
            desc = "Reserved.";
            sw = r; hw = w;
            reset = 0x0;
        } reserved_31_23[31:23];
        field {
            name = "csc_sign_mode";
            desc = "CSC output mode control signal.
- 0: CSC outputs 10-bit unsigned numbers.
- 1: CSC outputs 12-bit signed numbers.";
            sw = rw; hw = r;
            reset = 0x0;
        } csc_sign_mode[22:22];
        field {
            name = "cscodc1";
            desc = "Output U/G component DC parameter, MSB is the sign bit. Two's complement representation.";
            sw = rw; hw = r;
            reset = 0x0;
        } cscodc1[21:11];
        field {
            name = "cscodc0";
            desc = "Output Y/R component DC parameter, MSB is the sign bit. Two's complement representation.";
            sw = rw; hw = r;
            reset = 0x0;
        } cscodc0[10:0];
    } G0_CSC_ODC @ 0x60c4;
    reg {
        name = "G0_CSC_IODC";
        desc = "G0_CSC_IODC is the color space conversion input/output DC component register, an immediate register. G0_CSC_IODC (offset 0x60C8, total reset 0x0000_0000; PROVEN: Hi3535 data sheet, PDF page 1072, section 5.10).";
        field {
            name = "reserved";
            desc = "Reserved.";
            sw = r; hw = w;
            reset = 0x0;
        } reserved_31_22[31:22];
        field {
            name = "cscodc2";
            desc = "Output V/B component DC parameter, MSB is the sign bit. Two's complement representation.";
            sw = rw; hw = r;
            reset = 0x0;
        } cscodc2[21:11];
        field {
            name = "cscidc2";
            desc = "Input Y/R component DC parameter; the MSB is the sign bit. Two's complement representation.";
            sw = rw; hw = r;
            reset = 0x0;
        } cscidc2[10:0];
    } G0_CSC_IODC @ 0x60c8;
    reg {
        name = "G0_CSC_P0";
        desc = "G0_CSC_P0 is color space conversion parameter 0, an immediate register. G0_CSC_P0 (offset 0x60CC, total reset 0x0000_0000; PROVEN: Hi3535 data sheet, PDF page 1073, section 5.10).";
        field {
            name = "reserved";
            desc = "Reserved.";
            sw = r; hw = w;
            reset = 0x0;
        } reserved_31_31[31:31];
        field {
            name = "cscp01";
            desc = "5.10 data format: 1-bit sign, 4-bit integer part, 10-bit fraction. Two's complement representation.";
            sw = rw; hw = r;
            reset = 0x0;
        } cscp01[30:16];
        field {
            name = "reserved";
            desc = "Reserved.";
            sw = r; hw = w;
            reset = 0x0;
        } reserved_15_15[15:15];
        field {
            name = "cscp00";
            desc = "5.10 data format: 1-bit sign, 4-bit integer part, 10-bit fraction. Two's complement representation.";
            sw = rw; hw = r;
            reset = 0x0;
        } cscp00[14:0];
    } G0_CSC_P0 @ 0x60cc;
    reg {
        name = "G0_CSC_P1";
        desc = "G0_CSC_P1 is color space conversion parameter 1, an immediate register. G0_CSC_P1 (offset 0x60D0, total reset 0x0000_0000; PROVEN: Hi3535 data sheet, PDF page 1073, section 5.10).";
        field {
            name = "reserved";
            desc = "Reserved.";
            sw = r; hw = w;
            reset = 0x0;
        } reserved_31_31[31:31];
        field {
            name = "cscp10";
            desc = "5.10 data format: 1-bit sign, 4-bit integer part, 10-bit fraction. Two's complement representation.";
            sw = rw; hw = r;
            reset = 0x0;
        } cscp10[30:16];
        field {
            name = "reserved";
            desc = "Reserved.";
            sw = r; hw = w;
            reset = 0x0;
        } reserved_15_15[15:15];
        field {
            name = "cscp02";
            desc = "5.10 data format: 1-bit sign, 4-bit integer part, 10-bit fraction. Two's complement representation.";
            sw = rw; hw = r;
            reset = 0x0;
        } cscp02[14:0];
    } G0_CSC_P1 @ 0x60d0;
    reg {
        name = "G0_CSC_P2";
        desc = "G0_CSC_P2 is color space conversion parameter 2, an immediate register. G0_CSC_P2 (offset 0x60D4, total reset 0x0000_0000; PROVEN: Hi3535 data sheet, PDF page 1074, section 5.10).";
        field {
            name = "reserved";
            desc = "Reserved.";
            sw = r; hw = w;
            reset = 0x0;
        } reserved_31_31[31:31];
        field {
            name = "cscp12";
            desc = "5.10 data format: 1-bit sign, 4-bit integer part, 10-bit fraction. Two's complement representation.";
            sw = rw; hw = r;
            reset = 0x0;
        } cscp12[30:16];
        field {
            name = "reserved";
            desc = "Reserved.";
            sw = r; hw = w;
            reset = 0x0;
        } reserved_15_15[15:15];
        field {
            name = "cscp11";
            desc = "5.10 data format: 1-bit sign, 4-bit integer part, 10-bit fraction. Two's complement representation.";
            sw = rw; hw = r;
            reset = 0x0;
        } cscp11[14:0];
    } G0_CSC_P2 @ 0x60d4;
    reg {
        name = "G0_CSC_P3";
        desc = "G0_CSC_P3 is color space conversion parameter 3, an immediate register. G0_CSC_P3 (offset 0x60D8, total reset 0x0000_0000; PROVEN: Hi3535 data sheet, PDF page 1074, section 5.10).";
        field {
            name = "reserved";
            desc = "Reserved.";
            sw = r; hw = w;
            reset = 0x0;
        } reserved_31_31[31:31];
        field {
            name = "cscp21";
            desc = "5.10 data format: 1-bit sign, 4-bit integer part, 10-bit fraction. Two's complement representation.";
            sw = rw; hw = r;
            reset = 0x0;
        } cscp21[30:16];
        field {
            name = "reserved";
            desc = "Reserved.";
            sw = r; hw = w;
            reset = 0x0;
        } reserved_15_15[15:15];
        field {
            name = "cscp20";
            desc = "5.10 data format: 1-bit sign, 4-bit integer part, 10-bit fraction. Two's complement representation.";
            sw = rw; hw = r;
            reset = 0x0;
        } cscp20[14:0];
    } G0_CSC_P3 @ 0x60d8;
    reg {
        name = "G0_CSC_P4";
        desc = "G0_CSC_P4 is color space conversion parameter 4; immediate register. G0_CSC_P4 (offset 0x60DC, total reset 0x0000_0000; PROVEN: Hi3535 data sheet, PDF page 1075, section 5.10).";
        field {
            name = "reserved";
            desc = "Reserved.";
            sw = r; hw = w;
            reset = 0x0;
        } reserved_31_15[31:15];
        field {
            name = "cscp22";
            desc = "5.10 data format: 1-bit sign, 4-bit integer part, 10-bit fraction. Two's complement representation.";
            sw = rw; hw = r;
            reset = 0x0;
        } cscp22[14:0];
    } G0_CSC_P4 @ 0x60dc;
    reg {
        name = "WBC_G0_CTRL";
        desc = "WBC_G0_CTRL is the control register of WBC0; non-immediate register. WBC_G0_CTRL (offset 0xA000, total reset 0x0000_0000; PROVEN: Hi3535 data sheet, PDF page 1075, section 5.10).";
        field {
            name = "wbc_en";
            desc = "WBC enable.";
            sw = rw; hw = r;
            reset = 0x0;
        } wbc_en[31:31];
        field {
            name = "reserved";
            desc = "Reserved.";
            sw = r; hw = w;
            reset = 0x0;
        } reserved_30_28[30:28];
        field {
            name = "format_out";
            desc = "Output data format of the WBC.
- 0x2: ARGB8888; Others: Reserved.";
            sw = rw; hw = r;
            reset = 0x0;
        } format_out[27:26];
        field {
            name = "reserved";
            desc = "Reserved.";
            sw = r; hw = w;
            reset = 0x0;
        } reserved_25_11[25:11];
        field {
            name = "auto_stop_en";
            desc = "Automatically turn off the WBC when write-back is too fast and causes low bandwidth";
            sw = rw; hw = r;
            reset = 0x0;
        } auto_stop_en[10:10];
        field {
            name = "req_interval";
            desc = "Minimum interval between WBC bus requests: the interval between the end of the n-th request and the (n+1)-th request is req_interval clock cycles.";
            sw = rw; hw = r;
            reset = 0x0;
        } req_interval[9:0];
    } WBC_G0_CTRL @ 0xa000;
    reg {
        name = "WBC_G0_UPD";
        desc = "WBC_G0_UPD is the WBC0 channel update enable register. WBC_G0_UPD (offset 0xA004, total reset 0x0000_0000; PROVEN: Hi3535 data sheet, PDF page 1076, section 5.10).";
        field {
            name = "reserved";
            desc = "Reserved.";
            sw = r; hw = w;
            reset = 0x0;
        } reserved_31_5[31:5];
        field {
            name = "atuo_stop_int";
            desc = "Write-back auto-stop interrupt status.
- 0: No auto-stop.
- 1: Write-back auto-stop.";
            sw = r; hw = w;
            reset = 0x0;
        } atuo_stop_int[4:4];
        field {
            name = "reserved";
            desc = "Reserved.";
            sw = r; hw = w;
            reset = 0x0;
        } reserved_3_1[3:1];
        field {
            name = "regup";
            desc = "CAPTURE register update. After software finishes configuring the registers of this layer, write 1 to update them; hardware clears the bit automatically when the update completes. (data sheet access type WC)";
            sw = rw; hw = r; onwrite = woclr;
            reset = 0x0;
        } regup[0:0];
    } WBC_G0_UPD @ 0xa004;
    reg {
        name = "WBC_G0_CMP";
        desc = "WBC_G0_CMP is the compression module control register. WBC_G0_CMP (offset 0xA008, total reset 0x0000_0000; PROVEN: Hi3535 data sheet, PDF page 1077, section 5.10).";
        field {
            name = "cmp_en";
            desc = "Compression enable
- 0: Compression disabled, bypass;
- 1: Compression enabled.";
            sw = r; hw = w;
            reset = 0x0;
        } cmp_en[31:31];
        field {
            name = "reserved";
            desc = "Reserved.";
            sw = r; hw = w;
            reset = 0x0;
        } reserved_30_0[30:0];
    } WBC_G0_CMP @ 0xa008;
    reg {
        name = "WBC_G0_AR_ADDR";
        desc = "WBC_G0_AR_ADDR is the CAPTURE luma write address register. WBC_G0_AR_ADDR (offset 0xA010, total reset 0x0000_0000; PROVEN: Hi3535 data sheet, PDF page 1077, section 5.10).";
        field {
            name = "wbcaddr";
            desc = "Compression start address of the written-back AR component.";
            sw = r; hw = na;
            reset = 0x0;
        } wbcaddr[31:0];
    } WBC_G0_AR_ADDR @ 0xa010;
    reg {
        name = "WBC_G0_GB_ADDR";
        desc = "WBC_G0_GB_ADDR is the 'CAPTURE chroma write address register. WBC_G0_GB_ADDR (offset 0xA014, total reset 0x0000_0000; PROVEN: Hi3535 data sheet, PDF page 1077, section 5.10).";
        field {
            name = "wbccaddr";
            desc = "Compression start address of the written-back GB component.";
            sw = r; hw = na;
            reset = 0x0;
        } wbccaddr[31:0];
    } WBC_G0_GB_ADDR @ 0xa014;
    reg {
        name = "WBC_G0_STRIDE";
        desc = "WBC_G0_STRIDE is the CAPTURE stride register. WBC_G0_STRIDE (offset 0xA018, total reset 0x0000_0000; PROVEN: Hi3535 data sheet, PDF page 1078, section 5.10).";
        field {
            name = "reserved";
            desc = "Reserved.";
            sw = r; hw = w;
            reset = 0x0;
        } reserved_31_16[31:16];
        field {
            name = "wbcstride";
            desc = "Stride of the frame buffer. 16-byte aligned.";
            sw = rw; hw = r;
            reset = 0x0;
        } wbcstride[15:0];
    } WBC_G0_STRIDE @ 0xa018;
    reg {
        name = "WBC_G0_OFFSET";
        desc = "WBC_G0_OFFSET is the CAPTURE offset register. WBC_G0_OFFSET (offset 0xA01C, total reset 0x0000_0000; PROVEN: Hi3535 data sheet, PDF page 1078, section 5.10).";
        field {
            name = "wbcoffset";
            desc = "Luma stride of the frame buffer. 16-byte aligned.";
            sw = rw; hw = r;
            reset = 0x0;
        } wbcoffset[31:0];
    } WBC_G0_OFFSET @ 0xa01c;
    reg {
        name = "WBC_G0_ORESO";
        desc = "WBC_G0_ORESO is the output resolution register, not an immediate register. WBC_G0_ORESO (offset 0xA020, total reset 0x0000_0000; PROVEN: Hi3535 data sheet, PDF page 1079, section 5.10).";
        field {
            name = "reserved";
            desc = "Reserved.";
            sw = r; hw = w;
            reset = 0x0;
        } reserved_31_24[31:24];
        field {
            name = "oh";
            desc = "Height, in lines. Actual height minus 1. Note: For interlaced output, the actual height of the layer must be even. Progressive output has no such restriction.";
            sw = rw; hw = r;
            reset = 0x0;
        } oh[23:12];
        field {
            name = "ow";
            desc = "Width in pixels. Actual width minus 1. Note: the actual width of the layer must be an even number.";
            sw = rw; hw = r;
            reset = 0x0;
        } ow[11:0];
    } WBC_G0_ORESO @ 0xa020;
    reg {
        name = "WBC_G0_FCROP";
        desc = "WBC_G0_FCROP is the input image CROP start coordinate register, not an immediate register. WBC_G0_FCROP (offset 0xA024, total reset 0x0000_0000; PROVEN: Hi3535 data sheet, PDF page 1080, section 5.10).";
        field {
            name = "reserved";
            desc = "Reserved.";
            sw = r; hw = w;
            reset = 0x0;
        } reserved_31_24[31:24];
        field {
            name = "hfcrop";
            desc = "Height, in lines. Actual height minus 1. Note: For interlaced output, the actual height of the layer must be even. Progressive output has no such restriction.";
            sw = rw; hw = r;
            reset = 0x0;
        } hfcrop[23:12];
        field {
            name = "wfcrop";
            desc = "Width in pixels. Actual width minus 1. Note: the actual width of the layer must be an even number.";
            sw = rw; hw = r;
            reset = 0x0;
        } wfcrop[11:0];
    } WBC_G0_FCROP @ 0xa024;
    reg {
        name = "WBC_G0_LCROP";
        desc = "WBC_G0_LCROP is the input image CROP end coordinate register; non-immediate register. WBC_G0_LCROP (offset 0xA028, total reset 0x0000_0000; PROVEN: Hi3535 data sheet, PDF page 1080, section 5.10).";
        field {
            name = "reserved";
            desc = "Reserved.";
            sw = r; hw = w;
            reset = 0x0;
        } reserved_31_24[31:24];
        field {
            name = "hlcrop";
            desc = "Height, in lines. Actual height minus 1. Note: For interlaced output, the actual height of the layer must be even. Progressive output has no such restriction.";
            sw = rw; hw = r;
            reset = 0x0;
        } hlcrop[23:12];
        field {
            name = "wlcrop";
            desc = "Width in pixels. Actual width minus 1. Note: the actual width of the layer must be an even number.";
            sw = rw; hw = r;
            reset = 0x0;
        } wlcrop[11:0];
    } WBC_G0_LCROP @ 0xa028;
    reg {
        name = "WBC_G0_STPSTACLR";
        desc = "WBC_G0_STPSTACLR is the auto-stop status clear register. Write 1 to clear to 0. WBC_G0_STPSTACLR (offset 0xA03C, total reset 0x0000_0000; PROVEN: Hi3535 data sheet, PDF page 1079, section 5.10).";
        field {
            name = "reserved";
            desc = "Reserved.";
            sw = r; hw = w;
            reset = 0x0;
        } reserved_31_1[31:1];
        field {
            name = "stpsta_clr";
            desc = "Auto-stop status clear register. Write 1 to clear the status.";
            sw = rw; hw = r;
            reset = 0x0;
        } stpsta_clr[0:0];
    } WBC_G0_STPSTACLR @ 0xa03c;
    reg {
        name = "WBC_DHD0_CTRL";
        desc = "WBC_DHD0_CTRL is the WBC0 control register, a non-immediate register. WBC_DHD0_CTRL (offset 0xAC00, total reset 0x0000_1000; PROVEN: Hi3535 data sheet, PDF page 1081, section 5.10).";
        field {
            name = "wbc_en";
            desc = "WBC enable.
- 0: Disable.
- 1: Enable.";
            sw = rw; hw = r;
            reset = 0x0;
        } wbc_en[31:31];
        field {
            name = "reserved";
            desc = "Reserved.";
            sw = rw; hw = r;
            reset = 0x0;
        } reserved_30_30[30:30];
        field {
            name = "mode_out";
            desc = "WBC output mode.
- 0x00: Selected automatically according to the interface read mode (progressive write-back for progressive display, interlaced write-back for interlaced display, with the top and bottom fields adapted automatically);
- 0x01: Progressive output;
- 0x10: Top field output;
- 0x11: Bottom field output.";
            sw = rw; hw = r;
            reset = 0x0;
        } mode_out[29:28];
        field {
            name = "format_out";
            desc = "WBC output data format. semiplanar
- 0100: YUV420;
- 0101: YUV422;
Other values: reserved.";
            sw = rw; hw = r;
            reset = 0x0;
        } format_out[27:24];
        field {
            name = "reserved";
            desc = "Reserved.";
            sw = r; hw = w;
            reset = 0x0;
        } reserved_23_13[23:13];
        field {
            name = "wbc_vtthd_mode";
            desc = "WBC interrupt reporting mode.
- 0: Report an interrupt per frame;
- 1: Report an interrupt per field.";
            sw = rw; hw = r;
            reset = 0x1;
        } wbc_vtthd_mode[12:12];
        field {
            name = "reserved";
            desc = "Reserved.";
            sw = r; hw = w;
            reset = 0x0;
        } reserved_11_11[11:11];
        field {
            name = "auto_stop_en";
            desc = "Automatically turn off the WBC when write-back is too fast and causes low bandwidth.";
            sw = rw; hw = r;
            reset = 0x0;
        } auto_stop_en[10:10];
        field {
            name = "req_interval";
            desc = "Minimum interval between WBC bus requests: the interval between the end of the n-th request and the (n+1)-th request is req_interval clock cycles.";
            sw = rw; hw = r;
            reset = 0x0;
        } req_interval[9:0];
    } WBC_DHD0_CTRL @ 0xac00;
    reg {
        name = "WBC_DHD0_UPD";
        desc = "WBC_DHD0_UPD is the WBC_DHD0 channel update enable register. WBC_DHD0_UPD (offset 0xAC04, total reset 0x0000_0000; PROVEN: Hi3535 data sheet, PDF page 1082, section 5.10).";
        field {
            name = "reserved";
            desc = "Reserved.";
            sw = r; hw = w;
            reset = 0x0;
        } reserved_31_5[31:5];
        field {
            name = "atuo_stop_int";
            desc = "Write-back auto-stop interrupt status.
- 0: No auto-stop.
- 1: Write-back auto-stop.";
            sw = r; hw = w;
            reset = 0x0;
        } atuo_stop_int[4:4];
        field {
            name = "reserved";
            desc = "Reserved.";
            sw = r; hw = w;
            reset = 0x0;
        } reserved_3_1[3:1];
        field {
            name = "regup";
            desc = "CAPTURE register update. After software finishes configuring the registers of this layer, write 1 to update them; hardware clears the bit automatically when the update completes. (data sheet access type WC)";
            sw = rw; hw = r; onwrite = woclr;
            reset = 0x0;
        } regup[0:0];
    } WBC_DHD0_UPD @ 0xac04;
    reg {
        name = "WBC_DHD0_YADDR";
        desc = "WBC_DHD0_YADDR is the CAPTURE luminance write address register. WBC_DHD0_YADDR (offset 0xAC10, total reset 0x0000_0000; PROVEN: Hi3535 data sheet, PDF page 1082, section 5.10).";
        field {
            name = "wbcaddr";
            desc = "When the output format is semiplanar: this register is the start address of the luminance component of the frame buffer. When the output format is Package or ARGB: this register is the start address of a frame of image (the chrominance start address WBC_G0_CADDR is meaningless in this case). This register must be 4-byte aligned; the lower 2 bits are invalid (supports seamless splicing).";
            sw = rw; hw = r;
            reset = 0x0;
        } wbcaddr[31:0];
    } WBC_DHD0_YADDR @ 0xac10;
    reg {
        name = "WBC_DHD0_CADDR";
        desc = "WBC_DHD0_CADDR is the CAPTURE chroma write address register. WBC_DHD0_CADDR (offset 0xAC14, total reset 0x0000_0000; PROVEN: Hi3535 data sheet, PDF page 1083, section 5.10).";
        field {
            name = "wbccaddr";
            desc = "Start address of the frame buffer chroma component. 4-byte aligned, the lower 2 bits are invalid (supports seamless splicing).";
            sw = rw; hw = r;
            reset = 0x0;
        } wbccaddr[31:0];
    } WBC_DHD0_CADDR @ 0xac14;
    reg {
        name = "WBC_DHD0_STRIDE";
        desc = "WBC_DHD0_STRIDE is the CAPTURE stride register. WBC_DHD0_STRIDE (offset 0xAC18, total reset 0x0000_0000; PROVEN: Hi3535 data sheet, PDF page 1083, section 5.10).";
        field {
            name = "wbccstride";
            desc = "Chroma stride of the frame buffer. 16-byte aligned.";
            sw = rw; hw = r;
            reset = 0x0;
        } wbccstride[31:16];
        field {
            name = "wbclstride";
            desc = "Luma stride of the frame buffer. 16-byte aligned.";
            sw = rw; hw = r;
            reset = 0x0;
        } wbclstride[15:0];
    } WBC_DHD0_STRIDE @ 0xac18;
    reg {
        name = "WBC_DHD0_ORESO";
        desc = "WBC_DHD0_ORESO is the output resolution register, a non-immediate register. WBC_DHD0_ORESO (offset 0xAC20, total reset 0x0000_0000; PROVEN: Hi3535 data sheet, PDF page 1084, section 5.10).";
        field {
            name = "reserved";
            desc = "Reserved.";
            sw = r; hw = w;
            reset = 0x0;
        } reserved_31_24[31:24];
        field {
            name = "oh";
            desc = "Height, in lines. Actual height minus 1. Note: For interlaced output, the actual height of the layer must be even. Progressive output has no such restriction.";
            sw = rw; hw = r;
            reset = 0x0;
        } oh[23:12];
        field {
            name = "ow";
            desc = "Width in pixels. Actual width minus 1. Note: the actual width of the layer must be an even number.";
            sw = rw; hw = r;
            reset = 0x0;
        } ow[11:0];
    } WBC_DHD0_ORESO @ 0xac20;
    reg {
        name = "WBC_DHD0_FCROP";
        desc = "WBC_DHD0_FCROP is the input image CROP start coordinate register. It is a non-immediate register. WBC_DHD0_FCROP (offset 0xAC24, total reset 0x0000_0000; PROVEN: Hi3535 data sheet, PDF page 1084, section 5.10).";
        field {
            name = "reserved";
            desc = "Reserved.";
            sw = r; hw = w;
            reset = 0x0;
        } reserved_31_24[31:24];
        field {
            name = "hfcrop";
            desc = "Height, in lines. Actual height minus 1. Note: For interlaced output, the actual height of the layer must be even. Progressive output has no such restriction.";
            sw = rw; hw = r;
            reset = 0x0;
        } hfcrop[23:12];
        field {
            name = "wfcrop";
            desc = "Width in pixels. Actual width minus 1. Note: the actual width of the layer must be an even number.";
            sw = rw; hw = r;
            reset = 0x0;
        } wfcrop[11:0];
    } WBC_DHD0_FCROP @ 0xac24;
    reg {
        name = "WBC_DHD0_LCROP";
        desc = "WBC_DHD0_LCROP is the input image CROP end coordinate register, a non-immediate register. WBC_DHD0_LCROP (offset 0xAC28, total reset 0x0000_0000; PROVEN: Hi3535 data sheet, PDF page 1085, section 5.10).";
        field {
            name = "reserved";
            desc = "Reserved.";
            sw = r; hw = w;
            reset = 0x0;
        } reserved_31_24[31:24];
        field {
            name = "hlcrop";
            desc = "Height, in lines. Actual height minus 1. Note: For interlaced output, the actual height of the layer must be even. Progressive output has no such restriction.";
            sw = rw; hw = r;
            reset = 0x0;
        } hlcrop[23:12];
        field {
            name = "wlcrop";
            desc = "Width in pixels. Actual width minus 1. Note: the actual width of the layer must be an even number.";
            sw = rw; hw = r;
            reset = 0x0;
        } wlcrop[11:0];
    } WBC_DHD0_LCROP @ 0xac28;
    reg {
        name = "WBC_DHD0_STPSTACLR";
        desc = "WBC_DHD0_STPSTACLR is the auto-stop status clear register. Write 1 to clear to 0. WBC_DHD0_STPSTACLR (offset 0xAC3C, total reset 0x0000_0000; PROVEN: Hi3535 data sheet, PDF page 1085, section 5.10).";
        field {
            name = "reserved";
            desc = "Reserved.";
            sw = r; hw = w;
            reset = 0x0;
        } reserved_31_1[31:1];
        field {
            name = "stpsta_clr";
            desc = "Auto-stop status clear register.";
            sw = rw; hw = r;
            reset = 0x0;
        } stpsta_clr[0:0];
    } WBC_DHD0_STPSTACLR @ 0xac3c;
    reg {
        name = "WBC_DHD0_PARAUP";
        desc = "WBC_DHD0_PARAUP is the update enable register for WBC DHD0 coefficient-related registers. The VDP scaling coefficients are configured through the AXI Master; software uses the Slave interface to configure the start address and the flag indicating that parameters need to be updated. WBC_DHD0_PARAUP (offset 0xAC40, total reset 0x0000_0000; PROVEN: Hi3535 data sheet, PDF page 1086, section 5.10).";
        field {
            name = "reserved";
            desc = "Reserved.";
            sw = r; hw = w;
            reset = 0x0;
        } reserved_31_4[31:4];
        field {
            name = "wbc_vccoef_upd";
            desc = "Whether the vertical chrominance filter coefficients need to be updated. Cleared automatically after the hardware update.
- 0: Do not update.
- 1: Update.";
            sw = rw; hw = r;
            reset = 0x0;
        } wbc_vccoef_upd[3:3];
        field {
            name = "wbc_vlcoef_upd";
            desc = "Whether the vertical luminance filter coefficients need to be updated. Cleared automatically after the hardware update.
- 0: Do not update.
- 1: Update.";
            sw = rw; hw = r;
            reset = 0x0;
        } wbc_vlcoef_upd[2:2];
        field {
            name = "wbc_hccoef_upd";
            desc = "Whether the horizontal chroma filter coefficients need to be updated. Cleared automatically by hardware after the update.
- 0: No update;
- 1: Update.";
            sw = rw; hw = r;
            reset = 0x0;
        } wbc_hccoef_upd[1:1];
        field {
            name = "wbc_hlcoef_upd";
            desc = "Whether the horizontal luma filter coefficients need to be updated. Cleared automatically after the hardware update.
- 0: Do not update;
- 1: Update.";
            sw = rw; hw = r;
            reset = 0x0;
        } wbc_hlcoef_upd[0:0];
    } WBC_DHD0_PARAUP @ 0xac40;
    reg {
        name = "WBC_DHD0_HLCOEFAD";
        desc = "WBC_DHD0_HLCOEFAD is the WBC horizontal luma filter coefficient address register. WBC_DHD0_HLCOEFAD (offset 0xAC50, total reset 0x0000_0000; PROVEN: Hi3535 data sheet, PDF page 1087, section 5.10).";
        field {
            name = "coef_addr";
            desc = "Start address in Local Memory where the coefficients are placed.";
            sw = rw; hw = r;
            reset = 0x0;
        } coef_addr[31:0];
    } WBC_DHD0_HLCOEFAD @ 0xac50;
    reg {
        name = "WBC_DHD0_HCCOEFAD";
        desc = "WBC_DHD0_HCCOEFAD is the WBC horizontal chroma filter coefficient address register. WBC_DHD0_HCCOEFAD (offset 0xAC54, total reset 0x0000_0000; PROVEN: Hi3535 data sheet, PDF page 1087, section 5.10).";
        field {
            name = "coef_addr";
            desc = "Start address in Local Memory where the coefficients are placed.";
            sw = rw; hw = r;
            reset = 0x0;
        } coef_addr[31:0];
    } WBC_DHD0_HCCOEFAD @ 0xac54;
    reg {
        name = "WBC_DHD0_VLCOEFAD";
        desc = "WBC_DHD0_VLCOEFAD is the WBC vertical luma filter coefficient address register. WBC_DHD0_VLCOEFAD (offset 0xAC58, total reset 0x0000_0000; PROVEN: Hi3535 data sheet, PDF page 1087, section 5.10).";
        field {
            name = "coef_addr";
            desc = "Start address in Local Memory where the coefficients are placed.";
            sw = rw; hw = r;
            reset = 0x0;
        } coef_addr[31:0];
    } WBC_DHD0_VLCOEFAD @ 0xac58;
    reg {
        name = "WBC_DHD0_VCCOEFAD";
        desc = "WBC_DHD0_VCCOEFAD is the WBC vertical chroma filter coefficient address register. WBC_DHD0_VCCOEFAD (offset 0xAC5C, total reset 0x0000_0000; PROVEN: Hi3535 data sheet, PDF page 1088, section 5.10).";
        field {
            name = "coef_addr";
            desc = "Start address in Local Memory where the coefficients are placed.";
            sw = rw; hw = r;
            reset = 0x0;
        } coef_addr[31:0];
    } WBC_DHD0_VCCOEFAD @ 0xac5c;
    reg {
        name = "WBC_DHD0_DITHER_CTRL";
        desc = "WBC_DHD0_DITHER_CTRL is the Dither control register. WBC_DHD0_DITHER_CTRL (offset 0xAD00, total reset 0x2000_0000; PROVEN: Hi3535 data sheet, PDF page 1088, section 5.10).";
        field {
            name = "dither_md";
            desc = "Dither mode select register.
- 000: 10-bit input, 8-bit output, no dither, direct truncation;
- 011: 10-bit input, 8-bit output, temporal and spatial dither;
- 101: 10-bit input, 8-bit output, rounding;
Others: Reserved.";
            sw = rw; hw = r;
            reset = 0x1;
        } dither_md[31:29];
        field {
            name = "reserved";
            desc = "Reserved.";
            sw = r; hw = w;
            reset = 0x0;
        } reserved_28_0[28:0];
    } WBC_DHD0_DITHER_CTRL @ 0xad00;
    reg {
        name = "WBC_DHD0_DITHER_COEF0";
        desc = "WBC_DHD0_DITHER_COEF0 is Dither coefficient 0 register. WBC_DHD0_DITHER_COEF0 (offset 0xAD04, total reset 0xDD66_4400; PROVEN: Hi3535 data sheet, PDF page 1089, section 5.10).";
        field {
            name = "dither_coef3";
            desc = "Coefficient 3 used by temporal-mode Dither.";
            sw = rw; hw = r;
            reset = 0xdd;
        } dither_coef3[31:24];
        field {
            name = "dither_coef2";
            desc = "Coefficient 2 used by temporal-mode Dither.";
            sw = rw; hw = r;
            reset = 0x66;
        } dither_coef2[23:16];
        field {
            name = "dither_coef1";
            desc = "Coefficient 1 used by temporal-mode Dither.";
            sw = rw; hw = r;
            reset = 0x44;
        } dither_coef1[15:8];
        field {
            name = "dither_coef0";
            desc = "Coefficient 0 used by temporal-mode Dither.";
            sw = rw; hw = r;
            reset = 0x0;
        } dither_coef0[7:0];
    } WBC_DHD0_DITHER_COEF0 @ 0xad04;
    reg {
        name = "WBC_DHD0_DITHER_COEF1";
        desc = "WBC_DHD0_DITHER_COEF1 is Dither coefficient 1 register. WBC_DHD0_DITHER_COEF1 (offset 0xAD08, total reset 0xDD66_4400; PROVEN: Hi3535 data sheet, PDF page 1089, section 5.10).";
        field {
            name = "dither_coef7";
            desc = "Coefficient 7 used by temporal-mode Dither.";
            sw = rw; hw = r;
            reset = 0xdd;
        } dither_coef7[31:24];
        field {
            name = "dither_coef6";
            desc = "Coefficient 6 used by temporal-mode Dither.";
            sw = rw; hw = r;
            reset = 0x66;
        } dither_coef6[23:16];
        field {
            name = "dither_coef5";
            desc = "Coefficient 5 used by temporal-mode Dither.";
            sw = rw; hw = r;
            reset = 0x44;
        } dither_coef5[15:8];
        field {
            name = "dither_coef4";
            desc = "Coefficient 4 used by temporal-mode Dither.";
            sw = rw; hw = r;
            reset = 0x0;
        } dither_coef4[7:0];
    } WBC_DHD0_DITHER_COEF1 @ 0xad08;
    reg {
        name = "WBC_DHD0_HCDS";
        desc = "WBC_DHD0_HCDS is the horizontal chroma downsampling parameter configuration register. A non-immediate register. WBC_DHD0_HCDS (offset 0xAE10, total reset 0x8000_0000; PROVEN: Hi3535 data sheet, PDF page 1090, section 5.10).";
        field {
            name = "hcds_en";
            desc = "Horizontal chroma downsampling enable.
- 0: Disable;
- 1: Enable.";
            sw = rw; hw = r;
            reset = 0x1;
        } hcds_en[31:31];
        field {
            name = "hchmid_en";
            desc = "Horizontal chroma downsampling median filter enable (this bit has no effect when hchfir_en is disabled).
- 0: Disable;
- 1: Enable.";
            sw = rw; hw = r;
            reset = 0x0;
        } hchmid_en[30:30];
        field {
            name = "hchfir_en";
            desc = "Horizontal chroma downsampling mode.
- 0: Copy mode (filtering disabled);
- 1: Filter mode (filtering enabled).";
            sw = rw; hw = r;
            reset = 0x0;
        } hchfir_en[29:29];
        field {
            name = "reserved";
            desc = "Reserved.";
            sw = r; hw = w;
            reset = 0x0;
        } reserved_28_0[28:0];
    } WBC_DHD0_HCDS @ 0xae10;
    reg {
        name = "WBC_DHD0_HCDS_COEF0";
        desc = "WBC_DHD0_HCDS_COEF0 is downsampling coefficient 0 register. WBC_DHD0_HCDS_COEF0 (offset 0xAE14, total reset 0x2750_F367; PROVEN: Hi3535 data sheet, PDF page 1090, section 5.10).";
        field {
            name = "reserved";
            desc = "Reserved.";
            sw = r; hw = w;
            reset = 0x0;
        } reserved_31_30[31:30];
        field {
            name = "coef2";
            desc = "CDS filter coefficient 2.";
            sw = rw; hw = r;
            reset = 0x275;
        } coef2[29:20];
        field {
            name = "coef1";
            desc = "CDS filter coefficient 1.";
            sw = rw; hw = r;
            reset = 0x3c;
        } coef1[19:10];
        field {
            name = "coef0";
            desc = "CDS filter coefficient 0.";
            sw = rw; hw = r;
            reset = 0x367;
        } coef0[9:0];
    } WBC_DHD0_HCDS_COEF0 @ 0xae14;
    reg {
        name = "WBC_DHD0_HCDS_COEF1";
        desc = "WBC_DHD0_HCDS_COEF1 is downsampling coefficient 1 register. WBC_DHD0_HCDS_COEF1 (offset 0xAE18, total reset 0x0000_03E3; PROVEN: Hi3535 data sheet, PDF page 1091, section 5.10).";
        field {
            name = "reserved";
            desc = "Reserved.";
            sw = r; hw = w;
            reset = 0x0;
        } reserved_31_10[31:10];
        field {
            name = "coef3";
            desc = "CDS filter coefficient 3.";
            sw = rw; hw = r;
            reset = 0x3e3;
        } coef3[9:0];
    } WBC_DHD0_HCDS_COEF1 @ 0xae18;
    reg {
        name = "WBC_DHD0_ZME_HSP";
        desc = "WBC_DHD0_ZME_HSP is the horizontal scaling parameter (horizontal Scaling Parameter) configuration register. A non-immediate register. Scaling ratio = input width / output width. WBC_DHD0_ZME_HSP (offset 0xAEC0, total reset 0x0010_0000; PROVEN: Hi3535 data sheet, PDF page 1091, section 5.10).";
        field {
            name = "hlmsc_en";
            desc = "Horizontal luma scaling enable.
- 0: Disable;
- 1: Enable.";
            sw = rw; hw = r;
            reset = 0x0;
        } hlmsc_en[31:31];
        field {
            name = "hchmsc_en";
            desc = "Horizontal chrominance scaling enable.
- 0: Disable.
- 1: Enable.";
            sw = rw; hw = r;
            reset = 0x0;
        } hchmsc_en[30:30];
        field {
            name = "hlmid_en";
            desc = "Horizontal luma scaling median filter enable (this bit has no effect when hlfir_en is inactive).
- 0: Disable;
- 1: Enable.";
            sw = rw; hw = r;
            reset = 0x0;
        } hlmid_en[29:29];
        field {
            name = "hchmid_en";
            desc = "Horizontal chroma scaling median filter enable (this bit has no effect when hchfir_en is inactive).
- 0: Disable;
- 1: Enable.";
            sw = rw; hw = r;
            reset = 0x0;
        } hchmid_en[28:28];
        field {
            name = "reserved";
            desc = "Reserved.";
            sw = r; hw = w;
            reset = 0x0;
        } reserved_27_27[27:27];
        field {
            name = "hlfir_en";
            desc = "Horizontal luma scaling mode.
- 0: Copy mode (filtering disabled);
- 1: Filter mode (filtering enabled).";
            sw = rw; hw = r;
            reset = 0x0;
        } hlfir_en[26:26];
        field {
            name = "hchfir_en";
            desc = "Horizontal chroma scaling mode.
- 0: Copy mode (filtering disabled);
- 1: Filter mode (filtering enabled).";
            sw = rw; hw = r;
            reset = 0x0;
        } hchfir_en[25:25];
        field {
            name = "hfir_order";
            desc = "Horizontal scaling position.
- 0: Horizontal scaling precedes vertical scaling;
- 1: Horizontal scaling follows vertical scaling.";
            sw = rw; hw = r;
            reset = 0x0;
        } hfir_order[24:24];
        field {
            name = "hratio";
            desc = "Horizontal scaling factor, (u,4,20) format.";
            sw = rw; hw = r;
            reset = 0x100000;
        } hratio[23:0];
    } WBC_DHD0_ZME_HSP @ 0xaec0;
    reg {
        name = "WBC_DHD0_ZME_HLOFFSET";
        desc = "WBC_DHD0_ZME_HLOFFSET is the luma horizontal position offset register. Used for pan-scan. Non-immediate register. WBC_DHD0_ZME_HLOFFSET (offset 0xAEC4, total reset 0x0000_0000; PROVEN: Hi3535 data sheet, PDF page 1092, section 5.10).";
        field {
            name = "reserved";
            desc = "Reserved.";
            sw = r; hw = w;
            reset = 0x0;
        } reserved_31_28[31:28];
        field {
            name = "hor_loffset";
            desc = "Horizontal luma position offset, (s,8,20) format. Two's complement representation.";
            sw = rw; hw = r;
            reset = 0x0;
        } hor_loffset[27:0];
    } WBC_DHD0_ZME_HLOFFSET @ 0xaec4;
    reg {
        name = "WBC_DHD0_ZME_HCOFFSET";
        desc = "WBC_DHD0_ZME_HCOFFSET is the chroma horizontal position offset register, used for pan-scan. It is a non-immediate register. WBC_DHD0_ZME_HCOFFSET (offset 0xAEC8, total reset 0x0000_0000; PROVEN: Hi3535 data sheet, PDF page 1093, section 5.10).";
        field {
            name = "reserved";
            desc = "Reserved.";
            sw = r; hw = w;
            reset = 0x0;
        } reserved_31_28[31:28];
        field {
            name = "hor_coffset";
            desc = "Horizontal chrominance position offset, (s,8,20) format. Two's complement representation.";
            sw = rw; hw = r;
            reset = 0x0;
        } hor_coffset[27:0];
    } WBC_DHD0_ZME_HCOFFSET @ 0xaec8;
    reg {
        name = "WBC_DHD0_ZME_VSP";
        desc = "WBC_DHD0_ZME_VSP is the scaling parameter (vertical Scaling Parameter) register. WBC_DHD0_ZME_VSP (offset 0xAED8, total reset 0x0000_0000; PROVEN: Hi3535 data sheet, PDF page 1093, section 5.10).";
        field {
            name = "vlmsc_en";
            desc = "Vertical luma scaling enable.
- 0: Disable;
- 1: Enable.";
            sw = rw; hw = r;
            reset = 0x0;
        } vlmsc_en[31:31];
        field {
            name = "vchmsc_en";
            desc = "Vertical chroma scaling enable.
- 0: Disable;
- 1: Enable.";
            sw = rw; hw = r;
            reset = 0x0;
        } vchmsc_en[30:30];
        field {
            name = "vlmid_en";
            desc = "Vertical luma scaling median filter enable (this bit has no effect when vlfir_en is inactive).
- 0: Disable.
- 1: Enable.";
            sw = rw; hw = r;
            reset = 0x0;
        } vlmid_en[29:29];
        field {
            name = "vchmid_en";
            desc = "Vertical chroma scaling median filter enable (this bit has no effect when vchfir_en is inactive).
- 0: Disable;
- 1: Enable.";
            sw = rw; hw = r;
            reset = 0x0;
        } vchmid_en[28:28];
        field {
            name = "reserved";
            desc = "Reserved.";
            sw = r; hw = w;
            reset = 0x0;
        } reserved_27_27[27:27];
        field {
            name = "vsc_chroma_tap";
            desc = "Vertical chroma scaling order.
- 0: 4th-order FIR;
- 1: 2nd-order FIR.";
            sw = rw; hw = r;
            reset = 0x0;
        } vsc_chroma_tap[26:26];
        field {
            name = "reserved";
            desc = "Reserved.";
            sw = rw; hw = r;
            reset = 0x0;
        } reserved_25_25[25:25];
        field {
            name = "vlfir_en";
            desc = "Vertical luminance scaling mode.
- 0: Copy mode (filtering disabled).
- 1: Filter mode (filtering enabled).";
            sw = rw; hw = r;
            reset = 0x0;
        } vlfir_en[24:24];
        field {
            name = "vchfir_en";
            desc = "Vertical chroma scaling mode.
- 0: Copy mode (filtering disabled);
- 1: Filter mode (filtering enabled).";
            sw = rw; hw = r;
            reset = 0x0;
        } vchfir_en[23:23];
        field {
            name = "zme_out_fmt";
            desc = "Scaling output data format.
- 0: 422;
- 1: 420.";
            sw = rw; hw = r;
            reset = 0x0;
        } zme_out_fmt[22:21];
        field {
            name = "zme_in_fmt";
            desc = "Scaling input data format.
- 0: 422;
- 1: 420.";
            sw = rw; hw = r;
            reset = 0x0;
        } zme_in_fmt[20:19];
        field {
            name = "reserved";
            desc = "Reserved.";
            sw = r; hw = w;
            reset = 0x0;
        } reserved_18_0[18:0];
    } WBC_DHD0_ZME_VSP @ 0xaed8;
    reg {
        name = "WBC_DHD0_ZME_VSR";
        desc = "WBC_DHD0_ZME_VSR is the Luma Vertical Scaling Ratio register. Scaling ratio = input height / output height. It is a non-immediate register. WBC_DHD0_ZME_VSR (offset 0xAEDC, total reset 0x0000_1000; PROVEN: Hi3535 data sheet, PDF page 1095, section 5.10).";
        field {
            name = "reserved";
            desc = "Reserved.";
            sw = r; hw = w;
            reset = 0x0;
        } reserved_31_16[31:16];
        field {
            name = "vratio";
            desc = "Vertical scaling factor, (u,4,12) format.";
            sw = rw; hw = r;
            reset = 0x1000;
        } vratio[15:0];
    } WBC_DHD0_ZME_VSR @ 0xaedc;
    reg {
        name = "WBC_DHD0_ZME_VOFFSET";
        desc = "WBC_DHD0_ZME_VOFFSET is the vertical scaling offset (Vertical Scaling Offset) register. The vertical scaling offset is affected by two factors: pan-scan and the field offset when frames are repeated. When there is no field offset, vluma_offset is the lowest integer bits plus the fractional bits of offset_pan-scan; in YCbCr422 format, vchroma_offset equals vluma_offset; in YCbCr420 format, vchroma_offset = scaling_chroma/2-0.25. When a field offset is needed (for example, a still frame or repeated frames), assuming the bottom field is repeated, the vluma_offset and vchroma_offset configured for the top field are the same as in the no-offset case above, and the bottom field configuration must take the field offset into account. WBC_DHD0_ZME_VOFFSET (offset 0xAEE0, total reset 0x0000_0000; PROVEN: Hi3535 data sheet, PDF page 1095, section 5.10).";
        field {
            name = "vluma_offset";
            desc = "Vertical luma offset, two's complement representation, (s,4,12) format.";
            sw = rw; hw = r;
            reset = 0x0;
        } vluma_offset[31:16];
        field {
            name = "vchroma_offset";
            desc = "Vertical chroma offset, two's complement, (s,4,12) format.";
            sw = rw; hw = r;
            reset = 0x0;
        } vchroma_offset[15:0];
    } WBC_DHD0_ZME_VOFFSET @ 0xaee0;
    reg {
        name = "WBC_DHD0_ZME_VBOFFSET";
        desc = "WBC_DHD0_ZME_VBOFFSET is the bottom field Vertical Scaling Offset register. The vertical scaling offset is affected by two factors: pan-scan and the field offset when frames are repeated. When there is no field offset, vluma_offset is the lowest integer bits plus the fractional bits of offset_pan-scan; in YCbCr422 format vchroma_offset equals vluma_offset; in YCbCr420 format, vchroma_offset = scaling_chroma/2-0.25. When a field offset is needed (for example, a still frame or repeated frame), assuming the bottom field is repeated, the vluma_offset and vchroma_offset configured for the top field are the same as in the no-offset case above, and the bottom field configuration must account for the field offset. WBC_DHD0_ZME_VBOFFSET (offset 0xAEE4, total reset 0x0000_0000; PROVEN: Hi3535 data sheet, PDF page 1096, section 5.10).";
        field {
            name = "vbluma_offset";
            desc = "Vertical luma offset, two's complement representation, (s,4,12) format.";
            sw = rw; hw = r;
            reset = 0x0;
        } vbluma_offset[31:16];
        field {
            name = "vbchroma_offset";
            desc = "Vertical chroma offset, two's complement, (s,4,12) format.";
            sw = rw; hw = r;
            reset = 0x0;
        } vbchroma_offset[15:0];
    } WBC_DHD0_ZME_VBOFFSET @ 0xaee4;
    reg {
        name = "WBC_DHD0_CSCIDC";
        desc = "WBC_DHD0_CSCIDC is the color space conversion input DC component register; an immediate register. WBC_DHD0_CSCIDC (offset 0xAF00, total reset 0x0000_0000; PROVEN: Hi3535 data sheet, PDF page 1096, section 5.10).";
        field {
            name = "reserved";
            desc = "Reserved.";
            sw = r; hw = w;
            reset = 0x0;
        } reserved_31_31[31:31];
        field {
            name = "csc_mode";
            desc = "Valid only when the CSC coefficients are fixed.
- 000: reserved
- 001: YUV2YUV
- 010: YUV601_RGB
- 011: YUV709_RGB
- 100: YUV2YUV_709_601
- 101: YUV2YUV_601_709
- 110: RGB2YUV_601
- 111: RGB2YUV_709";
            sw = rw; hw = r;
            reset = 0x0;
        } csc_mode[30:28];
        field {
            name = "csc_en";
            desc = "CSC enable control signal.
- 0: CSC disabled;
- 1: CSC enabled.";
            sw = rw; hw = r;
            reset = 0x0;
        } csc_en[27:27];
        field {
            name = "cscidc2";
            desc = "Input Y/R component DC parameter; the MSB is the sign bit. Two's complement representation.";
            sw = rw; hw = r;
            reset = 0x0;
        } cscidc2[26:18];
        field {
            name = "cscidc1";
            desc = "Input U/G component DC parameter, MSB is the sign bit. Two's complement representation.";
            sw = rw; hw = r;
            reset = 0x0;
        } cscidc1[17:9];
        field {
            name = "cscidc0";
            desc = "Input V/B component DC parameter, the MSB is the sign bit. Two's complement representation.";
            sw = rw; hw = r;
            reset = 0x0;
        } cscidc0[8:0];
    } WBC_DHD0_CSCIDC @ 0xaf00;
    reg {
        name = "WBC_DHD0_CSCODC";
        desc = "WBC_DHD0_CSCODC is the color space conversion output DC component register, an immediate register. WBC_DHD0_CSCODC (offset 0xAF04, total reset 0x0000_0000; PROVEN: Hi3535 data sheet, PDF page 1097, section 5.10).";
        field {
            name = "reserved";
            desc = "Reserved.";
            sw = r; hw = w;
            reset = 0x0;
        } reserved_31_27[31:27];
        field {
            name = "cscodc2";
            desc = "Output V/B component DC parameter, MSB is the sign bit. Two's complement representation.";
            sw = rw; hw = r;
            reset = 0x0;
        } cscodc2[26:18];
        field {
            name = "cscodc1";
            desc = "Output U/G component DC parameter, MSB is the sign bit. Two's complement representation.";
            sw = rw; hw = r;
            reset = 0x0;
        } cscodc1[17:9];
        field {
            name = "cscodc0";
            desc = "Output Y/R component DC parameter, MSB is the sign bit. Two's complement representation.";
            sw = rw; hw = r;
            reset = 0x0;
        } cscodc0[8:0];
    } WBC_DHD0_CSCODC @ 0xaf04;
    reg {
        name = "WBC_DHD0_CSCP0";
        desc = "WBC_DHD0_CSCP0 is color space conversion parameter 0. It is an immediate register. WBC_DHD0_CSCP0 (offset 0xAF08, total reset 0x0000_0000; PROVEN: Hi3535 data sheet, PDF page 1097, section 5.10).";
        field {
            name = "reserved";
            desc = "Reserved.";
            sw = r; hw = w;
            reset = 0x0;
        } reserved_31_31[31:31];
        field {
            name = "cscp01";
            desc = "5.8 data format: 1-bit sign, 4-bit integer, 8-bit fraction. Two's complement representation.";
            sw = rw; hw = r;
            reset = 0x0;
        } cscp01[30:16];
        field {
            name = "reserved";
            desc = "Reserved.";
            sw = r; hw = w;
            reset = 0x0;
        } reserved_15_15[15:15];
        field {
            name = "cscp00";
            desc = "5.8 data format: 1-bit sign, 4-bit integer, 8-bit fraction. Two's complement representation.";
            sw = rw; hw = r;
            reset = 0x0;
        } cscp00[14:0];
    } WBC_DHD0_CSCP0 @ 0xaf08;
    reg {
        name = "WBC_DHD0_CSCP1";
        desc = "WBC_DHD0_CSCP1 is color space conversion parameter 1, an immediate register. WBC_DHD0_CSCP1 (offset 0xAF0C, total reset 0x0000_0000; PROVEN: Hi3535 data sheet, PDF page 1098, section 5.8).";
        field {
            name = "reserved";
            desc = "Reserved.";
            sw = r; hw = w;
            reset = 0x0;
        } reserved_31_31[31:31];
        field {
            name = "cscp10";
            desc = "5.8 data format: 1-bit sign, 4-bit integer, 8-bit fraction. Two's complement representation.";
            sw = rw; hw = r;
            reset = 0x0;
        } cscp10[30:16];
        field {
            name = "reserved";
            desc = "Reserved.";
            sw = r; hw = w;
            reset = 0x0;
        } reserved_15_15[15:15];
        field {
            name = "cscp02";
            desc = "5.8 data format: 1-bit sign, 4-bit integer, 8-bit fraction. Two's complement representation.";
            sw = rw; hw = r;
            reset = 0x0;
        } cscp02[14:0];
    } WBC_DHD0_CSCP1 @ 0xaf0c;
    reg {
        name = "WBC_DHD0_CSCP2";
        desc = "WBC_DHD0_CSCP2 is color space conversion parameter 2; an immediate register. WBC_DHD0_CSCP2 (offset 0xAF10, total reset 0x0000_0000; PROVEN: Hi3535 data sheet, PDF page 1098, section 5.8).";
        field {
            name = "reserved";
            desc = "Reserved.";
            sw = r; hw = w;
            reset = 0x0;
        } reserved_31_31[31:31];
        field {
            name = "cscp12";
            desc = "5.8 data format: 1-bit sign, 4-bit integer, 8-bit fraction. Two's complement representation.";
            sw = rw; hw = r;
            reset = 0x0;
        } cscp12[30:16];
        field {
            name = "reserved";
            desc = "Reserved.";
            sw = r; hw = w;
            reset = 0x0;
        } reserved_15_15[15:15];
        field {
            name = "cscp11";
            desc = "5.8 data format: 1-bit sign, 4-bit integer, 8-bit fraction. Two's complement representation.";
            sw = rw; hw = r;
            reset = 0x0;
        } cscp11[14:0];
    } WBC_DHD0_CSCP2 @ 0xaf10;
    reg {
        name = "WBC_DHD0_CSCP3";
        desc = "WBC_DHD0_CSCP3 is color space conversion parameter 3, an immediate register. WBC_DHD0_CSCP3 (offset 0xAF14, total reset 0x0000_0000; PROVEN: Hi3535 data sheet, PDF page 1099, section 5.8).";
        field {
            name = "reserved";
            desc = "Reserved.";
            sw = r; hw = w;
            reset = 0x0;
        } reserved_31_31[31:31];
        field {
            name = "cscp21";
            desc = "5.8 data format: 1-bit sign, 4-bit integer, 8-bit fraction. Two's complement representation.";
            sw = rw; hw = r;
            reset = 0x0;
        } cscp21[30:16];
        field {
            name = "reserved";
            desc = "Reserved.";
            sw = r; hw = w;
            reset = 0x0;
        } reserved_15_15[15:15];
        field {
            name = "cscp20";
            desc = "5.8 data format: 1-bit sign, 4-bit integer, 8-bit fraction. Two's complement representation.";
            sw = rw; hw = r;
            reset = 0x0;
        } cscp20[14:0];
    } WBC_DHD0_CSCP3 @ 0xaf14;
    reg {
        name = "WBC_DHD0_CSCP4";
        desc = "WBC_DHD0_CSCP4 is color space conversion parameter 4. It is an immediate register. WBC_DHD0_CSCP4 (offset 0xAF18, total reset 0x0000_0000; PROVEN: Hi3535 data sheet, PDF page 1100, section 5.8).";
        field {
            name = "reserved";
            desc = "Reserved.";
            sw = r; hw = w;
            reset = 0x0;
        } reserved_31_15[31:15];
        field {
            name = "cscp22";
            desc = "5.8 data format: 1-bit sign, 4-bit integer, 8-bit fraction. Two's complement representation.";
            sw = rw; hw = r;
            reset = 0x0;
        } cscp22[14:0];
    } WBC_DHD0_CSCP4 @ 0xaf18;
    reg {
        name = "CBM_BKG1";
        desc = "CBM_BKG1 is the CBM Mixer1 overlay background color register. CBM_BKG1 (offset 0xB400, total reset 0x0000_0000; PROVEN: Hi3535 data sheet, PDF page 1100, section 5.8).";
        field {
            name = "reserved";
            desc = "Reserved.";
            sw = r; hw = w;
            reset = 0x0;
        } reserved_31_30[31:30];
        field {
            name = "cbm_bkgy1";
            desc = "CBM Mixer1 overlay background color, Y component.";
            sw = rw; hw = r;
            reset = 0x0;
        } cbm_bkgy1[29:20];
        field {
            name = "cbm_bkgcb1";
            desc = "CBM Mixer1 overlay background color, Cb component.";
            sw = rw; hw = r;
            reset = 0x0;
        } cbm_bkgcb1[19:10];
        field {
            name = "cbm_bkgcr1";
            desc = "CBM Mixer1 overlay background color, Cr component.";
            sw = rw; hw = r;
            reset = 0x0;
        } cbm_bkgcr1[9:0];
    } CBM_BKG1 @ 0xb400;
    reg {
        name = "CBM_MIX1";
        desc = "CBM_MIX1 is the CBM Mixer1 priority configuration register. Takes effect on update at vsync. mixer_prio_x indicates the layer configured at the x-th priority. This register is an immediate register. CBM_MIX1 (offset 0xB408, total reset 0x0000_0001; PROVEN: Hi3535 data sheet, PDF page 1101, section 5.8).";
        field {
            name = "reserved";
            desc = "Reserved.";
            sw = r; hw = w;
            reset = 0x0;
        } reserved_31_16[31:16];
        field {
            name = "mixer_prio3";
            desc = "Overlay layer priority configuration of CBM Mixer1, indicating the layer driven at priority 3.
- 0000: No layer driven;
- 0001: v0;
- 0010: g0;
- 1001: v1;
- 1010: hc; Others: Reserved.";
            sw = rw; hw = r;
            reset = 0x0;
        } mixer_prio3[15:12];
        field {
            name = "mixer_prio2";
            desc = "Overlay layer priority configuration of CBM Mixer1; indicates the layer driving priority 2.
- 0000: No layer drives;
- 0001: v0;
- 0010: g0;
- 1001: v1;
- 1010: hc; Others: Reserved.";
            sw = rw; hw = r;
            reset = 0x0;
        } mixer_prio2[11:8];
        field {
            name = "mixer_prio1";
            desc = "CBM Mixer1 overlay layer priority configuration, indicating the layer driving priority 1.
- 0000: No layer drives.
- 0001: v0.
- 0010: g0.
- 1001: v1.
- 1010: hc. Others: Reserved.";
            sw = rw; hw = r;
            reset = 0x0;
        } mixer_prio1[7:4];
        field {
            name = "mixer_prio0";
            desc = "Overlay layer priority configuration of CBM Mixer1, indicating the layer driven at priority 0.
- 0000: No layer driven;
- 0001: v0;
- 0010: g0;
- 1001: v1;
- 1010: hc;
Others: Reserved.";
            sw = rw; hw = r;
            reset = 0x1;
        } mixer_prio0[3:0];
    } CBM_MIX1 @ 0xb408;
    reg {
        name = "CBM_BKG2";
        desc = "CBM_BKG2 is the CBM Mixer2 overlay background color register. CBM_BKG2 (offset 0xB420, total reset 0x0000_0000; PROVEN: Hi3535 data sheet, PDF page 1102, section 5.8).";
        field {
            name = "reserved";
            desc = "Reserved.";
            sw = r; hw = w;
            reset = 0x0;
        } reserved_31_30[31:30];
        field {
            name = "cbm_bkgy2";
            desc = "CBM Mixer2 overlay background color, Y component.";
            sw = rw; hw = r;
            reset = 0x0;
        } cbm_bkgy2[29:20];
        field {
            name = "cbm_bkgcb2";
            desc = "CBM Mixer2 overlay background color, Cb component.";
            sw = rw; hw = r;
            reset = 0x0;
        } cbm_bkgcb2[19:10];
        field {
            name = "cbm_bkgcr2";
            desc = "CBM Mixer2 overlay background color, Cr component.";
            sw = rw; hw = r;
            reset = 0x0;
        } cbm_bkgcr2[9:0];
    } CBM_BKG2 @ 0xb420;
    reg {
        name = "CBM_MIX2";
        desc = "CBM_MIX2 is the CBM Mixer2 priority configuration register. Takes effect at vsync. mixer_prio_x indicates the layer configured for the x-th priority. This register is an immediate register. CBM_MIX2 (offset 0xB428, total reset 0x0000_0000; PROVEN: Hi3535 data sheet, PDF page 1102, section 5.8).";
        field {
            name = "reserved";
            desc = "Reserved.";
            sw = r; hw = w;
            reset = 0x0;
        } reserved_31_16[31:16];
        field {
            name = "mixer_prio3";
            desc = "CBM Mixer2 overlay layer priority configuration; indicates the layer driving priority 3.
- 0000: No layer drives.
- 0011: v3.
- 0100: g4.
- 1001: v1.
- 1010: hc. Others: Reserved.";
            sw = rw; hw = r;
            reset = 0x0;
        } mixer_prio3[15:12];
        field {
            name = "mixer_prio2";
            desc = "CBM Mixer2 overlay layer priority configuration, indicating the layer driving priority 2.
- 0000: No layer drives.
- 0011: v3.
- 0100: g4.
- 1001: v1.
- 1010: hc. Others: Reserved.";
            sw = rw; hw = r;
            reset = 0x0;
        } mixer_prio2[11:8];
        field {
            name = "mixer_prio1";
            desc = "Overlay priority configuration of CBM Mixer2: the layer driven at priority 1.
- 0000: No layer driven;
- 0011: v3;
- 0100: g4;
- 1001: v1;
- 1010: hc;
Other values: reserved.";
            sw = rw; hw = r;
            reset = 0x0;
        } mixer_prio1[7:4];
        field {
            name = "mixer_prio0";
            desc = "Overlay layer priority configuration of CBM Mixer2, indicating the layer driven at priority 0.
- 0000: No layer driven;
- 0011: v3;
- 0100: g4;
- 1001: v1;
- 1010: hc;
Others: Reserved.";
            sw = rw; hw = r;
            reset = 0x0;
        } mixer_prio0[3:0];
    } CBM_MIX2 @ 0xb428;
    reg {
        name = "MIXDSD_BKG";
        desc = "MIXDSD_BKG is the DSD path Mixer1 overlay background color register. MIXDSD_BKG (offset 0xB600, total reset 0x0000_0000; PROVEN: Hi3535 data sheet, PDF page 1104, section 5.8).";
        field {
            name = "reserved";
            desc = "Reserved.";
            sw = r; hw = w;
            reset = 0x0;
        } reserved_31_30[31:30];
        field {
            name = "mixer_bkgy";
            desc = "MIXDSD overlay background color, Y component.";
            sw = rw; hw = r;
            reset = 0x0;
        } mixer_bkgy[29:20];
        field {
            name = "mixer_bkgcb";
            desc = "MIXDSD overlay background color, Cb component.";
            sw = rw; hw = r;
            reset = 0x0;
        } mixer_bkgcb[19:10];
        field {
            name = "mixer_bkgcr";
            desc = "MIXDSD overlay background color, Cr component.";
            sw = rw; hw = r;
            reset = 0x0;
        } mixer_bkgcr[9:0];
    } MIXDSD_BKG @ 0xb600;
    reg {
        name = "MIXDSD_MIX";
        desc = "MIXDSD_MIX is the DSD Mixer1 priority configuration register. Updates take effect at vsync. mixer_prio_x indicates the layer configured at the x-th priority. This register is an immediate register. MIXDSD_MIX (offset 0xB608, total reset 0x0000_0001; PROVEN: Hi3535 data sheet, PDF page 1104, section 5.8).";
        field {
            name = "reserved";
            desc = "Reserved.";
            sw = r; hw = w;
            reset = 0x0;
        } reserved_31_12[31:12];
        field {
            name = "mixer_prio2";
            desc = "Overlay priority configuration of DSD Mixer1: the layer driven at priority 2.
- 0000: No layer driven;
- 0001: v4;
- 0010: g1;
- 1010: hc;
Other values: reserved.";
            sw = rw; hw = r;
            reset = 0x0;
        } mixer_prio2[11:8];
        field {
            name = "mixer_prio1";
            desc = "Overlay layer priority configuration of DSD Mixer1, indicating the layer driven at priority 1.
- 0000: No layer driven;
- 0001: v4;
- 0010: g1;
- 1010: hc;
Others: Reserved.";
            sw = rw; hw = r;
            reset = 0x0;
        } mixer_prio1[7:4];
        field {
            name = "mixer_prio0";
            desc = "DSD Mixer1 overlay layer priority configuration, indicating the layer driving priority 0.
- 0000: No layer drives.
- 0001: v4.
- 0010: g1.
- 1010: hc. Others: Reserved.";
            sw = rw; hw = r;
            reset = 0x1;
        } mixer_prio0[3:0];
    } MIXDSD_MIX @ 0xb608;
    reg {
        name = "DHD0_CTRL";
        desc = "DHD0_CTRL is the overall control register of the display channel. All bits of this register must be configured no later than the DHD0_CTRL.intf_en bit; otherwise the configuration does not take effect. DHD0_CTRL (offset 0xC000, total reset 0x0000_0000; PROVEN: Hi3535 data sheet, PDF page 1105, section 5.8).";
        field {
            name = "intf_en";
            desc = "Display interface enable. The interface outputs only when enabled. An immediate register.
- 0: Disable.
- 1: Enable.";
            sw = rw; hw = r;
            reset = 0x0;
        } intf_en[31:31];
        field {
            name = "cbar_en";
            desc = "Color bar enable. When enabled, the interface outputs a color bar.
- 0: Disable;
- 1: Enable.";
            sw = rw; hw = r;
            reset = 0x0;
        } cbar_en[30:30];
        field {
            name = "cbar_sel";
            desc = "Output color bar color space select signal, immediate register.
- 0: VGA;
- 1: YPbPr.";
            sw = rw; hw = r;
            reset = 0x0;
        } cbar_sel[29:29];
        field {
            name = "reserved";
            desc = "Reserved.";
            sw = r; hw = w;
            reset = 0x0;
        } reserved_28_28[28:28];
        field {
            name = "fpga_lmt_en";
            desc = "debug register. Due to the FPGA clock bus frequency limit, 1080i image content cannot be displayed. When this register is enabled, image content of 1280 width can be displayed on the 1080i interface.
- 0: Disable.
- 1: Enable.";
            sw = rw; hw = r;
            reset = 0x0;
        } fpga_lmt_en[27:27];
        field {
            name = "fpga_lmt_width";
            desc = "Debug register. When fpga_lmt_en is enabled, the valid area width output by the VDP interface is determined by this register. Actual output valid area width = fpga_lmt_width*16.";
            sw = rw; hw = r;
            reset = 0x0;
        } fpga_lmt_width[26:20];
        field {
            name = "reserved";
            desc = "Reserved.";
            sw = r; hw = w;
            reset = 0x0;
        } reserved_19_5[19:5];
        field {
            name = "iop";
            desc = "Progressive or interlaced display. Non-immediate register.
- 0: Interlaced display;
- 1: Progressive display.";
            sw = rw; hw = r;
            reset = 0x0;
        } iop[4:4];
        field {
            name = "reserved";
            desc = "Reserved";
            sw = r; hw = w;
            reset = 0x0;
        } reserved_3_1[3:1];
        field {
            name = "regup";
            desc = "Register update of the surface. After software finishes configuring the registers of this layer, write 1 to update; hardware clears it automatically when the update completes. (data sheet access type WC)";
            sw = rw; hw = r; onwrite = woclr;
            reset = 0x0;
        } regup[0:0];
    } DHD0_CTRL @ 0xc000;
    reg {
        name = "DHD0_VSYNC";
        desc = "DHD0_VSYNC: for interlaced output, this register holds the top field vertical sync timing; for progressive output, it holds the frame vertical sync timing. Non-immediate register. DHD0_VSYNC (offset 0xC004, total reset 0x0011_321B; PROVEN: Hi3535 data sheet, PDF page 1106, section 5.8).";
        field {
            name = "reserved";
            desc = "Reserved.";
            sw = r; hw = w;
            reset = 0x0;
        } reserved_31_28[31:28];
        field {
            name = "vfb";
            desc = "For interlaced output: top field vertical blanking front porch; for progressive output: vertical blanking front porch.";
            sw = rw; hw = r;
            reset = 0x1;
        } vfb[27:20];
        field {
            name = "vbb";
            desc = "For interlaced output: vertical back porch of the top field; for progressive output: vertical back porch plus the width of the vertical pulse.";
            sw = rw; hw = r;
            reset = 0x13;
        } vbb[19:12];
        field {
            name = "vact";
            desc = "For interlaced output: height of the active image of the top field. For progressive output: height of the active image of a frame. The register value is the actual value minus 1.";
            sw = rw; hw = r;
            reset = 0x21b;
        } vact[11:0];
    } DHD0_VSYNC @ 0xc004;
    reg {
        name = "DHD0_HSYNC1";
        desc = "DHD0_HSYNC1 is the horizontal sync configuration register for interlaced or progressive output. Non-immediate register. DHD0_HSYNC1 (offset 0xC008, total reset 0x00BF_077F; PROVEN: Hi3535 data sheet, PDF page 1107, section 5.8).";
        field {
            name = "hbb";
            desc = "Horizontal blanking back porch, in pixels.";
            sw = rw; hw = r;
            reset = 0xbf;
        } hbb[31:16];
        field {
            name = "hact";
            desc = "Number of horizontal pixels in the active area.";
            sw = rw; hw = r;
            reset = 0x77f;
        } hact[15:0];
    } DHD0_HSYNC1 @ 0xc008;
    reg {
        name = "DHD0_HSYNC2";
        desc = "DHD0_HSYNC2 is the horizontal sync configuration register for interlaced or progressive output; not an immediate register. DHD0_HSYNC2 (offset 0xC00C, total reset 0x0000_020F; PROVEN: Hi3535 data sheet, PDF page 1107, section 5.8).";
        field {
            name = "hmid";
            desc = "Bottom field vertical sync valid pixel value (active data area).";
            sw = rw; hw = r;
            reset = 0x0;
        } hmid[31:16];
        field {
            name = "hfb";
            desc = "Horizontal blanking front porch, in pixels.";
            sw = rw; hw = r;
            reset = 0x20f;
        } hfb[15:0];
    } DHD0_HSYNC2 @ 0xc00c;
    reg {
        name = "DHD0_VPLUS";
        desc = "DHD0_VPLUS: for interlaced output, this register indicates the vertical sync timing of the bottom field; not an immediate register. DHD0_VPLUS (offset 0xC010, total reset 0x0021_321B; PROVEN: Hi3535 data sheet, PDF page 1108, section 5.8).";
        field {
            name = "reserved";
            desc = "Reserved.";
            sw = r; hw = w;
            reset = 0x0;
        } reserved_31_28[31:28];
        field {
            name = "bvfb";
            desc = "For interlaced output: bottom field vertical blanking front porch.";
            sw = rw; hw = r;
            reset = 0x2;
        } bvfb[27:20];
        field {
            name = "bvbb";
            desc = "In interlaced output: width of the vertical pulse of the bottom field vertical blanking back porch.";
            sw = rw; hw = r;
            reset = 0x13;
        } bvbb[19:12];
        field {
            name = "bvact";
            desc = "For interlaced output: height of the active picture of the bottom field. The register value is the actual value minus 1.";
            sw = rw; hw = r;
            reset = 0x21b;
        } bvact[11:0];
    } DHD0_VPLUS @ 0xc010;
    reg {
        name = "DHD0_PWR";
        desc = "DHD0_PWR is the sync signal pulse width, a non-immediate register. DHD0_PWR (offset 0xC014, total reset 0x0000_0000; PROVEN: Hi3535 data sheet, PDF page 1108, section 5.8).";
        field {
            name = "reserved";
            desc = "Reserved.";
            sw = r; hw = w;
            reset = 0x0;
        } reserved_31_24[31:24];
        field {
            name = "vpw";
            desc = "Vertical pulse width minus 1.";
            sw = rw; hw = r;
            reset = 0x0;
        } vpw[23:16];
        field {
            name = "hpw";
            desc = "Horizontal pulse width minus 1.";
            sw = rw; hw = r;
            reset = 0x0;
        } hpw[15:0];
    } DHD0_PWR @ 0xc014;
    reg {
        name = "DHD0_VTTHD3";
        desc = "DHD0_VTTHD3 is the Vertical Timing Threshold register, an immediate register. It contains two threshold settings, each of which can independently generate an interrupt. DHD0_VTTHD3 (offset 0xC018, total reset 0x0000_0000; PROVEN: Hi3535 data sheet, PDF page 1109, section 5.8).";
        field {
            name = "thd4_mode";
            desc = "Mode in which threshold 4 is generated.
- 0: Frame mode, threshold counting is per frame;
- 1: Field mode, threshold counting is per field when displaying interlaced.";
            sw = rw; hw = r;
            reset = 0x0;
        } thd4_mode[31:31];
        field {
            name = "reserved";
            desc = "Reserved.";
            sw = r; hw = w;
            reset = 0x0;
        } reserved_30_29[30:29];
        field {
            name = "vtmgthd4";
            desc = "Vertical timing threshold 4, used for synchronous triggering of DHD and DSD. The DSD interface timing starts later than the DHD by the number of lines configured in vtmgthd4.";
            sw = rw; hw = r;
            reset = 0x0;
        } vtmgthd4[28:16];
        field {
            name = "thd3_mode";
            desc = "Mode for generating the threshold 3 interrupt:
- 0: Frame mode, the threshold is counted in frames;
- 1: Field mode, the threshold is counted in fields during interlaced display.";
            sw = rw; hw = r;
            reset = 0x0;
        } thd3_mode[15:15];
        field {
            name = "reserved";
            desc = "Reserved.";
            sw = r; hw = w;
            reset = 0x0;
        } reserved_14_13[14:13];
        field {
            name = "vtmgthd3";
            desc = "Vertical timing threshold 3. When the vertical timing counter reaches this threshold, the VOINTSTA[dhdvtthd3_int] interrupt is triggered.";
            sw = rw; hw = r;
            reset = 0x0;
        } vtmgthd3[12:0];
    } DHD0_VTTHD3 @ 0xc018;
    reg {
        name = "DHD0_VTTHD";
        desc = "DHD0_VTTHD is the Vertical Timing Threshold register, an immediate register. It contains two threshold configurations that can each independently generate an interrupt. DHD0_VTTHD (offset 0xC01C, total reset 0x0001_0001; PROVEN: Hi3535 data sheet, PDF page 1110, section 5.8).";
        field {
            name = "thd2_mode";
            desc = "Mode of threshold 2 interrupt generation.
- 0: Frame mode, threshold counting is done per frame;
- 1: Field mode, threshold counting is done per field in interlaced display.";
            sw = rw; hw = r;
            reset = 0x0;
        } thd2_mode[31:31];
        field {
            name = "reserved";
            desc = "Reserved.";
            sw = r; hw = w;
            reset = 0x0;
        } reserved_30_29[30:29];
        field {
            name = "vtmgthd2";
            desc = "Vertical timing threshold 2. When the vertical timing counter reaches this threshold, the VOINTSTA[dhdvtthd2_int] interrupt is triggered.";
            sw = rw; hw = r;
            reset = 0x1;
        } vtmgthd2[28:16];
        field {
            name = "thd1_mode";
            desc = "Mode in which the threshold 1 interrupt is generated:
- 0: Frame mode; threshold counting is done per frame.
- 1: Field mode; for interlaced display, threshold counting is done per field.";
            sw = rw; hw = r;
            reset = 0x0;
        } thd1_mode[15:15];
        field {
            name = "reserved";
            desc = "Reserved.";
            sw = r; hw = w;
            reset = 0x0;
        } reserved_14_13[14:13];
        field {
            name = "vtmgthd1";
            desc = "Vertical timing threshold 1. When the vertical timing counter reaches this threshold, the VOINTSTA[dhdvtthd_int1] interrupt is triggered.";
            sw = rw; hw = r;
            reset = 0x1;
        } vtmgthd1[12:0];
    } DHD0_VTTHD @ 0xc01c;
    reg {
        name = "DHD0_AFFTHD";
        desc = "DHD0_AFFTHD is the DHD asynchronous FIFO pre-low-bandwidth threshold register. DHD0_AFFTHD (offset 0xC030, total reset 0x0000_0020; PROVEN: Hi3535 data sheet, PDF page 1110, section 5.8).";
        field {
            name = "reserved";
            desc = "Reserved.";
            sw = r; hw = w;
            reset = 0x0;
        } reserved_31_6[31:6];
        field {
            name = "dhd_aff_thd";
            desc = "DHD asynchronous FIFO pre-low-bandwidth threshold.";
            sw = rw; hw = r;
            reset = 0x20;
        } dhd_aff_thd[5:0];
    } DHD0_AFFTHD @ 0xc030;
    reg {
        name = "DHD0_VGA_DACDET1";
        desc = "DHD0_VGA_DACDET1 is VGA DAC auto-detection register 1. DHD0_VGA_DACDET1 (offset 0xC038, total reset 0x000D_0303; PROVEN: Hi3535 data sheet, PDF page 1111, section 5.8).";
        field {
            name = "reserved";
            desc = "Reserved.";
            sw = r; hw = w;
            reset = 0x0;
        } reserved_31_26[31:26];
        field {
            name = "det_line";
            desc = "Line on which the level is detected.";
            sw = rw; hw = r;
            reset = 0xd;
        } det_line[25:16];
        field {
            name = "reserved";
            desc = "Reserved.";
            sw = r; hw = w;
            reset = 0x0;
        } reserved_15_10[15:10];
        field {
            name = "vdac_det_high";
            desc = "Detected level value.";
            sw = rw; hw = r;
            reset = 0x303;
        } vdac_det_high[9:0];
    } DHD0_VGA_DACDET1 @ 0xc038;
    reg {
        name = "DHD0_VGA_DACDET2";
        desc = "DHD0_VGA_DACDET2 is the VGA DAC auto-detection 2 register. DHD0_VGA_DACDET2 (offset 0xC03C, total reset 0x0030_0118; PROVEN: Hi3535 data sheet, PDF page 1111, section 5.8).";
        field {
            name = "vdac_det_en";
            desc = "DAC auto-detect enable.
- 0: Disable;
- 1: Enable.";
            sw = rw; hw = r;
            reset = 0x0;
        } vdac_det_en[31:31];
        field {
            name = "reserved";
            desc = "Reserved.";
            sw = r; hw = w;
            reset = 0x0;
        } reserved_30_27[30:27];
        field {
            name = "det_pixel_wid";
            desc = "Level width.";
            sw = rw; hw = r;
            reset = 0x30;
        } det_pixel_wid[26:16];
        field {
            name = "reserved";
            desc = "Reserved.";
            sw = r; hw = w;
            reset = 0x0;
        } reserved_15_11[15:11];
        field {
            name = "det_pixel_sta";
            desc = "At the start position of a line.";
            sw = rw; hw = r;
            reset = 0x118;
        } det_pixel_sta[10:0];
    } DHD0_VGA_DACDET2 @ 0xc03c;
    reg {
        name = "DHD0_PARATHD";
        desc = "DHD0_PARATHD is the PARA coefficient update point threshold register. DHD0_PARATHD (offset 0xC0B0, total reset 0x0000_0000; PROVEN: Hi3535 data sheet, PDF page 1112, section 5.8).";
        field {
            name = "dfs_en";
            desc = "DFS enable control bit.
- 0: Disable
- 1: Enable";
            sw = rw; hw = r;
            reset = 0x0;
        } dfs_en[31:31];
        field {
            name = "reserved";
            desc = "Reserved.";
            sw = rw; hw = r;
            reset = 0x0;
        } reserved_30_6[30:6];
        field {
            name = "para_thd";
            desc = "PARA coefficient update point threshold register. It indicates on which line of the vertical blanking the update point is generated (this control bit is valid only after DFS is enabled).";
            sw = rw; hw = r;
            reset = 0x0;
        } para_thd[5:0];
    } DHD0_PARATHD @ 0xc0b0;
    reg {
        name = "DHD0_START_POS";
        desc = "DHD0_START_POS is the DHD channel start signal start position register. DHD0_START_POS (offset 0xC0C0, total reset 0x0000_0805; PROVEN: Hi3535 data sheet, PDF page 1112, section 5.8).";
        field {
            name = "reserved";
            desc = "Reserved.";
            sw = rw; hw = r;
            reset = 0x0;
        } reserved_31_16[31:16];
        field {
            name = "timing_start_pos";
            desc = "The timing_gen state machine starts working a few lines before the active area.";
            sw = rw; hw = r;
            reset = 0x8;
        } timing_start_pos[15:8];
        field {
            name = "start_pos";
            desc = "In online mode, the start signal is generated on the first few lines of the active area.";
            sw = rw; hw = r;
            reset = 0x5;
        } start_pos[7:0];
    } DHD0_START_POS @ 0xc0c0;
    reg {
        name = "DHD0_STATE";
        desc = "DHD0_STATE is the DHD0 status register. DHD0_STATE (offset 0xC0F0, total reset 0x0000_0006; PROVEN: Hi3535 data sheet, PDF page 1113, section 5.8).";
        field {
            name = "reserved";
            desc = "Reserved.";
            sw = r; hw = w;
            reset = 0x0;
        } reserved_31_24[31:24];
        field {
            name = "count_int";
            desc = "DHD0 interrupt statistics counter. Incremented by 1 each time a vertical timing interrupt is reported.";
            sw = r; hw = w;
            reset = 0x0;
        } count_int[23:16];
        field {
            name = "vcnt";
            desc = "DHD0 display line valid count.";
            sw = r; hw = w;
            reset = 0x0;
        } vcnt[15:3];
        field {
            name = "bottom_field";
            desc = "DHD0 display top/bottom field flag.
- 0: Top field;
- 1: Bottom field.";
            sw = r; hw = w;
            reset = 0x1;
        } bottom_field[2:2];
        field {
            name = "vblank";
            desc = "DHD0 display blanking area indicator.
- 0: Active area.
- 1: Blanking area.";
            sw = r; hw = w;
            reset = 0x1;
        } vblank[1:1];
        field {
            name = "vback_blank";
            desc = "DHD0 display back-blanking flag.
- 0: Not in the back-blanking region;
- 1: In the back-blanking region.";
            sw = r; hw = w;
            reset = 0x0;
        } vback_blank[0:0];
    } DHD0_STATE @ 0xc0f0;
    reg {
        name = "DHD0_DEBUG";
        desc = "DHD0_DEBUG is the DHD DEBUG register. DHD0_DEBUG (offset 0xC0F8, total reset 0x0000_0000; PROVEN: Hi3535 data sheet, PDF page 1114, section 5.8).";
        field {
            name = "reserved";
            desc = "Reserved.";
            sw = r; hw = w;
            reset = 0x0;
        } reserved_31_31[31:31];
        field {
            name = "pix_src";
            desc = "Pixel source read by DHD0 DEBUG.
- 000: BT.1120 8bit;
- 001: DATE YCbCr 10bit;
- 010: HDMI RGB/YCbCr 10bit;
- 011: VGA RGB 10bit;
- 100: LCD RGB 8bit; Others: Reserved.";
            sw = rw; hw = r;
            reset = 0x0;
        } pix_src[30:28];
        field {
            name = "pix_v";
            desc = "Pixel vertical position read by DHD0 DEBUG.";
            sw = rw; hw = r;
            reset = 0x0;
        } pix_v[27:16];
        field {
            name = "pix_h";
            desc = "Horizontal pixel position read by DHD0 DEBUG.";
            sw = rw; hw = r;
            reset = 0x0;
        } pix_h[15:0];
    } DHD0_DEBUG @ 0xc0f8;
    reg {
        name = "DHD0_DEBUG_STATE";
        desc = "DHD0_DEBUG_STATE is the DHD0 DEBUG status register. DHD0_DEBUG_STATE (offset 0xC0FC, total reset 0x0000_0000; PROVEN: Hi3535 data sheet, PDF page 1114, section 5.8).";
        field {
            name = "reserved";
            desc = "Reserved.";
            sw = r; hw = w;
            reset = 0x0;
        } reserved_31_30[31:30];
        field {
            name = "pixel_value";
            desc = "Pixel value read out by DHD0 DEBUG.";
            sw = r; hw = w;
            reset = 0x0;
        } pixel_value[29:0];
    } DHD0_DEBUG_STATE @ 0xc0fc;
    reg {
        name = "INTF_CTRL";
        desc = "INTF_CTRL is the interface processing control register. INTF_CTRL (offset 0xD000, total reset 0x0000_0000; PROVEN: Hi3535 data sheet, PDF page 1115, section 5.8).";
        field {
            name = "hdmi_mode";
            desc = "Output HDMI data color space select. Non-immediate register; valid only for HDMI interface configuration, reserved for other interfaces.
- 0: YUV;
- 1: RGB.";
            sw = rw; hw = r;
            reset = 0x0;
        } hdmi_mode[31:31];
        field {
            name = "reserved";
            desc = "Reserved.";
            sw = r; hw = w;
            reset = 0x0;
        } reserved_30_0[30:0];
    } INTF_CTRL @ 0xd000;
    reg {
        name = "INTF_SYNC_INV";
        desc = "INTF_SYNC_INV is the sync signal polarity configuration register for external sync timing output. This register takes effect immediately after being configured and immediately affects the polarity of the corresponding sync signal. INTF_SYNC_INV (offset 0xD008, total reset 0x0000_0000; PROVEN: Hi3535 data sheet, PDF page 1115, section 5.8).";
        field {
            name = "reserved";
            desc = "Reserved.";
            sw = r; hw = w;
            reset = 0x0;
        } reserved_31_4[31:4];
        field {
            name = "f_inv";
            desc = "Odd/even field indication signal output inversion enable, immediate register.
- 0: Disable;
- 1: Enable.";
            sw = rw; hw = r;
            reset = 0x0;
        } f_inv[3:3];
        field {
            name = "vs_inv";
            desc = "Vertical sync pulse output inversion enable, immediate register.
- 0: Disable;
- 1: Enable.";
            sw = rw; hw = r;
            reset = 0x0;
        } vs_inv[2:2];
        field {
            name = "hs_inv";
            desc = "Horizontal sync pulse output inversion enable, immediate register.
- 0: Disable.
- 1: Enable.";
            sw = rw; hw = r;
            reset = 0x0;
        } hs_inv[1:1];
        field {
            name = "dv_inv";
            desc = "Data valid signal output inversion enable, immediate register.
- 0: Disable;
- 1: Enable.";
            sw = rw; hw = r;
            reset = 0x0;
        } dv_inv[0:0];
    } INTF_SYNC_INV @ 0xd008;
    reg {
        name = "INTF_CLIP0_L";
        desc = "INTF_CLIP0_L is the Clip processing lowest threshold register. It is an immediate register. INTF_CLIP0_L (offset 0xD010, total reset 0x0100_4010; PROVEN: Hi3535 data sheet, PDF page 1116, section 5.8).";
        field {
            name = "reserved";
            desc = "Reserved.";
            sw = r; hw = w;
            reset = 0x0;
        } reserved_31_30[31:30];
        field {
            name = "clip_cl2";
            desc = "Component 2 lower threshold Y/R, unsigned integer.";
            sw = rw; hw = r;
            reset = 0x10;
        } clip_cl2[29:20];
        field {
            name = "clip_cl1";
            desc = "Component 1 lowest threshold Cb/G, unsigned integer.";
            sw = rw; hw = r;
            reset = 0x10;
        } clip_cl1[19:10];
        field {
            name = "clip_cl0";
            desc = "Component 0 lower threshold Cr/B, unsigned integer.";
            sw = rw; hw = r;
            reset = 0x10;
        } clip_cl0[9:0];
    } INTF_CLIP0_L @ 0xd010;
    reg {
        name = "INTF_CLIP0_H";
        desc = "INTF_CLIP0_H is the Clip processing upper threshold register, an immediate register. For example, output data must be clipped for BT.656 standard output. INTF_CLIP0_H (offset 0xD014, total reset 0x0EB3_C0F0; PROVEN: Hi3535 data sheet, PDF page 1117, section 5.8).";
        field {
            name = "reserved";
            desc = "Reserved.";
            sw = r; hw = w;
            reset = 0x0;
        } reserved_31_30[31:30];
        field {
            name = "clip_ch2";
            desc = "Component 2 upper threshold Y/R, unsigned integer.";
            sw = rw; hw = r;
            reset = 0xeb;
        } clip_ch2[29:20];
        field {
            name = "clip_ch1";
            desc = "Component 1 maximum threshold Cb/G, unsigned integer.";
            sw = rw; hw = r;
            reset = 0xf0;
        } clip_ch1[19:10];
        field {
            name = "clip_ch0";
            desc = "Component 0 maximum threshold Cr/B, unsigned integer.";
            sw = rw; hw = r;
            reset = 0xf0;
        } clip_ch0[9:0];
    } INTF_CLIP0_H @ 0xd014;
    reg {
        name = "INTF_CSC_IDC";
        desc = "INTF_CSC_IDC is the color space conversion input DC component register; immediate register. INTF_CSC_IDC (offset 0xD020, total reset 0x0000_0000; PROVEN: Hi3535 data sheet, PDF page 1117, section 5.8).";
        field {
            name = "reserved";
            desc = "Reserved.";
            sw = r; hw = w;
            reset = 0x0;
        } reserved_31_23[31:23];
        field {
            name = "csc_en";
            desc = "CSC enable control signal.
- 0: CSC disabled;
- 1: CSC enabled.";
            sw = rw; hw = r;
            reset = 0x0;
        } csc_en[22:22];
        field {
            name = "cscidc1";
            desc = "Input U/G component DC parameter, MSB is the sign bit. Two's complement representation.";
            sw = rw; hw = r;
            reset = 0x0;
        } cscidc1[21:11];
        field {
            name = "cscidc0";
            desc = "Input V/B component DC parameter, the MSB is the sign bit. Two's complement representation.";
            sw = rw; hw = r;
            reset = 0x0;
        } cscidc0[10:0];
    } INTF_CSC_IDC @ 0xd020;
    reg {
        name = "INTF_CSC_ODC";
        desc = "INTF_CSC_ODC is the color space conversion output DC component register. It is an immediate register. INTF_CSC_ODC (offset 0xD024, total reset 0x0000_0000; PROVEN: Hi3535 data sheet, PDF page 1118, section 5.8).";
        field {
            name = "reserved";
            desc = "Reserved.";
            sw = r; hw = w;
            reset = 0x0;
        } reserved_31_23[31:23];
        field {
            name = "csc_sign_mode";
            desc = "CSC output mode control signal.
- 0: CSC outputs 10-bit unsigned numbers.
- 1: CSC outputs 12-bit signed numbers.";
            sw = rw; hw = r;
            reset = 0x0;
        } csc_sign_mode[22:22];
        field {
            name = "cscodc1";
            desc = "Output U/G component DC parameter, MSB is the sign bit. Two's complement representation.";
            sw = rw; hw = r;
            reset = 0x0;
        } cscodc1[21:11];
        field {
            name = "cscodc0";
            desc = "Output Y/R component DC parameter, MSB is the sign bit. Two's complement representation.";
            sw = rw; hw = r;
            reset = 0x0;
        } cscodc0[10:0];
    } INTF_CSC_ODC @ 0xd024;
    reg {
        name = "INTF_CSC_IODC";
        desc = "INTF_CSC_IODC is the color space conversion input/output DC component register, an immediate register. INTF_CSC_IODC (offset 0xD028, total reset 0x0000_0000; PROVEN: Hi3535 data sheet, PDF page 1118, section 5.8).";
        field {
            name = "reserved";
            desc = "Reserved.";
            sw = r; hw = w;
            reset = 0x0;
        } reserved_31_22[31:22];
        field {
            name = "cscodc2";
            desc = "Output V/B component DC parameter, MSB is the sign bit. Two's complement representation.";
            sw = rw; hw = r;
            reset = 0x0;
        } cscodc2[21:11];
        field {
            name = "cscidc2";
            desc = "Input Y/R component DC parameter; the MSB is the sign bit. Two's complement representation.";
            sw = rw; hw = r;
            reset = 0x0;
        } cscidc2[10:0];
    } INTF_CSC_IODC @ 0xd028;
    reg {
        name = "INTF_CSC_P0";
        desc = "INTF_CSC_P0 is color space conversion parameter 0; immediate register. INTF_CSC_P0 (offset 0xD02C, total reset 0x0000_0000; PROVEN: Hi3535 data sheet, PDF page 1119, section 5.8).";
        field {
            name = "reserved";
            desc = "Reserved.";
            sw = r; hw = w;
            reset = 0x0;
        } reserved_31_31[31:31];
        field {
            name = "cscp01";
            desc = "5.10 data format: 1-bit sign, 4-bit integer part, 10-bit fraction. Two's complement representation.";
            sw = rw; hw = r;
            reset = 0x0;
        } cscp01[30:16];
        field {
            name = "reserved";
            desc = "Reserved.";
            sw = r; hw = w;
            reset = 0x0;
        } reserved_15_15[15:15];
        field {
            name = "cscp00";
            desc = "5.10 data format: 1-bit sign, 4-bit integer part, 10-bit fraction. Two's complement representation.";
            sw = rw; hw = r;
            reset = 0x0;
        } cscp00[14:0];
    } INTF_CSC_P0 @ 0xd02c;
    reg {
        name = "INTF_CSC_P1";
        desc = "INTF_CSC_P1 is color space conversion parameter 1, an immediate register. INTF_CSC_P1 (offset 0xD030, total reset 0x0000_0000; PROVEN: Hi3535 data sheet, PDF page 1119, section 5.10).";
        field {
            name = "reserved";
            desc = "Reserved.";
            sw = r; hw = w;
            reset = 0x0;
        } reserved_31_31[31:31];
        field {
            name = "cscp10";
            desc = "5.10 data format: 1-bit sign, 4-bit integer part, 10-bit fraction. Two's complement representation.";
            sw = rw; hw = r;
            reset = 0x0;
        } cscp10[30:16];
        field {
            name = "reserved";
            desc = "Reserved.";
            sw = r; hw = w;
            reset = 0x0;
        } reserved_15_15[15:15];
        field {
            name = "cscp02";
            desc = "5.10 data format: 1-bit sign, 4-bit integer part, 10-bit fraction. Two's complement representation.";
            sw = rw; hw = r;
            reset = 0x0;
        } cscp02[14:0];
    } INTF_CSC_P1 @ 0xd030;
    reg {
        name = "INTF_CSC_P2";
        desc = "INTF_CSC_P2 is color space conversion parameter 2, an immediate register. INTF_CSC_P2 (offset 0xD034, total reset 0x0000_0000; PROVEN: Hi3535 data sheet, PDF page 1120, section 5.10).";
        field {
            name = "reserved";
            desc = "Reserved.";
            sw = r; hw = w;
            reset = 0x0;
        } reserved_31_31[31:31];
        field {
            name = "cscp12";
            desc = "5.10 data format: 1-bit sign, 4-bit integer part, 10-bit fraction. Two's complement representation.";
            sw = rw; hw = r;
            reset = 0x0;
        } cscp12[30:16];
        field {
            name = "reserved";
            desc = "Reserved.";
            sw = r; hw = w;
            reset = 0x0;
        } reserved_15_15[15:15];
        field {
            name = "cscp11";
            desc = "5.10 data format: 1-bit sign, 4-bit integer part, 10-bit fraction. Two's complement representation.";
            sw = rw; hw = r;
            reset = 0x0;
        } cscp11[14:0];
    } INTF_CSC_P2 @ 0xd034;
    reg {
        name = "INTF_CSC_P3";
        desc = "INTF_CSC_P3 is color space conversion parameter 3; immediate register. INTF_CSC_P3 (offset 0xD038, total reset 0x0000_0000; PROVEN: Hi3535 data sheet, PDF page 1120, section 5.10).";
        field {
            name = "reserved";
            desc = "Reserved.";
            sw = r; hw = w;
            reset = 0x0;
        } reserved_31_31[31:31];
        field {
            name = "cscp21";
            desc = "5.10 data format: 1-bit sign, 4-bit integer part, 10-bit fraction. Two's complement representation.";
            sw = rw; hw = r;
            reset = 0x0;
        } cscp21[30:16];
        field {
            name = "reserved";
            desc = "Reserved.";
            sw = r; hw = w;
            reset = 0x0;
        } reserved_15_15[15:15];
        field {
            name = "cscp20";
            desc = "5.10 data format: 1-bit sign, 4-bit integer part, 10-bit fraction. Two's complement representation.";
            sw = rw; hw = r;
            reset = 0x0;
        } cscp20[14:0];
    } INTF_CSC_P3 @ 0xd038;
    reg {
        name = "INTF_CSC_P4";
        desc = "INTF_CSC_P4 is color space conversion parameter 4. It is an immediate register. INTF_CSC_P4 (offset 0xD03C, total reset 0x0000_0000; PROVEN: Hi3535 data sheet, PDF page 1121, section 5.10).";
        field {
            name = "reserved";
            desc = "Reserved.";
            sw = r; hw = w;
            reset = 0x0;
        } reserved_31_15[31:15];
        field {
            name = "cscp22";
            desc = "5.10 data format: 1-bit sign, 4-bit integer part, 10-bit fraction. Two's complement representation.";
            sw = rw; hw = r;
            reset = 0x0;
        } cscp22[14:0];
    } INTF_CSC_P4 @ 0xd03c;
    reg {
        name = "INTF_HSPCFG0";
        desc = "INTF_HSPCFG0 is H sharpen configuration register 0, an immediate register. INTF_HSPCFG0 (offset 0xD040, total reset 0x0000_0000; PROVEN: Hi3535 data sheet, PDF page 1121, section 5.10).";
        field {
            name = "hsp_hf0_tmp3";
            desc = "High-frequency filter coefficient 3, signed.";
            sw = rw; hw = r;
            reset = 0x0;
        } hsp_hf0_tmp3[31:24];
        field {
            name = "hsp_hf0_tmp2";
            desc = "High-frequency filter coefficient 2, signed.";
            sw = rw; hw = r;
            reset = 0x0;
        } hsp_hf0_tmp2[23:16];
        field {
            name = "hsp_hf0_tmp1";
            desc = "High-frequency filter coefficient 1, signed.";
            sw = rw; hw = r;
            reset = 0x0;
        } hsp_hf0_tmp1[15:8];
        field {
            name = "hsp_hf0_tmp0";
            desc = "High-frequency filter coefficient 0, signed.";
            sw = rw; hw = r;
            reset = 0x0;
        } hsp_hf0_tmp0[7:0];
    } INTF_HSPCFG0 @ 0xd040;
    reg {
        name = "INTF_HSPCFG1";
        desc = "INTF_HSPCFG1 is H sharpen configuration register 1, an immediate register. INTF_HSPCFG1 (offset 0xD044, total reset 0x0000_0000; PROVEN: Hi3535 data sheet, PDF page 1122, section 5.10).";
        field {
            name = "hsp_en";
            desc = "Horizontal sharpen enable.";
            sw = rw; hw = r;
            reset = 0x0;
        } hsp_en[31:31];
        field {
            name = "reserved";
            desc = "Reserved.";
            sw = r; hw = w;
            reset = 0x0;
        } reserved_30_8[30:8];
        field {
            name = "hsp_hf0_coring";
            desc = "High-frequency coring coefficient, unsigned.";
            sw = rw; hw = r;
            reset = 0x0;
        } hsp_hf0_coring[7:0];
    } INTF_HSPCFG1 @ 0xd044;
    reg {
        name = "INTF_HSPCFG5";
        desc = "INTF_HSPCFG5 is H sharpen configuration register 5; immediate register. INTF_HSPCFG5 (offset 0xD054, total reset 0x0000_0000; PROVEN: Hi3535 data sheet, PDF page 1122, section 5.10).";
        field {
            name = "reserved";
            desc = "Reserved.";
            sw = r; hw = w;
            reset = 0x0;
        } reserved_31_27[31:27];
        field {
            name = "hsp_hf0_gainneg";
            desc = "High-frequency gain negative polarity coefficient, signed (10.8).";
            sw = rw; hw = r;
            reset = 0x0;
        } hsp_hf0_gainneg[26:16];
        field {
            name = "reserved";
            desc = "Reserved.";
            sw = r; hw = w;
            reset = 0x0;
        } reserved_15_11[15:11];
        field {
            name = "hsp_hf0_gainpos";
            desc = "High-frequency gain positive polarity coefficient, signed (10.8).";
            sw = rw; hw = r;
            reset = 0x0;
        } hsp_hf0_gainpos[10:0];
    } INTF_HSPCFG5 @ 0xd054;
    reg {
        name = "INTF_HSPCFG6";
        desc = "INTF_HSPCFG6 is H sharpen configuration register 6. It is an immediate register. INTF_HSPCFG6 (offset 0xD058, total reset 0x0000_0000; PROVEN: Hi3535 data sheet, PDF page 1123, section 5.10).";
        field {
            name = "hsp_hf0_adpshoot_en";
            desc = "High-frequency adjustment threshold enable.";
            sw = rw; hw = r;
            reset = 0x0;
        } hsp_hf0_adpshoot_en[31:31];
        field {
            name = "hsp_hf0_winsize";
            desc = "High-frequency window size, unsigned, range 0 to 4.";
            sw = rw; hw = r;
            reset = 0x0;
        } hsp_hf0_winsize[30:28];
        field {
            name = "reserved";
            desc = "Reserved.";
            sw = r; hw = w;
            reset = 0x0;
        } reserved_27_24[27:24];
        field {
            name = "hsp_hf0_mixratio";
            desc = "High-frequency adjustment threshold ratio, unsigned (8.7).";
            sw = rw; hw = r;
            reset = 0x0;
        } hsp_hf0_mixratio[23:16];
        field {
            name = "hsp_hf0_underth";
            desc = "High-frequency adjustment under threshold, unsigned.";
            sw = rw; hw = r;
            reset = 0x0;
        } hsp_hf0_underth[15:8];
        field {
            name = "hsp_hf0_overth";
            desc = "High-frequency adjustment over threshold, unsigned.";
            sw = rw; hw = r;
            reset = 0x0;
        } hsp_hf0_overth[7:0];
    } INTF_HSPCFG6 @ 0xd058;
    reg {
        name = "INTF_HSPCFG7";
        desc = "INTF_HSPCFG7 is H sharpen configuration register 7, an immediate register. INTF_HSPCFG7 (offset 0xD05C, total reset 0x0000_0000; PROVEN: Hi3535 data sheet, PDF page 1123, section 5.10).";
        field {
            name = "hsp_hf1_tmp3";
            desc = "High-frequency filter coefficient 3, signed.";
            sw = rw; hw = r;
            reset = 0x0;
        } hsp_hf1_tmp3[31:24];
        field {
            name = "hsp_hf1_tmp2";
            desc = "High-frequency filter coefficient 2, signed.";
            sw = rw; hw = r;
            reset = 0x0;
        } hsp_hf1_tmp2[23:16];
        field {
            name = "hsp_hf1_tmp1";
            desc = "High-frequency filter coefficient 1, signed.";
            sw = rw; hw = r;
            reset = 0x0;
        } hsp_hf1_tmp1[15:8];
        field {
            name = "hsp_hf1_tmp0";
            desc = "High-frequency filter coefficient 0, signed.";
            sw = rw; hw = r;
            reset = 0x0;
        } hsp_hf1_tmp0[7:0];
    } INTF_HSPCFG7 @ 0xd05c;
    reg {
        name = "INTF_HSPCFG8";
        desc = "INTF_HSPCFG8 is H sharpen configuration register 8, an immediate register. INTF_HSPCFG8 (offset 0xD060, total reset 0x0000_0000; PROVEN: Hi3535 data sheet, PDF page 1124, section 5.10).";
        field {
            name = "reserved";
            desc = "Reserved.";
            sw = r; hw = w;
            reset = 0x0;
        } reserved_31_8[31:8];
        field {
            name = "hsp_hf1_coring";
            desc = "High-frequency coring coefficient, unsigned";
            sw = rw; hw = r;
            reset = 0x0;
        } hsp_hf1_coring[7:0];
    } INTF_HSPCFG8 @ 0xd060;
    reg {
        name = "INTF_HSPCFG12";
        desc = "INTF_HSPCFG12 is H sharpen configuration register 12; immediate register. INTF_HSPCFG12 (offset 0xD070, total reset 0x0000_0000; PROVEN: Hi3535 data sheet, PDF page 1124, section 5.10).";
        field {
            name = "reserved";
            desc = "Reserved.";
            sw = r; hw = w;
            reset = 0x0;
        } reserved_31_27[31:27];
        field {
            name = "hsp_hf1_gainneg";
            desc = "High-frequency gain negative polarity coefficient, signed (10.8)";
            sw = rw; hw = r;
            reset = 0x0;
        } hsp_hf1_gainneg[26:16];
        field {
            name = "reserved";
            desc = "Reserved.";
            sw = r; hw = w;
            reset = 0x0;
        } reserved_15_11[15:11];
        field {
            name = "hsp_hf1_gainpos";
            desc = "High-frequency gain positive polarity coefficient, signed (10.8)";
            sw = rw; hw = r;
            reset = 0x0;
        } hsp_hf1_gainpos[10:0];
    } INTF_HSPCFG12 @ 0xd070;
    reg {
        name = "INTF_HSPCFG13";
        desc = "INTF_HSPCFG13 is H sharpen configuration register 13. It is an immediate register. INTF_HSPCFG13 (offset 0xD074, total reset 0x0000_0000; PROVEN: Hi3535 data sheet, PDF page 1125, section 5.10).";
        field {
            name = "hsp_hf1_adpshoot_en";
            desc = "High-frequency adjustment threshold enable";
            sw = rw; hw = r;
            reset = 0x0;
        } hsp_hf1_adpshoot_en[31:31];
        field {
            name = "hsp_hf1_winsize";
            desc = "High-frequency window size, unsigned, value range 0-4.";
            sw = rw; hw = r;
            reset = 0x0;
        } hsp_hf1_winsize[30:28];
        field {
            name = "reserved";
            desc = "Reserved.";
            sw = r; hw = w;
            reset = 0x0;
        } reserved_27_24[27:24];
        field {
            name = "hsp_hf1_mixratio";
            desc = "High-frequency adjustment threshold ratio, unsigned (8.7)";
            sw = rw; hw = r;
            reset = 0x0;
        } hsp_hf1_mixratio[23:16];
        field {
            name = "hsp_hf1_underth";
            desc = "High-frequency adjustment under threshold, unsigned";
            sw = rw; hw = r;
            reset = 0x0;
        } hsp_hf1_underth[15:8];
        field {
            name = "hsp_hf1_overth";
            desc = "High-frequency adjustment over threshold, unsigned";
            sw = rw; hw = r;
            reset = 0x0;
        } hsp_hf1_overth[7:0];
    } INTF_HSPCFG13 @ 0xd074;
    reg {
        name = "INTF_HSPCFG14";
        desc = "INTF_HSPCFG14 is H sharpen configuration register 14, an immediate register. INTF_HSPCFG14 (offset 0xD078, total reset 0x0000_0000; PROVEN: Hi3535 data sheet, PDF page 1126, section 5.10).";
        field {
            name = "hsp_h0_en";
            desc = "High-frequency filter 0 enable.";
            sw = rw; hw = r;
            reset = 0x0;
        } hsp_h0_en[31:31];
        field {
            name = "hsp_h1_en";
            desc = "High-frequency filter 1 enable.";
            sw = rw; hw = r;
            reset = 0x0;
        } hsp_h1_en[30:30];
        field {
            name = "hsp_ltih_en";
            desc = "Horizontal LTI enable.";
            sw = rw; hw = r;
            reset = 0x0;
        } hsp_ltih_en[29:29];
        field {
            name = "hsp_ctih_en";
            desc = "Horizontal CTI enable.";
            sw = rw; hw = r;
            reset = 0x0;
        } hsp_ctih_en[28:28];
        field {
            name = "reserved";
            desc = "Reserved.";
            sw = r; hw = w;
            reset = 0x0;
        } reserved_27_27[27:27];
        field {
            name = "hsp_hf_shootdiv";
            desc = "High-frequency adjustment shift coefficient, unsigned, range 1-7.";
            sw = rw; hw = r;
            reset = 0x0;
        } hsp_hf_shootdiv[26:24];
        field {
            name = "hsp_lti_ratio";
            desc = "Luma enhancement ratio, unsigned (8.7).";
            sw = rw; hw = r;
            reset = 0x0;
        } hsp_lti_ratio[23:16];
        field {
            name = "hsp_ldti_gain";
            desc = "Luma enhancement gain coefficient, unsigned (8.5).";
            sw = rw; hw = r;
            reset = 0x0;
        } hsp_ldti_gain[15:8];
        field {
            name = "hsp_cdti_gain";
            desc = "Chroma enhancement gain coefficient, unsigned (8.5).";
            sw = rw; hw = r;
            reset = 0x0;
        } hsp_cdti_gain[7:0];
    } INTF_HSPCFG14 @ 0xd078;
    reg {
        name = "INTF_HSPCFG15";
        desc = "INTF_HSPCFG15 is H sharpen configuration register 15, an immediate register. INTF_HSPCFG15 (offset 0xD07C, total reset 0x0000_0000; PROVEN: Hi3535 data sheet, PDF page 1127, section 5.10).";
        field {
            name = "reserved";
            desc = "Reserved.";
            sw = r; hw = w;
            reset = 0x0;
        } reserved_31_28[31:28];
        field {
            name = "hsp_peak_ratio";
            desc = "Luma enhancement ratio, unsigned (8.7).";
            sw = rw; hw = r;
            reset = 0x0;
        } hsp_peak_ratio[27:20];
        field {
            name = "reserved";
            desc = "Reserved.";
            sw = r; hw = w;
            reset = 0x0;
        } reserved_19_19[19:19];
        field {
            name = "hsp_glb_overth";
            desc = "Luma enhancement global high threshold, unsigned.";
            sw = rw; hw = r;
            reset = 0x0;
        } hsp_glb_overth[18:10];
        field {
            name = "reserved";
            desc = "Reserved.";
            sw = r; hw = w;
            reset = 0x0;
        } reserved_9_9[9:9];
        field {
            name = "hsp_glb_underth";
            desc = "Luma enhancement global low threshold, unsigned.";
            sw = rw; hw = r;
            reset = 0x0;
        } hsp_glb_underth[8:0];
    } INTF_HSPCFG15 @ 0xd07c;
    reg {
        name = "INTF_DITHER0_CTRL";
        desc = "INTF_DITHER0_CTRL is the interface processing Dither control register. INTF_DITHER0_CTRL (offset 0xD080, total reset 0x2000_0000; PROVEN: Hi3535 data sheet, PDF page 1127, section 5.10).";
        field {
            name = "dither_md";
            desc = "Dither mode select register.
- 000: 12-bit input, 10-bit output, no dither, direct truncation;
- 001: 12-bit input, 10-bit output, temporal dither;
- 010: 12-bit input, 10-bit output, spatial dither;
- 011: 12-bit input, 8-bit output, temporal and spatial dither;
- 100: 12-bit input, 10-bit output, rounding;
- 101: 12-bit input, 8-bit output, rounding.";
            sw = rw; hw = r;
            reset = 0x1;
        } dither_md[31:29];
        field {
            name = "reserved";
            desc = "Reserved.";
            sw = r; hw = w;
            reset = 0x0;
        } reserved_28_0[28:0];
    } INTF_DITHER0_CTRL @ 0xd080;
    reg {
        name = "INTF_DITHER0_COEF0";
        desc = "INTF_DITHER0_COEF0 is the interface processing Dither coefficient 0 register. INTF_DITHER0_COEF0 (offset 0xD084, total reset 0xDD66_4400; PROVEN: Hi3535 data sheet, PDF page 1128, section 5.10).";
        field {
            name = "dither_coef3";
            desc = "Coefficient 3 used by temporal-mode Dither.";
            sw = rw; hw = r;
            reset = 0xdd;
        } dither_coef3[31:24];
        field {
            name = "dither_coef2";
            desc = "Coefficient 2 used by temporal-mode Dither.";
            sw = rw; hw = r;
            reset = 0x66;
        } dither_coef2[23:16];
        field {
            name = "dither_coef1";
            desc = "Coefficient 1 used by temporal-mode Dither.";
            sw = rw; hw = r;
            reset = 0x44;
        } dither_coef1[15:8];
        field {
            name = "dither_coef0";
            desc = "Coefficient 0 used by temporal-mode Dither.";
            sw = rw; hw = r;
            reset = 0x0;
        } dither_coef0[7:0];
    } INTF_DITHER0_COEF0 @ 0xd084;
    reg {
        name = "INTF_DITHER0_COEF1";
        desc = "INTF_DITHER0_COEF1 is interface processing Dither coefficient 1 register. INTF_DITHER0_COEF1 (offset 0xD088, total reset 0xDD66_4400; PROVEN: Hi3535 data sheet, PDF page 1128, section 5.10).";
        field {
            name = "dither_coef7";
            desc = "Coefficient 7 used by temporal-mode Dither.";
            sw = rw; hw = r;
            reset = 0xdd;
        } dither_coef7[31:24];
        field {
            name = "dither_coef6";
            desc = "Coefficient 6 used by temporal-mode Dither.";
            sw = rw; hw = r;
            reset = 0x66;
        } dither_coef6[23:16];
        field {
            name = "dither_coef5";
            desc = "Coefficient 5 used by temporal-mode Dither.";
            sw = rw; hw = r;
            reset = 0x44;
        } dither_coef5[15:8];
        field {
            name = "dither_coef4";
            desc = "Coefficient 4 used by temporal-mode Dither.";
            sw = rw; hw = r;
            reset = 0x0;
        } dither_coef4[7:0];
    } INTF_DITHER0_COEF1 @ 0xd088;
    reg {
        name = "DATE_COEFF0";
        desc = "DATE_COEFF0 is the video standard parameter configuration register. DATE_COEFF0 (offset 0xF200, total reset 0x5284_14FC; PROVEN: Hi3535 data sheet, PDF page 1129, section 5.10).";
        field {
            name = "clpf_sel";
            desc = "Chroma low-pass filter bandwidth selection.
- 00: 1.1MHz bandwidth (NTSC);
- 01: 1.3MHz bandwidth (PAL);
- 10: 1.6MHz bandwidth (test);
- 11: Reserved.";
            sw = rw; hw = r;
            reset = 0x1;
        } clpf_sel[31:30];
        field {
            name = "dis_ire";
            desc = "For the (M)NTSC and (M,N)PAL standards, the black level is 7.5IRE above the blanking level; for other standards, the black level equals the blanking level. This bit controls whether the black level should be 7.5IRE above the blanking level.
- 0: The black level is 7.5IRE above the blanking level.
- 1: The black level equals the blanking level.";
            sw = rw; hw = r;
            reset = 0x0;
        } dis_ire[29:29];
        field {
            name = "reserved";
            desc = "Reserved.";
            sw = r; hw = w;
            reset = 0x1;
        } reserved_28_28[28:28];
        field {
            name = "pal_half_en";
            desc = "PAL half-line reduction enable.
- 0: Disable;
- 1: Enable.";
            sw = rw; hw = r;
            reset = 0x0;
        } pal_half_en[27:27];
        field {
            name = "pbpr_lpf_en";
            desc = "Component chroma low-pass filter enable.
- 0: Disable;
- 1: Enable.";
            sw = rw; hw = r;
            reset = 0x0;
        } pbpr_lpf_en[26:26];
        field {
            name = "scanline";
            desc = "Set according to the number of scan lines per frame in the different standards. For (M)NTSC, NTSC-J and (M)PAL, each frame contains 525 lines; for (B, D, J, H, I)PAL, (N)PAL and (Nc)PAL, each frame contains 625 lines.
- 0: 525 lines per frame;
- 1: 625 lines per frame.";
            sw = rw; hw = r;
            reset = 0x1;
        } scanline[25:25];
        field {
            name = "rgb_en";
            desc = "When intf_sel is configured as 100, this bit selects whether the component signal uses RGB or YPbPr.
- 0: The component signal uses YPbPr;
- 1: The component signal uses RGB.";
            sw = rw; hw = r;
            reset = 0x0;
        } rgb_en[24:24];
        field {
            name = "vbi_lpf_en";
            desc = "Vbi data low-pass filter enable control.
- 0: No filtering;
- 1: Filtering.";
            sw = rw; hw = r;
            reset = 0x1;
        } vbi_lpf_en[23:23];
        field {
            name = "fm_sel";
            desc = "FMsecam frequency modulation selection.
- 0: secam frequency modulation uses sin;
- 1: secam frequency modulation uses cos.";
            sw = rw; hw = r;
            reset = 0x0;
        } fm_sel[22:22];
        field {
            name = "style_sel";
            desc = "Used together with scanline to set the standard of the CVBS/S-Video output signal. When scanline is 0, that is, each frame contains 525 lines, the meanings are as follows:
- 0001: (M)NTSC standard.
- 0010: NTSC-J standard.
- 0100: (M)PAL standard. When scanline is 1, that is, each frame contains 625 lines, the meanings are as follows:
- 0001: (B, D, G, H, I)PAL standard.
- 0010: (N)PAL standard.
- 0100: (Nc)PAL standard.
- 1000: SECAM standard.";
            sw = rw; hw = r;
            reset = 0x1;
        } style_sel[21:18];
        field {
            name = "sync_mode_sel";
            desc = "The high bit specifies whether the component output must include the sync signal on all three channels; this control bit takes effect only when sync_mode_scart is configured to 0. The high bit is valid only when intf_sel is set to 100, that is, with component output, with the following meaning:
- 0: For component output, only one channel includes the sync signal;
- 1: For component output, all three channels include the sync signal. When this bit is set to 0, the sync channel can only be the Y channel for YPbPr output, and only the G channel for RGB output. The low bit specifies whether the RGB output has a blanking pedestal. The low bit is valid only when intf_sel is set to 100 and rgb_en is set to 1, with the following meaning:
- 0: No blanking pedestal for RGB output;
- 1: Blanking pedestal for RGB output.";
            sw = rw; hw = r;
            reset = 0x0;
        } sync_mode_sel[17:16];
        field {
            name = "sync_mode_scart";
            desc = "This bit indicates that none of the 3 component channels has sync superimposed.
- 0: The component sync output follows the sync_mode_sel[1] configuration.
- 1: None of the 3 component channels has sync superimposed; in this case sync_mode_sel[1] must be configured as 0.";
            sw = rw; hw = r;
            reset = 0x0;
        } sync_mode_scart[15:15];
        field {
            name = "length_sel";
            desc = "Specifies the active line width, in pixels, of each video line.
- 0: Output with the active line pixel width of BT.601 mode;
- 1: Output with the active line pixel width of BT.470 mode. When this bit is 0, the active line width is 720 pixels. When this bit is 1, the active line width is 704 pixels for the 625-line standard and 712 pixels for the 525-line standard. The current version does not support dynamic switching between BT601 mode and BT470 mode; configure it as needed after reset and do not change the configuration afterward. A fixed BT601 configuration, that is, the power-on reset value, is recommended.";
            sw = rw; hw = r;
            reset = 0x0;
        } length_sel[14:14];
        field {
            name = "agc_amp_sel";
            desc = "- 0: Generate the AGC pulse using the on-chip default value (recommended);
- 1: Generate the AGC pulse using the off-chip configuration.

DATE_COEFF1[amp_outside].";
            sw = rw; hw = r;
            reset = 0x0;
        } agc_amp_sel[13:13];
        field {
            name = "luma_dl";
            desc = "Shift of the chroma signal ahead of or behind the luma signal, in units of half a pixel width. The most significant bit indicates the direction of the chroma shift relative to luma.
- 0: The chroma signal lags the luma signal.
- 1: The chroma signal leads the chroma signal. The low 3 bits indicate the absolute value of the chroma shift relative to luma, in binary, ranging from 0 to 7.
- 000: Chroma is aligned with luma, no adjustment. 001 to 111: The chroma signal leads or lags the luma signal by 1 to 7 units.";
            sw = rw; hw = r;
            reset = 0xa;
        } luma_dl[12:9];
        field {
            name = "reserved";
            desc = "Reserved. Writes have no effect; reads return 0.";
            sw = r; hw = w;
            reset = 0x0;
        } reserved_8_8[8:8];
        field {
            name = "oversam_en";
            desc = "First-stage oversampling switch control bits, including the luma oversampling switch control bit and the chroma oversampling switch control bit. The high bit is the luma oversampling switch control bit.
- 0: Luma oversampling off;
- 1: Luma oversampling on. The low bit is the chroma oversampling switch control bit.
- 0: Chroma oversampling off;
- 1: Chroma oversampling on.";
            sw = rw; hw = r;
            reset = 0x3;
        } oversam_en[7:6];
        field {
            name = "lunt_en";
            desc = "Luma notch function switch control bit.
- 0: Luma notch function off;
- 1: Luma notch function on.";
            sw = rw; hw = r;
            reset = 0x1;
        } lunt_en[5:5];
        field {
            name = "oversam2_en";
            desc = "Second-stage oversampling switch control bit, controlling both the luma path and the chroma path.
- 0: Luma oversampling off;
- 1: Luma oversampling on.";
            sw = rw; hw = r;
            reset = 0x1;
        } oversam2_en[4:4];
        field {
            name = "chlp_en";
            desc = "Chroma low-pass filter function switch control bit.
- 0: Chroma low-pass filter off.
- 1: Chroma low-pass filter on.";
            sw = rw; hw = r;
            reset = 0x1;
        } chlp_en[3:3];
        field {
            name = "sylp_en";
            desc = "Sync low-pass filter function switch control bit.
- 0: Sync low-pass filter function off;
- 1: Sync low-pass filter function on.";
            sw = rw; hw = r;
            reset = 0x1;
        } sylp_en[2:2];
        field {
            name = "chgain_en";
            desc = "Chrominance gain switch control bit.
- 0: Chrominance gain off.
- 1: Chrominance gain on.";
            sw = rw; hw = r;
            reset = 0x0;
        } chgain_en[1:1];
        field {
            name = "tt_seq";
            desc = "Configures the transmission order of the bits in a Teletext data byte.
- 0: From the most significant bit to the least significant bit;
- 1: From the least significant bit to the most significant bit.";
            sw = rw; hw = r;
            reset = 0x0;
        } tt_seq[0:0];
    } DATE_COEFF0 @ 0xf200;
    reg {
        name = "DATE_COEFF1";
        desc = "DATE_COEFF1 is the amplitude configuration register. DATE_COEFF1 (offset 0xF204, total reset 0x0000_0000; PROVEN: Hi3535 data sheet, PDF page 1132, section 5.10).";
        field {
            name = "c_gain";
            desc = "Color burst gain amplitude adjustment.";
            sw = rw; hw = r;
            reset = 0x0;
        } c_gain[31:29];
        field {
            name = "cvbs_limit_en";
            desc = "CVBS limiting switch control bit.
- 0: No limiting.
- 1: Limiting.";
            sw = rw; hw = r;
            reset = 0x0;
        } cvbs_limit_en[28:28];
        field {
            name = "wss_seq";
            desc = "Configures the transmit order of the bits in the WSS data byte.
- 0: From MSB to LSB;
- 1: From LSB to MSB.";
            sw = rw; hw = r;
            reset = 0x0;
        } wss_seq[27:27];
        field {
            name = "vps_seq";
            desc = "Configures the transmit order of the bits in the VPS data bytes.
- 0: From high bit to low bit.
- 1: From low bit to high bit.";
            sw = rw; hw = r;
            reset = 0x0;
        } vps_seq[26:26];
        field {
            name = "cgms_seq";
            desc = "Configures the transmission order of the bits in the CGMS data bytes.
- 0: From the high bit to the low bit;
- 1: From the low bit to the high bit.";
            sw = rw; hw = r;
            reset = 0x0;
        } cgms_seq[25:25];
        field {
            name = "cc_seq";
            desc = "Configures the transmit order of the bits within a Closed Caption data byte.
- 0: From high bit to low bit.
- 1: From low bit to high bit.";
            sw = rw; hw = r;
            reset = 0x0;
        } cc_seq[24:24];
        field {
            name = "c_limit_en";
            desc = "Chroma limiting switch control bit.
- 0: No limiting.
- 1: Limiting.";
            sw = rw; hw = r;
            reset = 0x0;
        } c_limit_en[23:23];
        field {
            name = "amp_outside";
            desc = "External AGC pulse amplitude input.";
            sw = rw; hw = r;
            reset = 0x0;
        } amp_outside[22:13];
        field {
            name = "date_test_en";
            desc = "Test valid signal.";
            sw = rw; hw = r;
            reset = 0x0;
        } date_test_en[12:12];
        field {
            name = "date_test_mode";
            desc = "Test mode signal.";
            sw = rw; hw = r;
            reset = 0x0;
        } date_test_mode[11:10];
        field {
            name = "dac_test";
            desc = "DAC test value input.";
            sw = rw; hw = r;
            reset = 0x0;
        } dac_test[9:0];
    } DATE_COEFF1 @ 0xf204;
    reg {
        name = "DATE_COEFF2";
        desc = "DATE_COEFF2 is DATE coefficient 2 register. DATE_COEFF2 (offset 0xF208, total reset 0x0000_0000; PROVEN: Hi3535 data sheet, PDF page 1133, section 5.10).";
        field {
            name = "coef02";
            desc = "DATE coefficient 2 register.";
            sw = rw; hw = r;
            reset = 0x0;
        } coef02[31:0];
    } DATE_COEFF2 @ 0xf208;
    reg {
        name = "DATE_COEFF3";
        desc = "DATE_COEFF3 is DATE coefficient 3 register. DATE_COEFF3 (offset 0xF20C, total reset 0x0000_0000; PROVEN: Hi3535 data sheet, PDF page 1134, section 5.10).";
        field {
            name = "reserved";
            desc = "Reserved.";
            sw = r; hw = w;
            reset = 0x0;
        } reserved_31_26[31:26];
        field {
            name = "coef03";
            desc = "DATE coefficient 3 register.";
            sw = rw; hw = r;
            reset = 0x0;
        } coef03[25:0];
    } DATE_COEFF3 @ 0xf20c;
    reg {
        name = "DATE_COEFF4";
        desc = "DATE_COEFF4 is DATE coefficient 4 register. DATE_COEFF4 (offset 0xF210, total reset 0x0000_0000; PROVEN: Hi3535 data sheet, PDF page 1134, section 5.10).";
        field {
            name = "reserved";
            desc = "Reserved.";
            sw = r; hw = w;
            reset = 0x0;
        } reserved_31_30[31:30];
        field {
            name = "coef04";
            desc = "DATE coefficient 4 register.";
            sw = rw; hw = r;
            reset = 0x0;
        } coef04[29:0];
    } DATE_COEFF4 @ 0xf210;
    reg {
        name = "DATE_COEFF5";
        desc = "DATE_COEFF5 is the DATE coefficient 5 register. DATE_COEFF5 (offset 0xF214, total reset 0x0000_0000; PROVEN: Hi3535 data sheet, PDF page 1135, section 5.10).";
        field {
            name = "reserved";
            desc = "Reserved.";
            sw = r; hw = w;
            reset = 0x0;
        } reserved_31_29[31:29];
        field {
            name = "coef05";
            desc = "DATE coefficient 5 register.";
            sw = rw; hw = r;
            reset = 0x0;
        } coef05[28:0];
    } DATE_COEFF5 @ 0xf214;
    reg {
        name = "DATE_COEFF6";
        desc = "DATE_COEFF6 is DATE coefficient 6 register. DATE_COEFF6 (offset 0xF218, total reset 0x8000_0000; PROVEN: Hi3535 data sheet, PDF page 1135, section 5.10).";
        field {
            name = "coef06_0";
            desc = "DATE coefficient 6 register 0.";
            sw = rw; hw = r;
            reset = 0x1;
        } coef06_0[31:31];
        field {
            name = "reserved";
            desc = "Reserved.";
            sw = r; hw = w;
            reset = 0x0;
        } reserved_30_23[30:23];
        field {
            name = "coef06_1";
            desc = "DATE coefficient 6 register 1.";
            sw = rw; hw = r;
            reset = 0x0;
        } coef06_1[22:0];
    } DATE_COEFF6 @ 0xf218;
    reg {
        name = "DATE_COEFF7";
        desc = "DATE_COEFF7 is the Teletext configuration register. DATE_COEFF7 (offset 0xF21C, total reset 0x0000_0000; PROVEN: Hi3535 data sheet, PDF page 1136, section 5.10).";
        field {
            name = "tt22_enf1";
            desc = "Teletext switch control bit for line 22 of the odd field.
- 0: Off;
- 1: On.";
            sw = rw; hw = r;
            reset = 0x0;
        } tt22_enf1[31:31];
        field {
            name = "tt21_enf1";
            desc = "Teletext switch control bit for line 21 of the odd field.
- 0: Off.
- 1: On.";
            sw = rw; hw = r;
            reset = 0x0;
        } tt21_enf1[30:30];
        field {
            name = "tt20_enf1";
            desc = "Teletext switch control bit for line 20 of the odd field.
- 0: Off;
- 1: On.";
            sw = rw; hw = r;
            reset = 0x0;
        } tt20_enf1[29:29];
        field {
            name = "tt19_enf1";
            desc = "Teletext switch control bit for line 19 of the odd field.
- 0: Off;
- 1: On.";
            sw = rw; hw = r;
            reset = 0x0;
        } tt19_enf1[28:28];
        field {
            name = "tt18_enf1";
            desc = "Teletext switch control bit for line 18 of the odd field.
- 0: Off.
- 1: On.";
            sw = rw; hw = r;
            reset = 0x0;
        } tt18_enf1[27:27];
        field {
            name = "tt17_enf1";
            desc = "Teletext enable control bit for line 17 of the odd field.
- 0: Off;
- 1: On.";
            sw = rw; hw = r;
            reset = 0x0;
        } tt17_enf1[26:26];
        field {
            name = "tt16_enf1";
            desc = "Teletext switch control bit for line 16 of the odd field.
- 0: Off;
- 1: On.";
            sw = rw; hw = r;
            reset = 0x0;
        } tt16_enf1[25:25];
        field {
            name = "tt15_enf1";
            desc = "Teletext switch control bit for line 15 of the odd field.
- 0: Off.
- 1: On.";
            sw = rw; hw = r;
            reset = 0x0;
        } tt15_enf1[24:24];
        field {
            name = "tt14_enf1";
            desc = "Teletext switch control bit for line 14 of the odd field.
- 0: Off;
- 1: On.";
            sw = rw; hw = r;
            reset = 0x0;
        } tt14_enf1[23:23];
        field {
            name = "tt13_enf1";
            desc = "Teletext switch control bit for line 13 of the odd field.
- 0: Off;
- 1: On.";
            sw = rw; hw = r;
            reset = 0x0;
        } tt13_enf1[22:22];
        field {
            name = "tt12_enf1";
            desc = "Teletext enable control bit for line 12 of the odd field.
- 0: Off;
- 1: On.";
            sw = rw; hw = r;
            reset = 0x0;
        } tt12_enf1[21:21];
        field {
            name = "tt11_enf1";
            desc = "Teletext switch control bit for line 11 of the odd field.
- 0: Off;
- 1: On.";
            sw = rw; hw = r;
            reset = 0x0;
        } tt11_enf1[20:20];
        field {
            name = "tt10_enf1";
            desc = "Teletext switch control bit for line 10 of the odd field.
- 0: Off.
- 1: On.";
            sw = rw; hw = r;
            reset = 0x0;
        } tt10_enf1[19:19];
        field {
            name = "tt09_enf1";
            desc = "Teletext switch control bit for line 9 of the odd field.
- 0: Off;
- 1: On.";
            sw = rw; hw = r;
            reset = 0x0;
        } tt09_enf1[18:18];
        field {
            name = "tt08_enf1";
            desc = "Teletext switch control bit for line 8 of the odd field.
- 0: Off.
- 1: On.";
            sw = rw; hw = r;
            reset = 0x0;
        } tt08_enf1[17:17];
        field {
            name = "tt07_enf1";
            desc = "Teletext enable control bit for line 7 of the odd field.
- 0: Off;
- 1: On.";
            sw = rw; hw = r;
            reset = 0x0;
        } tt07_enf1[16:16];
        field {
            name = "tt22_enf2";
            desc = "Teletext switch control bit for line 22 of the even field.
- 0: Off;
- 1: On.";
            sw = rw; hw = r;
            reset = 0x0;
        } tt22_enf2[15:15];
        field {
            name = "tt21_enf2";
            desc = "Teletext switch control bit for line 21 of the even field.
- 0: Off.
- 1: On.";
            sw = rw; hw = r;
            reset = 0x0;
        } tt21_enf2[14:14];
        field {
            name = "tt20_enf2";
            desc = "Teletext switch control bit for line 20 of the even field.
- 0: Off;
- 1: On.";
            sw = rw; hw = r;
            reset = 0x0;
        } tt20_enf2[13:13];
        field {
            name = "tt19_enf2";
            desc = "Teletext switch control bit for line 19 of the even field.
- 0: Off.
- 1: On.";
            sw = rw; hw = r;
            reset = 0x0;
        } tt19_enf2[12:12];
        field {
            name = "tt18_enf2";
            desc = "Teletext enable control bit for line 18 of the even field.
- 0: Off;
- 1: On.";
            sw = rw; hw = r;
            reset = 0x0;
        } tt18_enf2[11:11];
        field {
            name = "tt17_enf2";
            desc = "Teletext switch control bit for line 17 of the even field.
- 0: Off;
- 1: On.";
            sw = rw; hw = r;
            reset = 0x0;
        } tt17_enf2[10:10];
        field {
            name = "tt16_enf2";
            desc = "Teletext switch control bit for line 16 of the even field.
- 0: Off;
- 1: On.";
            sw = rw; hw = r;
            reset = 0x0;
        } tt16_enf2[9:9];
        field {
            name = "tt15_enf2";
            desc = "Teletext switch control bit for line 15 of the even field.
- 0: Off;
- 1: On.";
            sw = rw; hw = r;
            reset = 0x0;
        } tt15_enf2[8:8];
        field {
            name = "tt14_enf2";
            desc = "Teletext switch control bit for line 14 of the even field.
- 0: Off.
- 1: On.";
            sw = rw; hw = r;
            reset = 0x0;
        } tt14_enf2[7:7];
        field {
            name = "tt13_enf2";
            desc = "Teletext enable control bit for line 13 of the even field.
- 0: Off;
- 1: On.";
            sw = rw; hw = r;
            reset = 0x0;
        } tt13_enf2[6:6];
        field {
            name = "tt12_enf2";
            desc = "Teletext switch control bit for line 12 of the even field.
- 0: Off;
- 1: On.";
            sw = rw; hw = r;
            reset = 0x0;
        } tt12_enf2[5:5];
        field {
            name = "tt11_enf2";
            desc = "Teletext switch control bit for line 11 of the even field.
- 0: Off;
- 1: On.";
            sw = rw; hw = r;
            reset = 0x0;
        } tt11_enf2[4:4];
        field {
            name = "tt10_enf2";
            desc = "Teletext switch control bit for line 10 of the even field.
- 0: Off;
- 1: On.";
            sw = rw; hw = r;
            reset = 0x0;
        } tt10_enf2[3:3];
        field {
            name = "tt09_enf2";
            desc = "Teletext switch control bit for line 9 of the even field.
- 0: Off.
- 1: On.";
            sw = rw; hw = r;
            reset = 0x0;
        } tt09_enf2[2:2];
        field {
            name = "tt08_enf2";
            desc = "Teletext enable control bit for line 8 of the even field.
- 0: Off;
- 1: On.";
            sw = rw; hw = r;
            reset = 0x0;
        } tt08_enf2[1:1];
        field {
            name = "tt07_enf2";
            desc = "Teletext switch control bit for line 7 of the even field.
- 0: Off;
- 1: On.";
            sw = rw; hw = r;
            reset = 0x0;
        } tt07_enf2[0:0];
    } DATE_COEFF7 @ 0xf21c;
    reg {
        name = "DATE_COEFF8";
        desc = "DATE_COEFF8 is the Teletext configuration register. DATE_COEFF8 (offset 0xF220, total reset 0x0000_0000; PROVEN: Hi3535 data sheet, PDF page 1139, section 5.10).";
        field {
            name = "tt_staddr";
            desc = "Teletext data start address.";
            sw = rw; hw = r;
            reset = 0x0;
        } tt_staddr[31:0];
    } DATE_COEFF8 @ 0xf220;
    reg {
        name = "DATE_COEFF9";
        desc = "DATE_COEFF9 is a Teletext configuration register. DATE_COEFF9 (offset 0xF224, total reset 0x0000_0000; PROVEN: Hi3535 data sheet, PDF page 1139, section 5.10).";
        field {
            name = "tt_edaddr";
            desc = "Teletext data end address.";
            sw = rw; hw = r;
            reset = 0x0;
        } tt_edaddr[31:0];
    } DATE_COEFF9 @ 0xf224;
    reg {
        name = "DATE_COEFF10";
        desc = "DATE_COEFF10 is a Teletext configuration register. In the current version, Teletext is supported in both 625-line and 525-line modes. Set tt_mode to 01 in 625-line mode and to 10 in 525-line mode. DATE_COEFF10 (offset 0xF228, total reset 0x0000_0000; PROVEN: Hi3535 data sheet, PDF page 1140, section 5.10).";
        field {
            name = "tt_ready";
            desc = "When software has configured the related parameters through the bus, set this bit to 1 and the Teletext module starts working; when the Teletext finishes the data transfer, this bit goes low, which software can poll, and the module waits for the next software configuration. (data sheet access type WC)";
            sw = rw; hw = r; onwrite = woclr;
            reset = 0x0;
        } tt_ready[31:31];
        field {
            name = "reserved";
            desc = "Reserved.";
            sw = r; hw = w;
            reset = 0x0;
        } reserved_30_13[30:13];
        field {
            name = "nabts_100ire";
            desc = "NABTS-NTSC data height configuration register.
- 0: 70IRE;
- 1: 100IRE.";
            sw = rw; hw = r;
            reset = 0x0;
        } nabts_100ire[12:12];
        field {
            name = "full_page";
            desc = "tt transmit full page mode control register.
- 0: Normal mode (tt data is sent on blanking lines);
- 1: Full page mode (tt data can also be sent in the active video area).";
            sw = rw; hw = r;
            reset = 0x0;
        } full_page[11:11];
        field {
            name = "tt_highest";
            desc = "Tt priority control register.
- 0: tt has the highest priority.
- 1: tt has the lowest priority.";
            sw = rw; hw = r;
            reset = 0x0;
        } tt_highest[10:10];
        field {
            name = "tt_mode";
            desc = "TT mode. Configure 01 for 625 lines, representing wst-pal; configure 10 for 525 lines, representing nabts-ntsc.";
            sw = rw; hw = r;
            reset = 0x0;
        } tt_mode[9:8];
        field {
            name = "tt_pktoff";
            desc = "TT packet offset address.";
            sw = rw; hw = r;
            reset = 0x0;
        } tt_pktoff[7:0];
    } DATE_COEFF10 @ 0xf228;
    reg {
        name = "DATE_COEFF11";
        desc = "DATE_COEFF11 is the Closed Caption configuration register. DATE_COEFF11 (offset 0xF22C, total reset 0x0000_0000; PROVEN: Hi3535 data sheet, PDF page 1141, section 5.10).";
        field {
            name = "reserved";
            desc = "Reserved.";
            sw = r; hw = w;
            reset = 0x0;
        } reserved_31_22[31:22];
        field {
            name = "cc_enf1";
            desc = "Closed Caption odd field switch control bit.
- 0: Off;
- 1: On.";
            sw = rw; hw = r;
            reset = 0x0;
        } cc_enf1[21:21];
        field {
            name = "cc_enf2";
            desc = "Closed Caption even-field switch control bit.
- 0: Off;
- 1: On.";
            sw = rw; hw = r;
            reset = 0x0;
        } cc_enf2[20:20];
        field {
            name = "date_clf1";
            desc = "Closed Caption odd field configuration line.";
            sw = rw; hw = r;
            reset = 0x0;
        } date_clf1[19:10];
        field {
            name = "date_clf2";
            desc = "Closed Caption even field configuration line.";
            sw = rw; hw = r;
            reset = 0x0;
        } date_clf2[9:0];
    } DATE_COEFF11 @ 0xf22c;
    reg {
        name = "DATE_COEFF12";
        desc = "DATE_COEFF12 is the Closed Caption configuration register. DATE_COEFF12 (offset 0xF230, total reset 0x0000_0000; PROVEN: Hi3535 data sheet, PDF page 1141, section 5.10).";
        field {
            name = "cc_f1data";
            desc = "Closed Caption odd field data.";
            sw = rw; hw = r;
            reset = 0x0;
        } cc_f1data[31:16];
        field {
            name = "cc_f2data";
            desc = "Closed Caption even field data.";
            sw = rw; hw = r;
            reset = 0x0;
        } cc_f2data[15:0];
    } DATE_COEFF12 @ 0xf230;
    reg {
        name = "DATE_COEFF13";
        desc = "DATE_COEFF13 is the CGMS configuration register. DATE_COEFF13 (offset 0xF234, total reset 0x0000_0000; PROVEN: Hi3535 data sheet, PDF page 1142, section 5.10).";
        field {
            name = "reserved";
            desc = "Reserved.";
            sw = r; hw = w;
            reset = 0x0;
        } reserved_31_22[31:22];
        field {
            name = "cg_enf1";
            desc = "CGMS odd field switch control bit.
- 0: Off.
- 1: On.";
            sw = rw; hw = r;
            reset = 0x0;
        } cg_enf1[21:21];
        field {
            name = "cg_enf2";
            desc = "CGMS even-field switch control bit.
- 0: Off;
- 1: On.";
            sw = rw; hw = r;
            reset = 0x0;
        } cg_enf2[20:20];
        field {
            name = "cg_f1data";
            desc = "CGMS odd field data.";
            sw = rw; hw = r;
            reset = 0x0;
        } cg_f1data[19:0];
    } DATE_COEFF13 @ 0xf234;
    reg {
        name = "DATE_COEFF14";
        desc = "DATE_COEFF14 is the CGMS configuration register. DATE_COEFF14 (offset 0xF238, total reset 0x0000_0000; PROVEN: Hi3535 data sheet, PDF page 1142, section 5.10).";
        field {
            name = "reserved";
            desc = "Reserved.";
            sw = r; hw = w;
            reset = 0x0;
        } reserved_31_20[31:20];
        field {
            name = "cg_f2data";
            desc = "CGMS even field data.";
            sw = rw; hw = r;
            reset = 0x0;
        } cg_f2data[19:0];
    } DATE_COEFF14 @ 0xf238;
    reg {
        name = "DATE_COEFF15";
        desc = "DATE_COEFF15 is the WSS configuration register. WSS is used only in the 625-line standard and is fixed at line 23. DATE_COEFF15 (offset 0xF23C, total reset 0x0000_0000; PROVEN: Hi3535 data sheet, PDF page 1143, section 5.10).";
        field {
            name = "reserved";
            desc = "Reserved.";
            sw = r; hw = w;
            reset = 0x0;
        } reserved_31_15[31:15];
        field {
            name = "wss_en";
            desc = "WSS switch control bit.
- 0: Off;
- 1: On.";
            sw = rw; hw = r;
            reset = 0x0;
        } wss_en[14:14];
        field {
            name = "wss_data";
            desc = "WSS data.";
            sw = rw; hw = r;
            reset = 0x0;
        } wss_data[13:0];
    } DATE_COEFF15 @ 0xf23c;
    reg {
        name = "DATE_COEFF16";
        desc = "DATE_COEFF16 is the VPS configuration register. DATE_COEFF16 (offset 0xF240, total reset 0x0000_0000; PROVEN: Hi3535 data sheet, PDF page 1143, section 5.10).";
        field {
            name = "reserved";
            desc = "Reserved.";
            sw = r; hw = w;
            reset = 0x0;
        } reserved_31_25[31:25];
        field {
            name = "vps_en";
            desc = "VPS switch control bit.
- 0: Off;
- 1: On.";
            sw = rw; hw = r;
            reset = 0x0;
        } vps_en[24:24];
        field {
            name = "vps_data";
            desc = "VPS data, bit 23 to bit 0, with bit 0 being the least significant bit.";
            sw = rw; hw = r;
            reset = 0x0;
        } vps_data[23:0];
    } DATE_COEFF16 @ 0xf240;
    reg {
        name = "DATE_COEFF17";
        desc = "DATE_COEFF17 is the VPS configuration register. DATE_COEFF17 (offset 0xF244, total reset 0x0000_0000; PROVEN: Hi3535 data sheet, PDF page 1144, section 5.10).";
        field {
            name = "vps_data";
            desc = "VPS data, bit 55 to bit 24, with the least significant bit being bit 0.";
            sw = rw; hw = r;
            reset = 0x0;
        } vps_data[31:0];
    } DATE_COEFF17 @ 0xf244;
    reg {
        name = "DATE_COEFF18";
        desc = "DATE_COEFF18 is the VPS configuration register. DATE_COEFF18 (offset 0xF248, total reset 0x0000_0000; PROVEN: Hi3535 data sheet, PDF page 1144, section 5.10).";
        field {
            name = "vps_data";
            desc = "VPS data, bits 87 to 56; the lowest bit is bit 0.";
            sw = rw; hw = r;
            reset = 0x0;
        } vps_data[31:0];
    } DATE_COEFF18 @ 0xf248;
    reg {
        name = "DATE_COEFF19";
        desc = "DATE_COEFF19 is the VPS configuration register. VPS is supported only in 625-line mode and is fixed on line 16. DATE_COEFF19 (offset 0xF24C, total reset 0x0000_0000; PROVEN: Hi3535 data sheet, PDF page 1144, section 5.10).";
        field {
            name = "reserved";
            desc = "Reserved.";
            sw = r; hw = w;
            reset = 0x0;
        } reserved_31_16[31:16];
        field {
            name = "vps_data";
            desc = "VPS data, bit 103 to bit 88; the least significant bit is bit 0.";
            sw = rw; hw = r;
            reset = 0x0;
        } vps_data[15:0];
    } DATE_COEFF19 @ 0xf24c;
    reg {
        name = "DATE_COEFF21";
        desc = "DATE_COEFF21 is the output matrix control register. DATE_COEFF21 (offset 0xF254, total reset 0x0065_1432; PROVEN: Hi3535 data sheet, PDF page 1145, section 5.10).";
        field {
            name = "reserved";
            desc = "Reserved.";
            sw = r; hw = w;
            reset = 0x0;
        } reserved_31_23[31:23];
        field {
            name = "dac5_in_sel";
            desc = "DAC5 output mode select.
- 000: 0.
- 001: cvbs.
- 010: G/Y.
- 011: B/Pb.
- 100: R/Pr.
- 101: svideo_y.
- 110: svideo_c.
- 111: 0.";
            sw = rw; hw = r;
            reset = 0x6;
        } dac5_in_sel[22:20];
        field {
            name = "reserved";
            desc = "Reserved.";
            sw = r; hw = w;
            reset = 0x0;
        } reserved_19_19[19:19];
        field {
            name = "dac4_in_sel";
            desc = "DAC4 output mode select.
- 000: 0;
- 001: cvbs;
- 010: G/Y;
- 011: B/Pb;
- 100: R/Pr;
- 101: svideo_y;
- 110: svideo_c;
- 111: 0.";
            sw = rw; hw = r;
            reset = 0x5;
        } dac4_in_sel[18:16];
        field {
            name = "reserved";
            desc = "Reserved.";
            sw = r; hw = w;
            reset = 0x0;
        } reserved_15_15[15:15];
        field {
            name = "dac3_in_sel";
            desc = "DAC3 output mode select.
- 000: 0;
- 001: cvbs;
- 010: G/Y;
- 011: B/Pb;
- 100: R/Pr;
- 101: svideo_y;
- 110: svideo_c;
- 111: 0.";
            sw = rw; hw = r;
            reset = 0x1;
        } dac3_in_sel[14:12];
        field {
            name = "reserved";
            desc = "Reserved. Writes have no effect; reads return 0.";
            sw = r; hw = w;
            reset = 0x0;
        } reserved_11_11[11:11];
        field {
            name = "dac2_in_sel";
            desc = "DAC2 output mode select.
- 000: 0.
- 001: cvbs.
- 010: G/Y.
- 011: B/Pb.
- 100: R/Pr.
- 101: svideo_y.
- 110: svideo_c.
- 111: 0.";
            sw = rw; hw = r;
            reset = 0x4;
        } dac2_in_sel[10:8];
        field {
            name = "reserved";
            desc = "Reserved. Writes have no effect; reads return 0.";
            sw = r; hw = w;
            reset = 0x0;
        } reserved_7_7[7:7];
        field {
            name = "dac1_in_sel";
            desc = "DAC1 output mode select.
- 000: 0;
- 001: cvbs;
- 010: G/Y;
- 011: B/Pb;
- 100: R/Pr;
- 101: svideo_y;
- 110: svideo_c;
- 111: 0.";
            sw = rw; hw = r;
            reset = 0x3;
        } dac1_in_sel[6:4];
        field {
            name = "reserved";
            desc = "Reserved.";
            sw = r; hw = w;
            reset = 0x0;
        } reserved_3_3[3:3];
        field {
            name = "dac0_in_sel";
            desc = "DAC0 output mode selection.
- 000: 0;
- 001: cvbs;
- 010: G/Y;
- 011: B/Pb; 100 R/Pr;
- 101: svideo_y;
- 110: svideo_c;
- 111: 0.";
            sw = rw; hw = r;
            reset = 0x2;
        } dac0_in_sel[2:0];
    } DATE_COEFF21 @ 0xf254;
    reg {
        name = "DATE_COEFF22";
        desc = "DATE_COEFF22 is the DTO initial phase configuration register. DATE_COEFF22 (offset 0xF258, total reset 0x0000_0000; PROVEN: Hi3535 data sheet, PDF page 1147, section 5.10).";
        field {
            name = "reserved";
            desc = "Reserved.";
            sw = r; hw = w;
            reset = 0x0;
        } reserved_31_11[31:11];
        field {
            name = "video_phase_delta";
            desc = "DTO initial phase configuration register.";
            sw = rw; hw = r;
            reset = 0x0;
        } video_phase_delta[10:0];
    } DATE_COEFF22 @ 0xf258;
    reg {
        name = "DATE_COEFF23";
        desc = "DATE_COEFF23 is the VIDEO_OUT delay configuration register. DATE_COEFF23 (offset 0xF25C, total reset 0x0000_0000; PROVEN: Hi3535 data sheet, PDF page 1148, section 5.10).";
        field {
            name = "reserved";
            desc = "Reserved.";
            sw = r; hw = w;
            reset = 0x0;
        } reserved_31_23[31:23];
        field {
            name = "dac5_out_dly";
            desc = "DAC5 output delay cycles. Configures n delay cycles, in units of one 54 MHz clock period.";
            sw = rw; hw = r;
            reset = 0x0;
        } dac5_out_dly[22:20];
        field {
            name = "reserved";
            desc = "Reserved.";
            sw = r; hw = w;
            reset = 0x0;
        } reserved_19_19[19:19];
        field {
            name = "dac4_out_dly";
            desc = "DAC4 output delay cycles. Configures n delay cycles, in units of one 54MHz clock cycle.";
            sw = rw; hw = r;
            reset = 0x0;
        } dac4_out_dly[18:16];
        field {
            name = "reserved";
            desc = "Reserved.";
            sw = r; hw = w;
            reset = 0x0;
        } reserved_15_15[15:15];
        field {
            name = "dac3_out_dly";
            desc = "DAC3 output delay cycles. Configures n delay cycles, in units of one 54MHz clock cycle.";
            sw = rw; hw = r;
            reset = 0x0;
        } dac3_out_dly[14:12];
        field {
            name = "reserved";
            desc = "Reserved.";
            sw = r; hw = w;
            reset = 0x0;
        } reserved_11_11[11:11];
        field {
            name = "dac2_out_dly";
            desc = "DAC2 output delay cycles. Configures n delay cycles, in units of one 54MHz clock cycle.";
            sw = rw; hw = r;
            reset = 0x0;
        } dac2_out_dly[10:8];
        field {
            name = "reserved";
            desc = "Reserved.";
            sw = r; hw = w;
            reset = 0x0;
        } reserved_7_7[7:7];
        field {
            name = "dac1_out_dly";
            desc = "DAC1 output delay cycles. Configures n delay cycles, in units of one 54MHz clock cycle.";
            sw = rw; hw = r;
            reset = 0x0;
        } dac1_out_dly[6:4];
        field {
            name = "reserved";
            desc = "Reserved.";
            sw = r; hw = w;
            reset = 0x0;
        } reserved_3_3[3:3];
        field {
            name = "dac0_out_dly";
            desc = "DAC0 output delay cycles. Configures n delay cycles, in units of one 54MHz clock cycle.";
            sw = rw; hw = r;
            reset = 0x0;
        } dac0_out_dly[2:0];
    } DATE_COEFF23 @ 0xf25c;
    reg {
        name = "DATE_COEFF24";
        desc = "DATE_COEFF24 is the ColorBurst start position register. DATE_COEFF24 (offset 0xF260, total reset 0x0001_2C99; PROVEN: Hi3535 data sheet, PDF page 1149, section 5.10).";
        field {
            name = "burst_start";
            desc = "ColorBurst start position register.";
            sw = rw; hw = r;
            reset = 0x12c99;
        } burst_start[31:0];
    } DATE_COEFF24 @ 0xf260;
    reg {
        name = "DATE_ISRMASK";
        desc = "DATE_ISRMASK is the interrupt mask register. DATE_ISRMASK (offset 0xF280, total reset 0x0000_0000; PROVEN: Hi3535 data sheet, PDF page 1149, section 5.10).";
        field {
            name = "reserved";
            desc = "Reserved.";
            sw = r; hw = w;
            reset = 0x0;
        } reserved_31_1[31:1];
        field {
            name = "tt_mask";
            desc = "Teletext interrupt mask bit.
- 0: Enable the Teletext interrupt;
- 1: Mask the Teletext interrupt.";
            sw = rw; hw = r;
            reset = 0x0;
        } tt_mask[0:0];
    } DATE_ISRMASK @ 0xf280;
    reg {
        name = "DATE_ISRSTATE";
        desc = "DATE_ISRSTATE is the interrupt status register. DATE_ISRSTATE (offset 0xF284, total reset 0x0000_0000; PROVEN: Hi3535 data sheet, PDF page 1150, section 5.10).";
        field {
            name = "reserved";
            desc = "Reserved.";
            sw = r; hw = w;
            reset = 0x0;
        } reserved_31_1[31:1];
        field {
            name = "tt_status";
            desc = "Teletext interrupt flag. This flag is set high after the DATE has read all Teletext data. To clear the interrupt, write 1 to this bit. (data sheet access type WC)";
            sw = rw; hw = r; onwrite = woclr;
            reset = 0x0;
        } tt_status[0:0];
    } DATE_ISRSTATE @ 0xf284;
    reg {
        name = "DATE_ISR";
        desc = "DATE_ISR is the interrupt register. DATE_ISR (offset 0xF288, total reset 0x0000_0000; PROVEN: Hi3535 data sheet, PDF page 1150, section 5.10).";
        field {
            name = "reserved";
            desc = "Reserved.";
            sw = r; hw = w;
            reset = 0x0;
        } reserved_31_1[31:1];
        field {
            name = "tt_int";
            desc = "Teletext interrupt register; the interrupt status of tt_status after masking by tt_mask.";
            sw = r; hw = w;
            reset = 0x0;
        } tt_int[0:0];
    } DATE_ISR @ 0xf288;
    reg {
        name = "DATE_VERSION";
        desc = "DATE_VERSION is the version register. DATE_VERSION (offset 0xF290, total reset 0x0000_0024; PROVEN: Hi3535 data sheet, PDF page 1151, section 5.10).";
        field {
            name = "reserved";
            desc = "Reserved.";
            sw = r; hw = w;
            reset = 0x24;
        } reserved_31_0[31:0];
    } DATE_VERSION @ 0xf290;
    reg {
        name = "DATE_COEFF37";
        desc = "DATE_COEFF37 is upsampling filter coefficient 1 register. DATE_COEFF37 (offset 0xF294, total reset 0x19EF_0CF9; PROVEN: Hi3535 data sheet, PDF page 1151, section 5.10).";
        field {
            name = "fir_y1_coeff3";
            desc = "Luma upsampling filter coefficient 13.";
            sw = rw; hw = r;
            reset = 0x19;
        } fir_y1_coeff3[31:24];
        field {
            name = "fir_y1_coeff2";
            desc = "Luma upsampling filter coefficient 12.";
            sw = rw; hw = r;
            reset = 0xef;
        } fir_y1_coeff2[23:16];
        field {
            name = "fir_y1_coeff1";
            desc = "Luma upsampling filter coefficient 11.";
            sw = rw; hw = r;
            reset = 0xc;
        } fir_y1_coeff1[15:8];
        field {
            name = "fir_y1_coeff0";
            desc = "Luma upsampling filter coefficient 10.";
            sw = rw; hw = r;
            reset = 0xf9;
        } fir_y1_coeff0[7:0];
    } DATE_COEFF37 @ 0xf294;
    reg {
        name = "DATE_COEFF38";
        desc = "DATE_COEFF38 is the upsampling filter coefficient 2 register. DATE_COEFF38 (offset 0xF298, total reset 0x003A_FFDA; PROVEN: Hi3535 data sheet, PDF page 1151, section 5.10).";
        field {
            name = "fir_y2_coeff1";
            desc = "Luma upsampling filter coefficient 21.";
            sw = rw; hw = r;
            reset = 0x3a;
        } fir_y2_coeff1[31:16];
        field {
            name = "fir_y2_coeff0";
            desc = "Luma upsampling filter coefficient 20.";
            sw = rw; hw = r;
            reset = 0xffda;
        } fir_y2_coeff0[15:0];
    } DATE_COEFF38 @ 0xf298;
    reg {
        name = "DATE_COEFF39";
        desc = "DATE_COEFF39 is upsampling filter coefficient 3 register. DATE_COEFF39 (offset 0xF29C, total reset 0x0148_FF97; PROVEN: Hi3535 data sheet, PDF page 1152, section 5.10).";
        field {
            name = "fir_y2_coeff3";
            desc = "Luma upsampling filter coefficient 23.";
            sw = rw; hw = r;
            reset = 0x148;
        } fir_y2_coeff3[31:16];
        field {
            name = "fir_y2_coeff2";
            desc = "Luma upsampling filter coefficient 22.";
            sw = rw; hw = r;
            reset = 0xff97;
        } fir_y2_coeff2[15:0];
    } DATE_COEFF39 @ 0xf29c;
    reg {
        name = "DATE_COEFF40";
        desc = "DATE_COEFF40 is upsampling filter coefficient 4 register. DATE_COEFF40 (offset 0xF2A0, total reset 0x19EF_0CF9; PROVEN: Hi3535 data sheet, PDF page 1152, section 5.10).";
        field {
            name = "fir_c1_coeff3";
            desc = "Chrominance upsampling filter coefficient 13.";
            sw = rw; hw = r;
            reset = 0x19;
        } fir_c1_coeff3[31:24];
        field {
            name = "fir_c1_coeff2";
            desc = "Chroma upsampling filter coefficient 12.";
            sw = rw; hw = r;
            reset = 0xef;
        } fir_c1_coeff2[23:16];
        field {
            name = "fir_c1_coeff1";
            desc = "Chroma upsampling filter coefficient 11.";
            sw = rw; hw = r;
            reset = 0xc;
        } fir_c1_coeff1[15:8];
        field {
            name = "fir_c1_coeff0";
            desc = "Chroma upsampling filter coefficient 10.";
            sw = rw; hw = r;
            reset = 0xf9;
        } fir_c1_coeff0[7:0];
    } DATE_COEFF40 @ 0xf2a0;
    reg {
        name = "DATE_COEFF41";
        desc = "DATE_COEFF41 is upsampling filter coefficient 5 register. DATE_COEFF41 (offset 0xF2A4, total reset 0x003A_FFDA; PROVEN: Hi3535 data sheet, PDF page 1153, section 5.10).";
        field {
            name = "fir_c2_coeff1";
            desc = "Chroma upsampling filter coefficient 21.";
            sw = rw; hw = r;
            reset = 0x3a;
        } fir_c2_coeff1[31:16];
        field {
            name = "fir_c2_coeff0";
            desc = "Chroma upsampling filter coefficient 20.";
            sw = rw; hw = r;
            reset = 0xffda;
        } fir_c2_coeff0[15:0];
    } DATE_COEFF41 @ 0xf2a4;
    reg {
        name = "DATE_COEFF42";
        desc = "DATE_COEFF42 is upsampling filter coefficient 6 register. DATE_COEFF42 (offset 0xF2A8, total reset 0x0148_FF97; PROVEN: Hi3535 data sheet, PDF page 1153, section 5.10).";
        field {
            name = "fir_c2_coeff3";
            desc = "Chrominance upsampling filter coefficient 23.";
            sw = rw; hw = r;
            reset = 0x148;
        } fir_c2_coeff3[31:16];
        field {
            name = "fir_c2_coeff2";
            desc = "Chroma upsampling filter coefficient 22.";
            sw = rw; hw = r;
            reset = 0xff97;
        } fir_c2_coeff2[15:0];
    } DATE_COEFF42 @ 0xf2a8;
    reg {
        name = "DATE_DACDET1";
        desc = "DATE_DACDET1 is the DAC auto-detection 1 register. DATE_DACDET1 (offset 0xF2C0, total reset 0x000D_0303; PROVEN: Hi3535 data sheet, PDF page 1153, section 5.10).";
        field {
            name = "reserved";
            desc = "Reserved.";
            sw = r; hw = w;
            reset = 0x0;
        } reserved_31_26[31:26];
        field {
            name = "det_line";
            desc = "Line on which the level is detected.";
            sw = rw; hw = r;
            reset = 0xd;
        } det_line[25:16];
        field {
            name = "reserved";
            desc = "Reserved.";
            sw = r; hw = w;
            reset = 0x0;
        } reserved_15_10[15:10];
        field {
            name = "vdac_det_high";
            desc = "Detected level value.";
            sw = rw; hw = r;
            reset = 0x303;
        } vdac_det_high[9:0];
    } DATE_DACDET1 @ 0xf2c0;
    reg {
        name = "DATE_DACDET2";
        desc = "DATE_DACDET2 is DAC auto-detect register 2. DATE_DACDET2 (offset 0xF2C4, total reset 0x0030_0118; PROVEN: Hi3535 data sheet, PDF page 1154, section 5.10).";
        field {
            name = "vdac_det_en";
            desc = "DAC auto-detect enable.
- 0: Disable;
- 1: Enable.";
            sw = rw; hw = r;
            reset = 0x0;
        } vdac_det_en[31:31];
        field {
            name = "reserved";
            desc = "Reserved.";
            sw = r; hw = w;
            reset = 0x0;
        } reserved_30_27[30:27];
        field {
            name = "det_pixel_wid";
            desc = "Level width.";
            sw = rw; hw = r;
            reset = 0x30;
        } det_pixel_wid[26:16];
        field {
            name = "reserved";
            desc = "Reserved.";
            sw = r; hw = w;
            reset = 0x0;
        } reserved_15_11[15:11];
        field {
            name = "det_pixel_sta";
            desc = "At the start position of a line.";
            sw = rw; hw = r;
            reset = 0x118;
        } det_pixel_sta[10:0];
    } DATE_DACDET2 @ 0xf2c4;
    reg {
        name = "DATE_COEFF50";
        desc = "DATE_COEFF50 is oversampling filter coefficient 1 register. DATE_COEFF50 (offset 0xF2C8, total reset 0x07FF_07FF; PROVEN: Hi3535 data sheet, PDF page 1155, section 5.10).";
        field {
            name = "reserved";
            desc = "Reserved.";
            sw = r; hw = w;
            reset = 0x0;
        } reserved_31_27[31:27];
        field {
            name = "ovs_coeff1";
            desc = "Luma oversampling filter coefficient 11.";
            sw = rw; hw = r;
            reset = 0x7ff;
        } ovs_coeff1[26:16];
        field {
            name = "reserved";
            desc = "Reserved.";
            sw = r; hw = w;
            reset = 0x0;
        } reserved_15_11[15:11];
        field {
            name = "ovs_coeff0";
            desc = "Luminance oversampling filter coefficient 10.";
            sw = rw; hw = r;
            reset = 0x7ff;
        } ovs_coeff0[10:0];
    } DATE_COEFF50 @ 0xf2c8;
    reg {
        name = "DATE_COEFF51";
        desc = "DATE_COEFF51 is oversampling filter coefficient 2 register. DATE_COEFF51 (offset 0xF2CC, total reset 0x07FF_0204; PROVEN: Hi3535 data sheet, PDF page 1155, section 5.10).";
        field {
            name = "reserved";
            desc = "Reserved.";
            sw = r; hw = w;
            reset = 0x0;
        } reserved_31_27[31:27];
        field {
            name = "ovs_coeff1";
            desc = "Luma oversampling filter coefficient 21.";
            sw = rw; hw = r;
            reset = 0x7ff;
        } ovs_coeff1[26:16];
        field {
            name = "reserved";
            desc = "Reserved.";
            sw = r; hw = w;
            reset = 0x0;
        } reserved_15_11[15:11];
        field {
            name = "ovs_coeff0";
            desc = "Luma oversampling filter coefficient 20.";
            sw = rw; hw = r;
            reset = 0x204;
        } ovs_coeff0[10:0];
    } DATE_COEFF51 @ 0xf2cc;
    reg {
        name = "DATE_COEFF52";
        desc = "DATE_COEFF52 is oversampling filter coefficient 3 register. DATE_COEFF52 (offset 0xF2D0, total reset 0x0000_07FF; PROVEN: Hi3535 data sheet, PDF page 1156, section 5.10).";
        field {
            name = "reserved";
            desc = "Reserved.";
            sw = r; hw = w;
            reset = 0x0;
        } reserved_31_27[31:27];
        field {
            name = "ovs_coeff1";
            desc = "Luminance oversampling filter coefficient 31.";
            sw = rw; hw = r;
            reset = 0x0;
        } ovs_coeff1[26:16];
        field {
            name = "reserved";
            desc = "Reserved.";
            sw = r; hw = w;
            reset = 0x0;
        } reserved_15_11[15:11];
        field {
            name = "ovs_coeff0";
            desc = "Luma oversampling filter coefficient 30.";
            sw = rw; hw = r;
            reset = 0x7ff;
        } ovs_coeff0[10:0];
    } DATE_COEFF52 @ 0xf2d0;
    reg {
        name = "DATE_COEFF53";
        desc = "DATE_COEFF53 is oversampling filter coefficient 4 register. DATE_COEFF53 (offset 0xF2D4, total reset 0x07BF_000C; PROVEN: Hi3535 data sheet, PDF page 1156, section 5.10).";
        field {
            name = "reserved";
            desc = "Reserved.";
            sw = r; hw = w;
            reset = 0x0;
        } reserved_31_27[31:27];
        field {
            name = "ovs_coeff1";
            desc = "Luma oversampling filter coefficient 41.";
            sw = rw; hw = r;
            reset = 0x7bf;
        } ovs_coeff1[26:16];
        field {
            name = "reserved";
            desc = "Reserved.";
            sw = r; hw = w;
            reset = 0x0;
        } reserved_15_11[15:11];
        field {
            name = "ovs_coeff0";
            desc = "Luma oversampling filter coefficient 40.";
            sw = rw; hw = r;
            reset = 0xc;
        } ovs_coeff0[10:0];
    } DATE_COEFF53 @ 0xf2d4;
    reg {
        name = "DATE_COEFF54";
        desc = "DATE_COEFF54 is the oversampling filter coefficient 5 register. DATE_COEFF54 (offset 0xF2D8, total reset 0x0135_0135; PROVEN: Hi3535 data sheet, PDF page 1157, section 5.10).";
        field {
            name = "reserved";
            desc = "Reserved.";
            sw = r; hw = w;
            reset = 0x0;
        } reserved_31_27[31:27];
        field {
            name = "ovs_coeff1";
            desc = "Luma oversampling filter coefficient 51.";
            sw = rw; hw = r;
            reset = 0x135;
        } ovs_coeff1[26:16];
        field {
            name = "reserved";
            desc = "Reserved.";
            sw = r; hw = w;
            reset = 0x0;
        } reserved_15_11[15:11];
        field {
            name = "ovs_coeff0";
            desc = "Luma oversampling filter coefficient 50.";
            sw = rw; hw = r;
            reset = 0x135;
        } ovs_coeff0[10:0];
    } DATE_COEFF54 @ 0xf2d8;
    reg {
        name = "DATE_COEFF55";
        desc = "DATE_COEFF55 is oversampling filter coefficient 6 register. DATE_COEFF55 (offset 0xF2DC, total reset 0x000C_07BF; PROVEN: Hi3535 data sheet, PDF page 1157, section 5.10).";
        field {
            name = "reserved";
            desc = "Reserved.";
            sw = r; hw = w;
            reset = 0x0;
        } reserved_31_27[31:27];
        field {
            name = "ovs_coeff1";
            desc = "Luma oversampling filter coefficient 61.";
            sw = rw; hw = r;
            reset = 0xc;
        } ovs_coeff1[26:16];
        field {
            name = "reserved";
            desc = "Reserved.";
            sw = r; hw = w;
            reset = 0x0;
        } reserved_15_11[15:11];
        field {
            name = "ovs_coeff0";
            desc = "Luminance oversampling filter coefficient 60. Contents";
            sw = rw; hw = r;
            reset = 0x7bf;
        } ovs_coeff0[10:0];
    } DATE_COEFF55 @ 0xf2dc;
};

`endif
