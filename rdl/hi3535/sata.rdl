`ifndef EHI3535_SATA_RDL
`define EHI3535_SATA_RDL
regfile eHI3535_SATA {
    name = "SATA 3.0 AHCI generic host control";
    desc = "SATA 3.0 AHCI generic host control. 32 registers extracted programmatically from the Hi3535 H.264 codec processor (Hi3535 user guide) data sheet (Issue 00B08, 2014-02-25); chapter 13.8.7.1, table 13-18. Field names, bit ranges, access types and reset values are taken from the register tables; reset values are the data sheet total reset values split onto the fields (per-field values where the table has them). Label: PROVEN. Hardware not verified here (no board).";
    reg {
        name = "SATA_GHC_CAP1";
        desc = "SATA_GHC_CAP1 is feature support register 1. SATA_GHC_CAP1 (offset 0x0000, total reset 0x6F37_7FA2; PROVEN: Hi3535 data sheet, PDF page 1364, section 13.8.7.1).";
        field {
            name = "s64a";
            desc = "Fixed to 0, indicating that 64-bit data structure access is not supported.";
            sw = r; hw = w;
            reset = 0x0;
        } s64a[31:31];
        field {
            name = "sncq";
            desc = "Fixed at 1, indicating NCQ support.";
            sw = r; hw = w;
            reset = 0x1;
        } sncq[30:30];
        field {
            name = "ssntf";
            desc = "Fixed at 1, indicating that the port SNTF register is supported.";
            sw = r; hw = w;
            reset = 0x1;
        } ssntf[29:29];
        field {
            name = "smps";
            desc = "Fixed at 0, indicating that mechanical hot plug is not supported.";
            sw = r; hw = w;
            reset = 0x0;
        } smps[28:28];
        field {
            name = "sss";
            desc = "Fixed to 1, indicating support for staggered spin-up.";
            sw = r; hw = w;
            reset = 0x1;
        } sss[27:27];
        field {
            name = "salp";
            desc = "Fixed to 1, indicating that power management is supported.";
            sw = r; hw = w;
            reset = 0x1;
        } salp[26:26];
        field {
            name = "sal";
            desc = "Fixed at 1, indicating support for the activity LED pin.";
            sw = r; hw = w;
            reset = 0x1;
        } sal[25:25];
        field {
            name = "sclo";
            desc = "Fixed at 1, indicating support for command list override.";
            sw = r; hw = w;
            reset = 0x1;
        } sclo[24:24];
        field {
            name = "iss";
            desc = "Fixed at 0x3, indicating a maximum supported rate of 6Gbps.";
            sw = r; hw = w;
            reset = 0x3;
        } iss[23:20];
        field {
            name = "reserved";
            desc = "Reserved.";
            sw = r; hw = w;
            reset = 0x0;
        } reserved_19_19[19:19];
        field {
            name = "sam";
            desc = "Fixed at 1, indicating that only AHCI mode is supported.";
            sw = r; hw = w;
            reset = 0x1;
        } sam[18:18];
        field {
            name = "spm";
            desc = "Fixed at 1, indicating that Port Multiplier is supported.";
            sw = r; hw = w;
            reset = 0x1;
        } spm[17:17];
        field {
            name = "fbss";
            desc = "Fixed at 1, indicating support for FIS-based Switching.";
            sw = r; hw = w;
            reset = 0x1;
        } fbss[16:16];
        field {
            name = "pmd";
            desc = "Fixed to 0, but PIO mode does not support transferring multiple DRQ blocks.";
            sw = r; hw = w;
            reset = 0x0;
        } pmd[15:15];
        field {
            name = "ssc";
            desc = "Fixed at 1, indicating support for entering the Slumber state.";
            sw = r; hw = w;
            reset = 0x1;
        } ssc[14:14];
        field {
            name = "psc";
            desc = "Fixed at 1, indicating support for entering the Partial state.";
            sw = r; hw = w;
            reset = 0x1;
        } psc[13:13];
        field {
            name = "ncs";
            desc = "Fixed at 0x1F, indicating that 32 command slots are supported.";
            sw = r; hw = w;
            reset = 0x1f;
        } ncs[12:8];
        field {
            name = "cccs";
            desc = "Fixed to 1, indicating that the CCC (Command Completion Coalescing) function is supported.";
            sw = r; hw = w;
            reset = 0x1;
        } cccs[7:7];
        field {
            name = "ems";
            desc = "Fixed at 0, indicating Enclosure Management is not supported.";
            sw = r; hw = w;
            reset = 0x0;
        } ems[6:6];
        field {
            name = "sxs";
            desc = "Fixed at 1, indicating that External SATA is supported.";
            sw = r; hw = w;
            reset = 0x1;
        } sxs[5:5];
        field {
            name = "np";
            desc = "Fixed at 0x02, indicating support for 3 ports.";
            sw = r; hw = w;
            reset = 0x2;
        } np[4:0];
    } SATA_GHC_CAP1 @ 0x0;
    reg {
        name = "SATA_GHC_GHC";
        desc = "SATA_GHC_GHC is the global control register. SATA_GHC_GHC (offset 0x0004, total reset 0x8000_0000; PROVEN: Hi3535 data sheet, PDF page 1365, section 13.8.7.1).";
        field {
            name = "ahci_en";
            desc = "Fixed to 1, indicating that software can interact with the controller only through the AHCI mechanism.";
            sw = r; hw = w;
            reset = 0x1;
        } ahci_en[31:31];
        field {
            name = "reserved";
            desc = "Reserved.";
            sw = r; hw = w;
            reset = 0x0;
        } reserved_30_2[30:2];
        field {
            name = "int_enable";
            desc = "Controller interrupt enable.
- 0: Disable;
- 1: Enable.";
            sw = rw; hw = r;
            reset = 0x0;
        } int_enable[1:1];
        field {
            name = "hba_rst";
            desc = "Controller soft reset control.
- 0: No reset;
- 1: Reset. Writing 1 resets the controller and the bit is cleared automatically when the reset completes; writing 0 has no effect on the controller. The reset does not affect the SATA_GHC_BOHC, SATA_PORT_FB and SATA_PORT_CLB registers.";
            sw = rw; hw = r;
            reset = 0x0;
        } hba_rst[0:0];
    } SATA_GHC_GHC @ 0x4;
    reg {
        name = "SATA_GHC_IS";
        desc = "SATA_GHC_IS is the interrupt status register. SATA_GHC_IS (offset 0x0008, total reset 0x0000_0000; PROVEN: Hi3535 data sheet, PDF page 1366, section 13.8.7.1).";
        field {
            name = "ips_ccc";
            desc = "CCC interrupt status.
- 0: No CCC interrupt generated;
- 1: CCC interrupt generated. (data sheet access type WC)";
            sw = rw; hw = r; onwrite = woclr;
            reset = 0x0;
        } ips_ccc[31:31];
        field {
            name = "reserved";
            desc = "Reserved.";
            sw = r; hw = w;
            reset = 0x0;
        } reserved_30_3[30:3];
        field {
            name = "ips_port2";
            desc = "Port 2 interrupt status.
- 0: No interrupt reported;
- 1: Interrupt reported. (data sheet access type WC)";
            sw = rw; hw = r; onwrite = woclr;
            reset = 0x0;
        } ips_port2[2:2];
        field {
            name = "ips_port1";
            desc = "Port 1 interrupt status.
- 0: No interrupt reported;
- 1: Interrupt reported. (data sheet access type WC)";
            sw = rw; hw = r; onwrite = woclr;
            reset = 0x0;
        } ips_port1[1:1];
        field {
            name = "ips_port0";
            desc = "Port 0 interrupt status.
- 0: No interrupt reported;
- 1: Interrupt reported. (data sheet access type WC)";
            sw = rw; hw = r; onwrite = woclr;
            reset = 0x0;
        } ips_port0[0:0];
    } SATA_GHC_IS @ 0x8;
    reg {
        name = "SATA_GHC_PI";
        desc = "SATA_GHC_PI is the ports implemented register. SATA_GHC_PI (offset 0x000C, total reset 0x0000_0007; PROVEN: Hi3535 data sheet, PDF page 1366, section 13.8.7.1).";
        field {
            name = "reserved";
            desc = "Reserved.";
            sw = r; hw = w;
            reset = 0x0;
        } reserved_31_3[31:3];
        field {
            name = "port_imp";
            desc = "Port valid indication. A value of 0x7 means that the 3 ports 0 to 2 are valid; bit[2] to bit[0] correspond to port 2 to port 0 respectively.
- 0: Port invalid;
- 1: Port valid.";
            sw = r; hw = w;
            reset = 0x7;
        } port_imp[2:0];
    } SATA_GHC_PI @ 0xc;
    reg {
        name = "SATA_GHC_VS";
        desc = "SATA_GHC_VS is the AHCI version identification register. SATA_GHC_VS (offset 0x0010, total reset 0x0001_0300; PROVEN: Hi3535 data sheet, PDF page 1367, section 13.8.7.1). Data sheet inconsistency: the bit diagram shows 0x0001_0200 as reset, the total reset value 0x0001_0300 (used here) matches the AHCI 1.3 version in the field description.";
        field {
            name = "achi_vs";
            desc = "Indicates that the supported AHCI version is V1.3.";
            sw = r; hw = w;
            reset = 0x10300;
        } achi_vs[31:0];
    } SATA_GHC_VS @ 0x10;
    reg {
        name = "SATA_GHC_CCC_CTL";
        desc = "SATA_GHC_CCC_CTL is the CCC control register. SATA_GHC_CCC_CTL (offset 0x0014, total reset 0x0001_01F8; PROVEN: Hi3535 data sheet, PDF page 1367, section 13.8.7.1).";
        field {
            name = "ccc_tv";
            desc = "CCC timeout parameter, in ms. When the CCC function is enabled, the timeout counter loads this value. While a port participating in the CCC function has a command executing, the counter decrements by 1 every 1 ms until it reaches 0 and generates a CCC interrupt. After the CCC interrupt is generated, the counter reloads this value for the next round of counting. This field must not be written with 0.";
            sw = rw; hw = r;
            reset = 0x1;
        } ccc_tv[31:16];
        field {
            name = "ccc_cc";
            desc = "CCC command completion upper limit. When the CCC function is enabled, the command completion counter is cleared and starts accumulating the number of command completions of the ports participating in the CCC function. When the counter reaches or exceeds this value, a CCC interrupt is generated, and after it is generated the counter is cleared and starts the next round of counting. If 0 is written to this field, the command completion interrupt is disabled, and the CCC interrupt can then be generated only by a timeout.";
            sw = rw; hw = r;
            reset = 0x1;
        } ccc_cc[15:8];
        field {
            name = "ccc_int";
            desc = "CCC interrupt vector number. Its value is 0x1F (31), meaning that SATA_GHC_IS bit[31] is the CCC interrupt status.";
            sw = r; hw = w;
            reset = 0x1f;
        } ccc_int[7:3];
        field {
            name = "reserved";
            desc = "Reserved.";
            sw = r; hw = w;
            reset = 0x0;
        } reserved_2_1[2:1];
        field {
            name = "ccc_en";
            desc = "CCC function enable.
- 0: Disable.
- 1: Enable. Note: While the CCC function is enabled, the values of the ccc_tv and ccc_cc parameters must not be changed.";
            sw = rw; hw = r;
            reset = 0x0;
        } ccc_en[0:0];
    } SATA_GHC_CCC_CTL @ 0x14;
    reg {
        name = "SATA_GHC_CCC_PORTS";
        desc = "SATA_GHC_CCC_PORTS is the CCC port enable register. SATA_GHC_CCC_PORTS (offset 0x0018, total reset 0x0000_0000; PROVEN: Hi3535 data sheet, PDF page 1368, section 13.8.7.1).";
        field {
            name = "reserved";
            desc = "Reserved.";
            sw = r; hw = w;
            reset = 0x0;
        } reserved_31_3[31:3];
        field {
            name = "ccc_prt";
            desc = "Specifies the ports that participate in the CCC function. bit[2] to bit[0] represent ports 2 to 0 respectively. A bit value of 1 means the port participates in CCC counting; 0 means it does not. This register can be changed at any time and takes effect immediately.";
            sw = rw; hw = r;
            reset = 0x0;
        } ccc_prt[2:0];
    } SATA_GHC_CCC_PORTS @ 0x18;
    reg {
        name = "SATA_GHC_CAP2";
        desc = "SATA_GHC_CAP2 is feature support register 2. SATA_GHC_CAP2 (offset 0x0024, total reset 0x0000_0001; PROVEN: Hi3535 data sheet, PDF page 1369, section 13.8.7.1).";
        field {
            name = "reserved";
            desc = "Reserved.";
            sw = r; hw = w;
            reset = 0x0;
        } reserved_31_1[31:1];
        field {
            name = "cap_boh";
            desc = "Fixed to 1, indicating support for BIOS/OS handoff control.";
            sw = r; hw = w;
            reset = 0x1;
        } cap_boh[0:0];
    } SATA_GHC_CAP2 @ 0x24;
    reg {
        name = "SATA_GHC_BOHC";
        desc = "SATA_GHC_BOHC is the BIOS/OS handoff control register. SATA_GHC_BOHC (offset 0x0028, total reset 0x0000_0000; PROVEN: Hi3535 data sheet, PDF page 1369, section 13.8.7.1).";
        field {
            name = "reserved";
            desc = "Reserved.";
            sw = r; hw = w;
            reset = 0x0;
        } reserved_31_5[31:5];
        field {
            name = "bohc_bb";
            desc = "BIOS busy status indication.
- 0: BIOS is not busy;
- 1: BIOS is busy completing the related operations and preparing to hand over control to the OS.";
            sw = rw; hw = r;
            reset = 0x0;
        } bohc_bb[4:4];
        field {
            name = "bohc_ooc";
            desc = "This bit is latched to 1 when the bohc_oos signal transitions from 0 to 1; write 1 to clear it, writing 0 has no effect. (data sheet access type WC)";
            sw = rw; hw = r; onwrite = woclr;
            reset = 0x0;
        } bohc_ooc[3:3];
        field {
            name = "bohc_sooe";
            desc = "Message interrupt enable.
- 0: No message interrupt is generated.
- 1: A message interrupt is generated when the bohc_ooc bit is set to 1.";
            sw = rw; hw = r;
            reset = 0x0;
        } bohc_sooe[2:2];
        field {
            name = "bohc_oos";
            desc = "Operating system controller request.
- 0: The OS has not requested control of the controller;
- 1: The OS requests control of the controller. If bohc_oos is 1 and bios_bos is 0, the operating system has taken control of the SATA controller. Resetting the controller with the SATA_GHC_GHC[hab_rst] bit does not affect this bit.";
            sw = rw; hw = r;
            reset = 0x0;
        } bohc_oos[1:1];
        field {
            name = "bohc_bos";
            desc = "BIOS owns-controller flag.
- 0: The BIOS does not own the controller;
- 1: The BIOS has taken ownership of the controller. If the operating system requests ownership of the controller, the BIOS clears this bit. Resetting the controller with the SATA_GHC_GHC[hab_rst] bit does not affect this bit.";
            sw = rw; hw = r;
            reset = 0x0;
        } bohc_bos[0:0];
    } SATA_GHC_BOHC @ 0x28;
    reg {
        name = "SATA_PHY0_CTLL";
        desc = "SATA_PHY0_CTLL is the PHY0 global control register, low part. SATA_PHY0_CTLL (offset 0x00A0, total reset 0x4980_003C; PROVEN: Hi3535 data sheet, PDF page 1370, section 13.8.7.1).";
        field {
            name = "los_bias";
            desc = "loss-of-signal detection voltage threshold setting. The value of this register must be set to 0x2.";
            sw = rw; hw = r;
            reset = 0x2;
        } los_bias[31:29];
        field {
            name = "los_level";
            desc = "Loss-of-signal detection voltage threshold setting. This register must be set to 0x9.";
            sw = rw; hw = r;
            reset = 0x9;
        } los_level[28:24];
        field {
            name = "ref_use_pad";
            desc = "Reference clock source select.
- 0: Select the chip CRG;
- 1: Select the external PAD.";
            sw = rw; hw = r;
            reset = 0x1;
        } ref_use_pad[23:23];
        field {
            name = "ssc_ref_clk_sel";
            desc = "spread spectrum clocking Shifting.";
            sw = rw; hw = r;
            reset = 0x0;
        } ssc_ref_clk_sel[22:14];
        field {
            name = "ssc_range";
            desc = "When ssc_en is active, indicates the clock frequency offset.
- 000: -4980;
- 001: -4492;
- 010: -4003;
- 011: -2000;
- 100: 4980;
- 101: 4492;
- 110: 4003;
- 111: 2000.";
            sw = rw; hw = r;
            reset = 0x0;
        } ssc_range[13:11];
        field {
            name = "ssc_en";
            desc = "Clock spread spectrum enable control signal.
- 0: Disable;
- 1: Enable.";
            sw = rw; hw = r;
            reset = 0x0;
        } ssc_en[10:10];
        field {
            name = "ref_ssp_en";
            desc = "Reference clock enable control signal.
- 0: Disable;
- 1: Enable.";
            sw = rw; hw = r;
            reset = 0x0;
        } ref_ssp_en[9:9];
        field {
            name = "ref_clkdiv2";
            desc = "Whether the input reference clock is divided. If the input reference clock is greater than 100MHz, this signal must be set to 1.";
            sw = rw; hw = r;
            reset = 0x0;
        } ref_clkdiv2[8:8];
        field {
            name = "mpll_multiplier";
            desc = "Controls the MPLL frequency output in the SerDes. The reference clock is multiplied by the corresponding factor to generate the required high-frequency clock. If the reference clock is 100 MHz, configure this as 0b0011110.";
            sw = rw; hw = r;
            reset = 0x1e;
        } mpll_multiplier[7:1];
        field {
            name = "reset";
            desc = "Reset signal, must be held for at least 5ns. Active high.";
            sw = rw; hw = r;
            reset = 0x0;
        } reset_[0:0];
    } SATA_PHY0_CTLL @ 0xa0;
    reg {
        name = "SATA_PHY0_CTLH";
        desc = "SATA_PHY0_CTLH is the PHY0 global control register, high part. SATA_PHY0_CTLH (offset 0x00A4, total reset 0x0000_0000; PROVEN: Hi3535 data sheet, PDF page 1371, section 13.8.7.1).";
        field {
            name = "reserved";
            desc = "Reserved.";
            sw = r; hw = w;
            reset = 0x0;
        } reserved_31_4[31:4];
        field {
            name = "data_invert";
            desc = "- 0: The endianness of the parallel data between the PHY and the SATA controller is the same.
- 1: The endianness of the parallel data between the PHY and the SATA controller is opposite.";
            sw = rw; hw = r;
            reset = 0x0;
        } data_invert[3:3];
        field {
            name = "test_powerdown";
            desc = "Test control signal that controls power-down of all circuits. Used during IDDQ testing.
- 0: No power-down.
- 1: Power-down.";
            sw = rw; hw = r;
            reset = 0x0;
        } test_powerdown[2:2];
        field {
            name = "test_bypass";
            desc = "Test control signal, set to 0.";
            sw = rw; hw = r;
            reset = 0x0;
        } test_bypass[1:1];
        field {
            name = "test_burnin";
            desc = "Test control signal, set to 0.";
            sw = rw; hw = r;
            reset = 0x0;
        } test_burnin[0:0];
    } SATA_PHY0_CTLH @ 0xa4;
    reg {
        name = "SATA_PHY0_STS";
        desc = "SATA_PHY0_STS is the PHY0 global status register. SATA_PHY0_STS (offset 0x00A8, total reset 0x0000_0000; PROVEN: Hi3535 data sheet, PDF page 1372, section 13.8.7.1).";
        field {
            name = "phy0_sts";
            desc = "SATA PHY0 common part status register.";
            sw = r; hw = w;
            reset = 0x0;
        } phy0_sts[31:0];
    } SATA_PHY0_STS @ 0xa8;
    reg {
        name = "SATA_PHY1_CTLL";
        desc = "SATA_PHY1_CTLL is the PHY1 global control register, low part. SATA_PHY1_CTLL (offset 0x00AC, total reset 0x4980_003C; PROVEN: Hi3535 data sheet, PDF page 1372, section 13.8.7.1).";
        field {
            name = "los_bias";
            desc = "loss-of-signal detection voltage threshold setting. The value of this register must be set to 0x2.";
            sw = rw; hw = r;
            reset = 0x2;
        } los_bias[31:29];
        field {
            name = "los_level";
            desc = "Loss-of-signal detection voltage threshold setting. This register must be set to 0x9.";
            sw = rw; hw = r;
            reset = 0x9;
        } los_level[28:24];
        field {
            name = "ref_use_pad";
            desc = "Reference clock source select.
- 0: Select the chip CRG;
- 1: Select the external PAD.";
            sw = rw; hw = r;
            reset = 0x1;
        } ref_use_pad[23:23];
        field {
            name = "ssc_ref_clk_sel";
            desc = "spread spectrum clocking Shifting.";
            sw = rw; hw = r;
            reset = 0x0;
        } ssc_ref_clk_sel[22:14];
        field {
            name = "ssc_range";
            desc = "When ssc_en is active, indicates the clock frequency offset.
- 000: -4980;
- 001: -4492;
- 010: -4003;
- 011: -2000;
- 100: 4980;
- 101: 4492;
- 110: 4003;
- 111: 2000.";
            sw = rw; hw = r;
            reset = 0x0;
        } ssc_range[13:11];
        field {
            name = "ssc_en";
            desc = "Clock spread spectrum enable control signal.
- 0: Disable;
- 1: Enable.";
            sw = rw; hw = r;
            reset = 0x0;
        } ssc_en[10:10];
        field {
            name = "ref_ssp_en";
            desc = "Reference clock enable control signal.
- 0: Disable;
- 1: Enable.";
            sw = rw; hw = r;
            reset = 0x0;
        } ref_ssp_en[9:9];
        field {
            name = "ref_clkdiv2";
            desc = "Controls whether the input reference clock is divided. If the input reference clock is greater than 100MHz, this signal must be set to 1.";
            sw = rw; hw = r;
            reset = 0x0;
        } ref_clkdiv2[8:8];
        field {
            name = "mpll_multiplier";
            desc = "Controls the MPLL frequency output in the SerDes. The reference clock is multiplied by the corresponding ratio to generate the required high-frequency clock. If the reference clock is 100MHz, configure this value as 0b0011110.";
            sw = rw; hw = r;
            reset = 0x1e;
        } mpll_multiplier[7:1];
        field {
            name = "reset";
            desc = "Reset signal, must be held for at least 5ns. Active high.";
            sw = rw; hw = r;
            reset = 0x0;
        } reset_[0:0];
    } SATA_PHY1_CTLL @ 0xac;
    reg {
        name = "SATA_PHY1_CTLH";
        desc = "SATA_PHY1_CTLH is the PHY1 global control register (high bits). SATA_PHY1_CTLH (offset 0x00B0, total reset 0x0000_0000; PROVEN: Hi3535 data sheet, PDF page 1374, section 13.8.7.1).";
        field {
            name = "reserved";
            desc = "Reserved.";
            sw = r; hw = w;
            reset = 0x0;
        } reserved_31_4[31:4];
        field {
            name = "data_invert";
            desc = "- 0: The endianness of the parallel data between the PHY and the SATA controller is the same.
- 1: The endianness of the parallel data between the PHY and the SATA controller is opposite.";
            sw = rw; hw = r;
            reset = 0x0;
        } data_invert[3:3];
        field {
            name = "test_powerdown";
            desc = "Test control signal that controls power-down of all circuits. Used during IDDQ testing.
- 0: No power-down.
- 1: Power-down.";
            sw = rw; hw = r;
            reset = 0x0;
        } test_powerdown[2:2];
        field {
            name = "test_bypass";
            desc = "Test control signal, set to 0.";
            sw = rw; hw = r;
            reset = 0x0;
        } test_bypass[1:1];
        field {
            name = "test_burnin";
            desc = "Test control signal, set to 0.";
            sw = rw; hw = r;
            reset = 0x0;
        } test_burnin[0:0];
    } SATA_PHY1_CTLH @ 0xb0;
    reg {
        name = "SATA_PHY1_STS";
        desc = "SATA_PHY1_STS is the PHY1 global status register. SATA_PHY1_STS (offset 0x00B4, total reset 0x0000_0000; PROVEN: Hi3535 data sheet, PDF page 1374, section 13.8.7.1).";
        field {
            name = "phy1_sts";
            desc = "SATA PHY1 common part status register.";
            sw = r; hw = w;
            reset = 0x0;
        } phy1_sts[31:0];
    } SATA_PHY1_STS @ 0xb4;
    reg {
        name = "SATA_OOB_CTL";
        desc = "SATA_OOB_CTL is the PHY OOB control register. SATA_OOB_CTL (offset 0x00B8, total reset 0x8406_0C15; PROVEN: Hi3535 data sheet, PDF page 1375, section 13.8.7.1).";
        field {
            name = "oob_ctrl_valid";
            desc = "OOB detection parameter configuration bit; when high, the parameter configuration of this register is selected.";
            sw = rw; hw = r;
            reset = 0x1;
        } oob_ctrl_valid[31:31];
        field {
            name = "min_comiwake";
            desc = "Minimum space count required for COMWAKE space detection.";
            sw = rw; hw = r;
            reset = 0x4;
        } min_comiwake[30:24];
        field {
            name = "max_comwake";
            desc = "Maximum space count required for COMWAKE space detection.";
            sw = rw; hw = r;
            reset = 0x6;
        } max_comwake[23:16];
        field {
            name = "min_cominit";
            desc = "Minimum space count value required for COMINIT space detection.";
            sw = rw; hw = r;
            reset = 0xc;
        } min_cominit[15:8];
        field {
            name = "max_cominit";
            desc = "Maximum space count required for COMINIT space detection.";
            sw = rw; hw = r;
            reset = 0x15;
        } max_cominit[7:0];
    } SATA_OOB_CTL @ 0xb8;
    reg {
        name = "SATA_AXI_DFX0";
        desc = "SATA_AXI_DFX0 is the control register of the SATA AXI bus. SATA_AXI_DFX0 (offset 0x00BC, total reset 0x0000_0000; PROVEN: Hi3535 data sheet, PDF page 1375, section 13.8.7.1).";
        field {
            name = "reserved";
            desc = "Reserved.";
            sw = r; hw = w;
            reset = 0x0;
        } reserved_31_30[31:30];
        field {
            name = "rd_otd_en";
            desc = "Whether to limit the maximum outstanding capability of AXI Master read operations.
- 0: Disable.
- 1: Enable.";
            sw = rw; hw = r;
            reset = 0x0;
        } rd_otd_en[29:29];
        field {
            name = "rd_otd_ctrl";
            desc = "Controls the maximum outstanding capability supported for AXI Master read operations.
- 0000: Outstanding of 1 supported;
- 0001: Outstanding of 2 supported;
- 0011: Outstanding of 4 supported;
Other values: reserved.";
            sw = rw; hw = r;
            reset = 0x0;
        } rd_otd_ctrl[28:25];
        field {
            name = "wr_otd_en";
            desc = "Whether to control the maximum outstanding capability supported for AXI Master write operations.
- 0: Disable;
- 1: Enable.";
            sw = rw; hw = r;
            reset = 0x0;
        } wr_otd_en[24:24];
        field {
            name = "wr_otd_ctrl";
            desc = "Controls the maximum outstanding capability supported for AXI Master write operations.
- 0000: Outstanding of 1 supported;
- 0001: Outstanding of 2 supported;
- 0011: Outstanding of 4 supported; Others: Reserved.";
            sw = rw; hw = r;
            reset = 0x0;
        } wr_otd_ctrl[23:20];
        field {
            name = "reserved";
            desc = "Reserved.";
            sw = r; hw = w;
            reset = 0x0;
        } reserved_19_18[19:18];
        field {
            name = "cnt_wr5";
            desc = "Whether the write-channel-direction DFX function of internal AXI channel 7 (SATA Port2 RX DMAC) is enabled, active high.
- 0: Disable;
- 1: Enable.";
            sw = rw; hw = r;
            reset = 0x0;
        } cnt_wr5[17:17];
        field {
            name = "cnt_wr4";
            desc = "Whether to enable the DFX function in the write channel direction for internal AXI channel 7 (SATA Port2 TX DMAC), active high.
- 0: Disable.
- 1: Enable.";
            sw = rw; hw = r;
            reset = 0x0;
        } cnt_wr4[16:16];
        field {
            name = "cnt_wr3";
            desc = "Whether to enable the DFX function in the write channel direction for internal AXI channel 7 (SATA Port1 RX DMAC), active high.
- 0: Disable.
- 1: Enable.";
            sw = rw; hw = r;
            reset = 0x0;
        } cnt_wr3[15:15];
        field {
            name = "cnt_wr2";
            desc = "Whether the DFX function in the write channel direction is enabled for AXI internal channel 7 (SATA Port1 TX DMAC); active high.
- 0: Disable;
- 1: Enable.";
            sw = rw; hw = r;
            reset = 0x0;
        } cnt_wr2[14:14];
        field {
            name = "cnt_wr1";
            desc = "Whether the DFX function in the write channel direction is enabled for AXI internal channel 7 (SATA Port0 RX DMAC); active high.
- 0: Disable;
- 1: Enable.";
            sw = rw; hw = r;
            reset = 0x0;
        } cnt_wr1[13:13];
        field {
            name = "cnt_wr0";
            desc = "Whether the write-channel-direction DFX function of internal AXI channel 7 (SATA Port0 TX DMAC) is enabled, active high.
- 0: Disable;
- 1: Enable.";
            sw = rw; hw = r;
            reset = 0x0;
        } cnt_wr0[12:12];
        field {
            name = "reserved";
            desc = "Reserved.";
            sw = r; hw = w;
            reset = 0x0;
        } reserved_11_10[11:10];
        field {
            name = "cnt_rd5";
            desc = "Whether the DFX function in the read channel direction of internal AXI channel 7 (SATA Port2 RX DMAC) is enabled, active high.
- 0: Disable.
- 1: Enable.";
            sw = rw; hw = r;
            reset = 0x0;
        } cnt_rd5[9:9];
        field {
            name = "cnt_rd4";
            desc = "Whether the DFX function for the read channel direction of internal AXI channel 7 (SATA Port2 TX DMAC) is enabled, active high.
- 0: Disable;
- 1: Enable.";
            sw = rw; hw = r;
            reset = 0x0;
        } cnt_rd4[8:8];
        field {
            name = "cnt_rd3";
            desc = "Whether the DFX function for the read channel direction of internal AXI channel 7 (SATA Port1 RX DMAC) is enabled, active high.
- 0: Disable;
- 1: Enable.";
            sw = rw; hw = r;
            reset = 0x0;
        } cnt_rd3[7:7];
        field {
            name = "cnt_rd2";
            desc = "Whether the read-channel DFX function is enabled for internal AXI channel 7 (SATA Port1 TX DMAC), active high.
- 0: Disable;
- 1: Enable.";
            sw = rw; hw = r;
            reset = 0x0;
        } cnt_rd2[6:6];
        field {
            name = "cnt_rd1";
            desc = "Whether the read-channel DFX function is enabled for internal AXI channel 7 (SATA Port0 RX DMAC), active high.
- 0: Disable;
- 1: Enable.";
            sw = rw; hw = r;
            reset = 0x0;
        } cnt_rd1[5:5];
        field {
            name = "cnt_rd0";
            desc = "Whether the DFX function in the read channel direction of internal AXI channel 7 (SATA Port0 TX DMAC) is enabled, active high.
- 0: Disable.
- 1: Enable.";
            sw = rw; hw = r;
            reset = 0x0;
        } cnt_rd0[4:4];
        field {
            name = "cnt_wr_latency_clr";
            desc = "Clear the latency-related debug registers of the current write channel, active high.
- 0: Do not clear;
- 1: Clear.";
            sw = rw; hw = r;
            reset = 0x0;
        } cnt_wr_latency_clr[3:3];
        field {
            name = "cnt_wr_acc_clr";
            desc = "Clear the debug register holding the total number of commands of the current write channel, active high.
- 0: Do not clear.
- 1: Clear.";
            sw = rw; hw = r;
            reset = 0x0;
        } cnt_wr_acc_clr[2:2];
        field {
            name = "cnt_rd_latency_clr";
            desc = "Clear the latency-related debug registers of the current read channel, active high.
- 0: Do not clear.
- 1: Clear.";
            sw = rw; hw = r;
            reset = 0x0;
        } cnt_rd_latency_clr[1:1];
        field {
            name = "cnt_rd_acc_clr";
            desc = "Clear the debug register of the total number of commands of the current read channel, active high.
- 0: Do not clear.
- 1: Clear.";
            sw = rw; hw = r;
            reset = 0x0;
        } cnt_rd_acc_clr[0:0];
    } SATA_AXI_DFX0 @ 0xbc;
    reg {
        name = "SATA_AXI_DFX1";
        desc = "SATA_AXI_DFX1 is status register 1 of the SATA AXI bus. SATA_AXI_DFX1 (offset 0x00C0, total reset 0x0000_0000; PROVEN: Hi3535 data sheet, PDF page 1378, section 13.8.7.1).";
        field {
            name = "reserved";
            desc = "Reserved.";
            sw = r; hw = w;
            reset = 0x0;
        } reserved_31_16[31:16];
        field {
            name = "cnt_rd_latency_max";
            desc = "DFX signal: maximum latency of the current read channel, in cycles.";
            sw = r; hw = w;
            reset = 0x0;
        } cnt_rd_latency_max[15:0];
    } SATA_AXI_DFX1 @ 0xc0;
    reg {
        name = "SATA_AXI_DFX2";
        desc = "SATA_AXI_DFX2 is SATA AXI bus status register 2. SATA_AXI_DFX2 (offset 0x00C4, total reset 0x0000_001F; PROVEN: Hi3535 data sheet, PDF page 1378, section 13.8.7.1).";
        field {
            name = "reserved";
            desc = "Reserved.";
            sw = r; hw = w;
            reset = 0x0;
        } reserved_31_16[31:16];
        field {
            name = "cnt_rd_latency_avg";
            desc = "DFX signal: average latency of the current read channel, in cycles.";
            sw = r; hw = w;
            reset = 0x1f;
        } cnt_rd_latency_avg[15:0];
    } SATA_AXI_DFX2 @ 0xc4;
    reg {
        name = "SATA_AXI_DFX3";
        desc = "SATA_AXI_DFX3 is status register 3 of the SATA AXI bus. SATA_AXI_DFX3 (offset 0x00C8, total reset 0x0000_0000; PROVEN: Hi3535 data sheet, PDF page 1379, section 13.8.7.1).";
        field {
            name = "reserved";
            desc = "Reserved.";
            sw = r; hw = w;
            reset = 0x0;
        } reserved_31_16[31:16];
        field {
            name = "cnt_wr_latency_max";
            desc = "DFX signal, maximum latency of the current write channel, in cycles.";
            sw = r; hw = w;
            reset = 0x0;
        } cnt_wr_latency_max[15:0];
    } SATA_AXI_DFX3 @ 0xc8;
    reg {
        name = "SATA_AXI_DFX4";
        desc = "SATA_AXI_DFX4 is status register 4 of the SATA AXI bus. SATA_AXI_DFX4 (offset 0x00CC, total reset 0x0000_001F; PROVEN: Hi3535 data sheet, PDF page 1379, section 13.8.7.1).";
        field {
            name = "reserved";
            desc = "Reserved.";
            sw = r; hw = w;
            reset = 0x0;
        } reserved_31_16[31:16];
        field {
            name = "cnt_wr_latency_avg";
            desc = "DFX signal: average latency of the current write channel, in cycles.";
            sw = r; hw = w;
            reset = 0x1f;
        } cnt_wr_latency_avg[15:0];
    } SATA_AXI_DFX4 @ 0xcc;
    reg {
        name = "SATA_AXI_DFX5";
        desc = "SATA_AXI_DFX5 is SATA AXI bus status register 5. SATA_AXI_DFX5 (offset 0x00D0, total reset 0x0000_0000; PROVEN: Hi3535 data sheet, PDF page 1380, section 13.8.7.1).";
        field {
            name = "cnt_rd_acc3";
            desc = "DFX signal: total number of read commands currently on AXI master Port3, corresponding to SATA Port1 RX DAMC.";
            sw = r; hw = w;
            reset = 0x0;
        } cnt_rd_acc3[31:24];
        field {
            name = "cnt_rd_acc2";
            desc = "DFX signal: total number of read commands of the current AXI masterPort2, corresponding to SATA Port1 TX DMAC.";
            sw = r; hw = w;
            reset = 0x0;
        } cnt_rd_acc2[23:16];
        field {
            name = "cnt_rd_acc1";
            desc = "DFX signal, total number of read commands of the current AXI masterPort1, corresponding to SATA Port0 RX DAMC.";
            sw = r; hw = w;
            reset = 0x0;
        } cnt_rd_acc1[15:8];
        field {
            name = "cnt_rd_acc0";
            desc = "DFX signal: total number of read commands of the current AXI master Port0, corresponding to SATA Port0 TX DMAC.";
            sw = r; hw = w;
            reset = 0x0;
        } cnt_rd_acc0[7:0];
    } SATA_AXI_DFX5 @ 0xd0;
    reg {
        name = "SATA_AXI_DFX6";
        desc = "SATA_AXI_DFX6 is status register 6 of the SATA AXI bus. SATA_AXI_DFX6 (offset 0x00D4, total reset 0x0000_0000; PROVEN: Hi3535 data sheet, PDF page 1380, section 13.8.7.1).";
        field {
            name = "reserved";
            desc = "Reserved.";
            sw = r; hw = w;
            reset = 0x0;
        } reserved_31_16[31:16];
        field {
            name = "cnt_rd_acc5";
            desc = "DFX signal: total number of read commands of the current AXI masterPort5, corresponding to SATA Port2 RX DMAC.";
            sw = r; hw = w;
            reset = 0x0;
        } cnt_rd_acc5[15:8];
        field {
            name = "cnt_rd_acc4";
            desc = "DFX signal, total number of read commands of the current AXI masterPort4, corresponding to SATA Port2 TX DAMC.";
            sw = r; hw = w;
            reset = 0x0;
        } cnt_rd_acc4[7:0];
    } SATA_AXI_DFX6 @ 0xd4;
    reg {
        name = "SATA_AXI_DFX7";
        desc = "SATA_AXI_DFX7 is status register 7 of the SATA AXI bus. SATA_AXI_DFX7 (offset 0x00D8, total reset 0x0000_0000; PROVEN: Hi3535 data sheet, PDF page 1381, section 13.8.7.1).";
        field {
            name = "cnt_wr_acc3";
            desc = "DFX signal, total number of write commands of the current AXI masterPort3, corresponding to SATA Port1 RX DAMC.";
            sw = r; hw = w;
            reset = 0x0;
        } cnt_wr_acc3[31:24];
        field {
            name = "cnt_wr_acc2";
            desc = "DFX signal: total number of write commands of the current AXI master Port2, corresponding to SATA Port1 TX DMAC.";
            sw = r; hw = w;
            reset = 0x0;
        } cnt_wr_acc2[23:16];
        field {
            name = "cnt_wr_acc1";
            desc = "DFX signal: total number of write commands of the current AXI masterPort1, corresponding to SATA Port0 RX DMAC.";
            sw = r; hw = w;
            reset = 0x0;
        } cnt_wr_acc1[15:8];
        field {
            name = "cnt_wr_acc0";
            desc = "DFX signal: total number of write commands of the current AXI masterPort0, corresponding to SATA Port0 TX DAMC.";
            sw = r; hw = w;
            reset = 0x0;
        } cnt_wr_acc0[7:0];
    } SATA_AXI_DFX7 @ 0xd8;
    reg {
        name = "SATA_AXI_DFX8";
        desc = "SATA_AXI_DFX8 is SATA AXI bus status register 8. SATA_AXI_DFX8 (offset 0x00DC, total reset 0x0000_0000; PROVEN: Hi3535 data sheet, PDF page 1381, section 13.8.7.1).";
        field {
            name = "reserved";
            desc = "Reserved.";
            sw = r; hw = w;
            reset = 0x0;
        } reserved_31_16[31:16];
        field {
            name = "cnt_wr_acc5";
            desc = "DFX signal: total number of write commands of the current AXI master Port5, corresponding to SATA Port2 RX DMAC.";
            sw = r; hw = w;
            reset = 0x0;
        } cnt_wr_acc5[15:8];
        field {
            name = "cnt_wr_acc4";
            desc = "DFX signal: total number of write commands of the current AXI masterPort4, corresponding to SATA Port2 TX DMAC.";
            sw = r; hw = w;
            reset = 0x0;
        } cnt_wr_acc4[7:0];
    } SATA_AXI_DFX8 @ 0xdc;
    reg {
        name = "SATA_AXI_DFX9";
        desc = "SATA_AXI_DFX9 is status register 9 of the SATA AXI bus. SATA_AXI_DFX9 (offset 0x00E0, total reset 0x0000_0000; PROVEN: Hi3535 data sheet, PDF page 1382, section 13.8.7.1).";
        field {
            name = "cnt_rd_otd3";
            desc = "DFX signal: total number of outstanding read commands of the current AXI master Port3, corresponding to SATA Port1 RX DMAC.";
            sw = r; hw = w;
            reset = 0x0;
        } cnt_rd_otd3[31:24];
        field {
            name = "cnt_rd_otd2";
            desc = "DFX signal: total number of read outstanding commands currently on AXI master Port2, corresponding to SATA Port1 TX DAMC.";
            sw = r; hw = w;
            reset = 0x0;
        } cnt_rd_otd2[23:16];
        field {
            name = "cnt_rd_otd1";
            desc = "DFX signal: total number of read outstanding commands of the current AXI masterPort1, corresponding to SATA Port0 RX DAMC.";
            sw = r; hw = w;
            reset = 0x0;
        } cnt_rd_otd1[15:8];
        field {
            name = "cnt_rd_otd0";
            desc = "DFX signal, total number of outstanding read commands of the current AXI masterPort0, corresponding to SATA Port0 TX DAMC.";
            sw = r; hw = w;
            reset = 0x0;
        } cnt_rd_otd0[7:0];
    } SATA_AXI_DFX9 @ 0xe0;
    reg {
        name = "SATA_AXI_DFX10";
        desc = "SATA_AXI_DFX10 is SATA AXI bus status register 10. SATA_AXI_DFX10 (offset 0x00E4, total reset 0x0000_0000; PROVEN: Hi3535 data sheet, PDF page 1382, section 13.8.7.1).";
        field {
            name = "reserved";
            desc = "Reserved.";
            sw = r; hw = w;
            reset = 0x0;
        } reserved_31_16[31:16];
        field {
            name = "cnt_rd_otd5";
            desc = "DFX signal, the current total number of outstanding read commands of AXI masterPort5, corresponding to SATA Port2 RX DAMC.";
            sw = r; hw = w;
            reset = 0x0;
        } cnt_rd_otd5[15:8];
        field {
            name = "cnt_rd_otd4";
            desc = "DFX signal: total number of read outstanding commands currently on AXI master Port4, corresponding to SATA Port2 TX DAMC.";
            sw = r; hw = w;
            reset = 0x0;
        } cnt_rd_otd4[7:0];
    } SATA_AXI_DFX10 @ 0xe4;
    reg {
        name = "SATA_AXI_DFX11";
        desc = "SATA_AXI_DFX11 is status register 11 of the SATA AXI bus. SATA_AXI_DFX11 (offset 0x00E8, total reset 0x0000_0000; PROVEN: Hi3535 data sheet, PDF page 1383, section 13.8.7.1).";
        field {
            name = "cnt_wr_otd3";
            desc = "DFX signal: total number of write outstanding commands of the current AXI masterPort3, corresponding to SATA Port1 RX DAMC.";
            sw = r; hw = w;
            reset = 0x0;
        } cnt_wr_otd3[31:24];
        field {
            name = "cnt_wr_otd2";
            desc = "DFX signal, the current total number of outstanding write commands of AXI masterPort2, corresponding to SATA Port1 TX DAMC.";
            sw = r; hw = w;
            reset = 0x0;
        } cnt_wr_otd2[23:16];
        field {
            name = "cnt_wr_otd1";
            desc = "DFX signal: total number of write outstanding commands currently on AXI master Port1, corresponding to SATA Port0 RX DAMC.";
            sw = r; hw = w;
            reset = 0x0;
        } cnt_wr_otd1[15:8];
        field {
            name = "cnt_wr_otd0";
            desc = "DFX signal: total number of outstanding write commands of the current AXI masterPort0, corresponding to SATA Port0 TX DMAC.";
            sw = r; hw = w;
            reset = 0x0;
        } cnt_wr_otd0[7:0];
    } SATA_AXI_DFX11 @ 0xe8;
    reg {
        name = "SATA_AXI_DFX12";
        desc = "SATA_AXI_DFX12 is status register 12 of the SATA AXI bus. SATA_AXI_DFX12 (offset 0x00EC, total reset 0x0000_0000; PROVEN: Hi3535 data sheet, PDF page 1383, section 13.8.7.1).";
        field {
            name = "reserved";
            desc = "Reserved.";
            sw = r; hw = w;
            reset = 0x0;
        } reserved_31_16[31:16];
        field {
            name = "cnt_wr_otd5";
            desc = "DFX signal: total number of write outstanding commands of the current AXI masterPort5, corresponding to SATA Port2 RX DAMC.";
            sw = r; hw = w;
            reset = 0x0;
        } cnt_wr_otd5[15:8];
        field {
            name = "cnt_wr_otd4";
            desc = "DFX signal, the current total number of outstanding write commands of AXI masterPort4, corresponding to SATA Port2 TX DAMC.";
            sw = r; hw = w;
            reset = 0x0;
        } cnt_wr_otd4[7:0];
    } SATA_AXI_DFX12 @ 0xec;
    reg {
        name = "SATA_PHY2_CTLL";
        desc = "SATA_PHY2_CTLL is the PHY2 global control register, low bits. SATA_PHY2_CTLL (offset 0x00F0, total reset 0x4980_003C; PROVEN: Hi3535 data sheet, PDF page 1384, section 13.8.7.1).";
        field {
            name = "los_bias";
            desc = "loss-of-signal detection voltage threshold setting. The value of this register must be set to 0x2.";
            sw = rw; hw = r;
            reset = 0x2;
        } los_bias[31:29];
        field {
            name = "los_level";
            desc = "Loss-of-signal detection voltage threshold setting. This register must be set to 0x9.";
            sw = rw; hw = r;
            reset = 0x9;
        } los_level[28:24];
        field {
            name = "ref_use_pad";
            desc = "Reference clock source select.
- 0: Select the chip CRG;
- 1: Select the external PAD.";
            sw = rw; hw = r;
            reset = 0x1;
        } ref_use_pad[23:23];
        field {
            name = "ssc_ref_clk_sel";
            desc = "spread spectrum clocking Shifting.";
            sw = rw; hw = r;
            reset = 0x0;
        } ssc_ref_clk_sel[22:14];
        field {
            name = "ssc_range";
            desc = "When ssc_en is active, indicates the clock frequency offset.
- 000: -4980;
- 001: -4492;
- 010: -4003;
- 011: -2000;
- 100: 4980;
- 101: 4492;
- 110: 4003;
- 111: 2000.";
            sw = rw; hw = r;
            reset = 0x0;
        } ssc_range[13:11];
        field {
            name = "ssc_en";
            desc = "Clock spread spectrum enable control signal.
- 0: Disable;
- 1: Enable.";
            sw = rw; hw = r;
            reset = 0x0;
        } ssc_en[10:10];
        field {
            name = "ref_ssp_en";
            desc = "Reference clock enable control signal.
- 0: Disable;
- 1: Enable.";
            sw = rw; hw = r;
            reset = 0x0;
        } ref_ssp_en[9:9];
        field {
            name = "ref_clkdiv2";
            desc = "Whether the input reference clock is divided. If the input reference clock is greater than 100MHz, this signal must be set to 1.";
            sw = rw; hw = r;
            reset = 0x0;
        } ref_clkdiv2[8:8];
        field {
            name = "mpll_multiplier";
            desc = "Controls the MPLL frequency output in the SerDes. The reference clock is multiplied by the corresponding ratio to generate the required high-frequency clock. If the reference clock is 100MHz, configure this value as 7'b0011110.";
            sw = rw; hw = r;
            reset = 0x1e;
        } mpll_multiplier[7:1];
        field {
            name = "reset";
            desc = "Reset signal, must be held for at least 5ns. Active high.";
            sw = rw; hw = r;
            reset = 0x0;
        } reset_[0:0];
    } SATA_PHY2_CTLL @ 0xf0;
    reg {
        name = "SATA_PHY2_CTLH";
        desc = "SATA_PHY2_CTLH is the PHY2 global control register, high part. SATA_PHY2_CTLH (offset 0x00F4, total reset 0x0000_0000; PROVEN: Hi3535 data sheet, PDF page 1385, section 13.8.7.1).";
        field {
            name = "reserved";
            desc = "Reserved.";
            sw = r; hw = w;
            reset = 0x0;
        } reserved_31_4[31:4];
        field {
            name = "data_invert";
            desc = "- 0: The endianness of the parallel data between the PHY and the SATA controller is the same.
- 1: The endianness of the parallel data between the PHY and the SATA controller is opposite.";
            sw = rw; hw = r;
            reset = 0x0;
        } data_invert[3:3];
        field {
            name = "test_powerdown";
            desc = "Test control signal that controls power-down of all circuits. Used during IDDQ testing.
- 0: No power-down;
- 1: Power-down.";
            sw = rw; hw = r;
            reset = 0x0;
        } test_powerdown[2:2];
        field {
            name = "test_bypass";
            desc = "Test control signal, set to 0.";
            sw = rw; hw = r;
            reset = 0x0;
        } test_bypass[1:1];
        field {
            name = "test_burnin";
            desc = "Test control signal, set to 0.";
            sw = rw; hw = r;
            reset = 0x0;
        } test_burnin[0:0];
    } SATA_PHY2_CTLH @ 0xf4;
    reg {
        name = "SATA_PHY2_STS";
        desc = "SATA_PHY2_STS is the PHY2 global status register. SATA_PHY2_STS (offset 0x00F8, total reset 0x0000_0000; PROVEN: Hi3535 data sheet, PDF page 1386, section 13.8.7.1).";
        field {
            name = "Phy2_sts";
            desc = "SATA PHY2 common part status register.";
            sw = r; hw = w;
            reset = 0x0;
        } Phy2_sts[31:0];
    } SATA_PHY2_STS @ 0xf8;
};

`endif
