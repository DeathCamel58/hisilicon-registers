`ifndef EHI3535_DDRC_AXI_RDL
`define EHI3535_DDRC_AXI_RDL
regfile eHI3535_DDRC_AXI {
    name = "DDRC AXI module";
    desc = "DDRC AXI module. 14 registers extracted programmatically from the Hi3535 H.264 codec processor (Hi3535 user guide) data sheet (Issue 00B08, 2014-02-25); chapter 4.1.5, tables 4-1/4-2. Field names, bit ranges, access types and reset values are taken from the register tables; reset values are the data sheet total reset values split onto the fields (per-field values where the table has them). Label: PROVEN. Hardware not verified here (no board).";
    reg {
        name = "AXI_CONFIG";
        desc = "AXI_CONFIG is the register that configures DDRC functions. AXI_CONFIG (offset 0x000, total reset 0x0006_000C; PROVEN: Hi3535 data sheet, PDF page 600, section 4.1.5.2).";
        field {
            name = "reserved";
            desc = "Reserved.";
            sw = r; hw = w;
            reset = 0x0;
        } reserved_31_19[31:19];
        field {
            name = "wr_rcv_mode";
            desc = "AXI port write command receive mode select.
- 0: Write commands are received directly.
- 1: A write command is received only after its corresponding write data has arrived.";
            sw = rw; hw = r;
            reset = 0x1;
        } wr_rcv_mode[18:18];
        field {
            name = "exclusive_en";
            desc = "Exclusive command enable.
- 0: Disable.
- 1: Enable.";
            sw = rw; hw = r;
            reset = 0x1;
        } exclusive_en[17:17];
        field {
            name = "rd_wrap_split_en";
            desc = "WRAP read command split enable.
- 0: No split.
- 1: Split.";
            sw = rw; hw = r;
            reset = 0x0;
        } rd_wrap_split_en[16:16];
        field {
            name = "reserved";
            desc = "Reserved.";
            sw = r; hw = w;
            reset = 0x0;
        } reserved_15_4[15:4];
        field {
            name = "bank_width";
            desc = "BANK width configuration.
- 1000: 256 bits.
- 1001: 512 bits.
- 1010: 1 kb.
- 1011: 2 kb.
- 1100: 4 kb.
- 1101: 8 kb.
- 1110: 16 kb.
- 1111: 32 kb. Others: Reserved. Example: For a 32-bit DDR device with column=10, bank_width=(32/8) x (2^10)=4k. Note: When the DDR3 SDRAM data bus width is configured as 32-bit and the capacity ratio of the upper 16-bit to the lower 16-bit DDR3 SDRAM is 1:2, it must be configured as 1011. Note: When mem_width is 16-bit, configure 1011; when mem_width is 32-bit, configure 1100 or any smaller value.";
            sw = rw; hw = r;
            reset = 0xc;
        } bank_width[3:0];
    } AXI_CONFIG @ 0x0;
    reg {
        name = "AXI_CKGCFG";
        desc = "AXI_CKGCFG is the DDRC clock gating configuration register. AXI_CKGCFG (offset 0x004, total reset 0x0310_007F; PROVEN: Hi3535 data sheet, PDF page 601, section 4.1.5.2).";
        field {
            name = "reserved";
            desc = "Reserved.";
            sw = rw; hw = r;
            reset = 0x1;
        } reserved_31_25[31:25];
        field {
            name = "sta_ckg_dmc0";
            desc = "Static clock gating of DMC0.
- 0: Clock off;
- 1: Clock enabled. Note: Hi3535 supports only one DMC.";
            sw = rw; hw = r;
            reset = 0x1;
        } sta_ckg_dmc0[24:24];
        field {
            name = "reserved";
            desc = "Reserved.";
            sw = r; hw = w;
            reset = 0x0;
        } reserved_23_21[23:21];
        field {
            name = "sta_ckg_apb";
            desc = "Static clock gating of the register configuration module.
- 0: Clock off;
- 1: Clock on.";
            sw = rw; hw = r;
            reset = 0x1;
        } sta_ckg_apb[20:20];
        field {
            name = "reserved";
            desc = "Reserved.";
            sw = r; hw = w;
            reset = 0x0;
        } reserved_19_7[19:7];
        field {
            name = "dyn_ckg_axi6";
            desc = "Dynamic clock gating of AXI port 6.
- 0: Clock always on;
- 1: The clock is gated automatically when the module is idle.";
            sw = rw; hw = r;
            reset = 0x1;
        } dyn_ckg_axi6[6:6];
        field {
            name = "dyn_ckg_axi5";
            desc = "Dynamic clock gating of AXI port 5.
- 0: Clock always on;
- 1: The clock is gated automatically when the module is idle.";
            sw = rw; hw = r;
            reset = 0x1;
        } dyn_ckg_axi5[5:5];
        field {
            name = "dyn_ckg_axi4";
            desc = "Dynamic clock gating of AXI port 4.
- 0: Clock always on.
- 1: The clock is gated automatically when the module is idle.";
            sw = rw; hw = r;
            reset = 0x1;
        } dyn_ckg_axi4[4:4];
        field {
            name = "dyn_ckg_axi3";
            desc = "Dynamic clock gating of AXI port 3.
- 0: Clock always on;
- 1: The clock is automatically gated when the module is idle.";
            sw = rw; hw = r;
            reset = 0x1;
        } dyn_ckg_axi3[3:3];
        field {
            name = "dyn_ckg_axi2";
            desc = "Dynamic clock gating of AXI port 2.
- 0: Clock always on.
- 1: The clock is gated automatically when the module is idle.";
            sw = rw; hw = r;
            reset = 0x1;
        } dyn_ckg_axi2[2:2];
        field {
            name = "dyn_ckg_axi1";
            desc = "Dynamic clock gating of AXI port 1.
- 0: Clock always on;
- 1: The clock is gated automatically when the module is idle.";
            sw = rw; hw = r;
            reset = 0x1;
        } dyn_ckg_axi1[1:1];
        field {
            name = "dyn_ckg_axi0";
            desc = "Dynamic clock gating of AXI port 0.
- 0: Clock always on.
- 1: The clock is gated automatically when the module is idle.";
            sw = rw; hw = r;
            reset = 0x1;
        } dyn_ckg_axi0[0:0];
    } AXI_CKGCFG @ 0x4;
    reg {
        name = "AXI_STATUS";
        desc = "AXI_STATUS is the DDRC interface status register. AXI_STATUS (offset 0x01C, total reset 0x0000_0000; PROVEN: Hi3535 data sheet, PDF page 603, section 4.1.5.2).";
        field {
            name = "reserved";
            desc = "Reserved.";
            sw = r; hw = w;
            reset = 0x0;
        } reserved_31_7[31:7];
        field {
            name = "axist6";
            desc = "Controller bus interface 6 status.
- 0: Idle;
- 1: Command executing.";
            sw = r; hw = w;
            reset = 0x0;
        } axist6[6:6];
        field {
            name = "axist5";
            desc = "Controller bus interface 5 status.
- 0: Idle;
- 1: A command is executing.";
            sw = r; hw = w;
            reset = 0x0;
        } axist5[5:5];
        field {
            name = "axist4";
            desc = "Controller bus interface 4 status.
- 0: Idle.
- 1: A command is executing.";
            sw = r; hw = w;
            reset = 0x0;
        } axist4[4:4];
        field {
            name = "axist3";
            desc = "Controller bus interface 3 status.
- 0: Idle;
- 1: A command is executing.";
            sw = r; hw = w;
            reset = 0x0;
        } axist3[3:3];
        field {
            name = "axist2";
            desc = "Controller bus interface 2 status.
- 0: Idle;
- 1: Command executing.";
            sw = r; hw = w;
            reset = 0x0;
        } axist2[2:2];
        field {
            name = "axist1";
            desc = "Controller bus interface 1 status.
- 0: Idle;
- 1: Command executing.";
            sw = r; hw = w;
            reset = 0x0;
        } axist1[1:1];
        field {
            name = "axist0";
            desc = "Controller bus interface 0 status.
- 0: Idle;
- 1: A command is executing.";
            sw = r; hw = w;
            reset = 0x0;
        } axist0[0:0];
    } AXI_STATUS @ 0x1c;
    reg {
        name = "AXI_QOSCFG0";
        desc = "AXI_QOSCFG0 is the DDRC QoS configuration register 0. AXI_QOSCFG0 (offset 0x040+0x4xports (ports = 0~6), total reset 0x0000_0000; PROVEN: Hi3535 data sheet, PDF page 604, section 4.1.5.2).";
        field {
            name = "pri_deliver_en";
            desc = "Port priority propagation enable.
- 0: Disable.
- 1: Enable.";
            sw = rw; hw = r;
            reset = 0x0;
        } pri_deliver_en[31:31];
        field {
            name = "reserved";
            desc = "Reserved.";
            sw = r; hw = w;
            reset = 0x0;
        } reserved_30_25[30:25];
        field {
            name = "tout_map_mode";
            desc = "Read/write command timeout mapping mode.
- 0: Use the mapping configured by the tout_id_map register;
- 1: Use the command sideband signal wr(rd)_tout_sel for timeout mapping.";
            sw = rw; hw = r;
            reset = 0x0;
        } tout_map_mode[24:24];
        field {
            name = "tout_id_map";
            desc = "Selects two bits of the read/write command ID for timeout configuration selection. id_map[7:4]: Configures bit[1] of the ID mapping. id_map[3:0]: Configures bit[0] of the ID mapping. For example, if ID_MAP is configured as 0x32, {ID[3],ID[2]} of the read/write command ID is used for ID mapping to complete the priority configuration. Note that the lower four bits of the read/write command ID are the AXI port number. That is, read/write command ID = {ID from the bus, four-bit AXI port number}.";
            sw = rw; hw = r;
            reset = 0x0;
        } tout_id_map[23:16];
        field {
            name = "reserved";
            desc = "Reserved.";
            sw = r; hw = w;
            reset = 0x0;
        } reserved_15_13[15:13];
        field {
            name = "pri_map_mode";
            desc = "Read/write command priority mapping mode.
- 0: Use the pri_id_map mapping configured in the register.
- 1: Use the AxQOS[2:0] signals of the AXI4 read/write command channels for QoS mapping.";
            sw = rw; hw = r;
            reset = 0x0;
        } pri_map_mode[12:12];
        field {
            name = "pri_id_map";
            desc = "Selects three bits of the read/write command ID for the QoS configuration selection. pri_id_map[11:8]: Configures bit[2] of the ID mapping. pri_id_map[7:4]: Configures bit[1] of the ID mapping. pri_id_map[3:0]: Configures bit[0] of the ID mapping. For example, if ID_MAP is configured as 0x320, {ID[3],ID[2],ID[0]} of the read/write command ID is used for ID mapping to complete the priority configuration. Note that the low four bits of the read/write command ID are the AXI port number. That is, read/write command ID = {ID from the bus, 4-bit AXI port number}.";
            sw = rw; hw = r;
            reset = 0x0;
        } pri_id_map[11:0];
    } AXI_QOSCFG0[7] @ 0x40 += 0x4;
    reg {
        name = "AXI_QOSCFG1";
        desc = "AXI_QOSCFG1 is QoS configuration register 1 of the DDRC. AXI_QOSCFG1 (offset 0x080+0x4xports (ports = 0~6), total reset 0x0000_0000; PROVEN: Hi3535 data sheet, PDF page 605, section 4.1.5.2).";
        field {
            name = "reserved";
            desc = "Reserved.";
            sw = r; hw = w;
            reset = 0x0;
        } reserved_31_24[31:24];
        field {
            name = "wr_pri_apt";
            desc = "Write command priority adaptation period configuration.
- 0x0: Disable the priority adaptation function;
0x1 to 0xF: N x 16 clock cycles.";
            sw = rw; hw = r;
            reset = 0x0;
        } wr_pri_apt[23:20];
        field {
            name = "wr_age_prd";
            desc = "Write command aging time configuration.
- 0x0: Disable the aging function. 0x1 to 0xF: N x 16 clock cycles.";
            sw = rw; hw = r;
            reset = 0x0;
        } wr_age_prd[19:16];
        field {
            name = "reserved";
            desc = "Reserved.";
            sw = r; hw = w;
            reset = 0x0;
        } reserved_15_8[15:8];
        field {
            name = "rd_pri_apt";
            desc = "Read command priority adaptation period configuration.
- 0x0: Priority adaptation disabled;
0x1 to 0xF: N x 16 clock cycles.";
            sw = rw; hw = r;
            reset = 0x0;
        } rd_pri_apt[7:4];
        field {
            name = "rd_age_prd";
            desc = "Read command aging time configuration.
- 0x0: Disable the Aging function; 0x1 to 0xF: N x 16 clock cycles.";
            sw = rw; hw = r;
            reset = 0x0;
        } rd_age_prd[3:0];
    } AXI_QOSCFG1[7] @ 0x80 += 0x4;
    reg {
        name = "AXI_WRPRI";
        desc = "AXI_WRPRI is the DDRC write command priority configuration register. AXI_WRPRI (offset 0x0C0+0x4xports (ports = 0~6), total reset 0x0000_0000; PROVEN: Hi3535 data sheet, PDF page 606, section 4.1.5.2).";
        field {
            name = "reserved";
            desc = "Reserved.";
            sw = r; hw = w;
            reset = 0x0;
        } reserved_31_31[31:31];
        field {
            name = "wr_pri7";
            desc = "Priority configuration when the write command id is mapped to 7.
- 000: Highest priority. ...
- 111: Lowest priority.";
            sw = rw; hw = r;
            reset = 0x0;
        } wr_pri7[30:28];
        field {
            name = "reserved";
            desc = "Reserved.";
            sw = r; hw = w;
            reset = 0x0;
        } reserved_27_27[27:27];
        field {
            name = "wr_pri6";
            desc = "Priority configuration when the write command id is mapped to 6.
- 000: Highest priority. ......
- 111: Lowest priority.";
            sw = rw; hw = r;
            reset = 0x0;
        } wr_pri6[26:24];
        field {
            name = "reserved";
            desc = "Reserved.";
            sw = r; hw = w;
            reset = 0x0;
        } reserved_23_23[23:23];
        field {
            name = "wr_pri5";
            desc = "Priority configuration when the write command id is mapped to 5.
- 000: Highest priority;
...
- 111: Lowest priority.";
            sw = rw; hw = r;
            reset = 0x0;
        } wr_pri5[22:20];
        field {
            name = "reserved";
            desc = "Reserved.";
            sw = r; hw = w;
            reset = 0x0;
        } reserved_19_19[19:19];
        field {
            name = "wr_pri4";
            desc = "Priority configuration when the write command id is mapped to 4.
- 000: Highest priority;
......
- 111: Lowest priority.";
            sw = rw; hw = r;
            reset = 0x0;
        } wr_pri4[18:16];
        field {
            name = "reserved";
            desc = "Reserved.";
            sw = r; hw = w;
            reset = 0x0;
        } reserved_15_15[15:15];
        field {
            name = "wr_pri3";
            desc = "Priority configuration when the write command id is mapped to 3.
- 000: Highest priority; ......
- 111: Lowest priority.";
            sw = rw; hw = r;
            reset = 0x0;
        } wr_pri3[14:12];
        field {
            name = "reserved";
            desc = "Reserved.";
            sw = r; hw = w;
            reset = 0x0;
        } reserved_11_11[11:11];
        field {
            name = "wr_pri2";
            desc = "Priority configuration when the write command id is mapped to 2.
- 000: Highest priority; ......
- 111: Lowest priority.";
            sw = rw; hw = r;
            reset = 0x0;
        } wr_pri2[10:8];
        field {
            name = "reserved";
            desc = "Reserved.";
            sw = r; hw = w;
            reset = 0x0;
        } reserved_7_7[7:7];
        field {
            name = "wr_pri1";
            desc = "Priority configuration when the write command id is mapped to 1.
- 000: Highest priority. ......
- 111: Lowest priority.";
            sw = rw; hw = r;
            reset = 0x0;
        } wr_pri1[6:4];
        field {
            name = "reserved";
            desc = "Reserved.";
            sw = r; hw = w;
            reset = 0x0;
        } reserved_3_3[3:3];
        field {
            name = "wr_pri0";
            desc = "Priority configuration when the write command id is mapped to 0.
- 000: Highest priority;
...
- 111: Lowest priority.";
            sw = rw; hw = r;
            reset = 0x0;
        } wr_pri0[2:0];
    } AXI_WRPRI[7] @ 0xc0 += 0x4;
    reg {
        name = "AXI_RDPRI";
        desc = "AXI_RDPRI is the DDRC read command priority configuration register. AXI_RDPRI (offset 0x100+0x4xports (ports = 0~6), total reset 0x0000_0000; PROVEN: Hi3535 data sheet, PDF page 607, section 4.1.5.2).";
        field {
            name = "reserved";
            desc = "Reserved.";
            sw = r; hw = w;
            reset = 0x0;
        } reserved_31_31[31:31];
        field {
            name = "rd_pri7";
            desc = "Priority configuration when the read command id is mapped to 7.
- 000: Highest priority. ...
- 111: Lowest priority.";
            sw = rw; hw = r;
            reset = 0x0;
        } rd_pri7[30:28];
        field {
            name = "reserved";
            desc = "Reserved.";
            sw = r; hw = w;
            reset = 0x0;
        } reserved_27_27[27:27];
        field {
            name = "rd_pri6";
            desc = "Priority configuration when the read command id is mapped to 6.
- 000: Highest priority;
......
- 111: Lowest priority.";
            sw = rw; hw = r;
            reset = 0x0;
        } rd_pri6[26:24];
        field {
            name = "reserved";
            desc = "Reserved.";
            sw = r; hw = w;
            reset = 0x0;
        } reserved_23_23[23:23];
        field {
            name = "rd_pri5";
            desc = "Priority configuration when the read command id is mapped to 5.
- 000: Highest priority;
...
- 111: Lowest priority.";
            sw = rw; hw = r;
            reset = 0x0;
        } rd_pri5[22:20];
        field {
            name = "reserved";
            desc = "Reserved.";
            sw = r; hw = w;
            reset = 0x0;
        } reserved_19_19[19:19];
        field {
            name = "rd_pri4";
            desc = "Priority configuration when the read command id is mapped to 4.
- 000: Highest priority. ......
- 111: Lowest priority.";
            sw = rw; hw = r;
            reset = 0x0;
        } rd_pri4[18:16];
        field {
            name = "reserved";
            desc = "Reserved.";
            sw = r; hw = w;
            reset = 0x0;
        } reserved_15_15[15:15];
        field {
            name = "rd_pri3";
            desc = "Priority configuration when the read command id is mapped to 3.
- 000: Highest priority; ......
- 111: Lowest priority.";
            sw = rw; hw = r;
            reset = 0x0;
        } rd_pri3[14:12];
        field {
            name = "reserved";
            desc = "Reserved.";
            sw = r; hw = w;
            reset = 0x0;
        } reserved_11_11[11:11];
        field {
            name = "rd_pri2";
            desc = "Priority configuration when the read command id is mapped to 2.
- 000: Highest priority;
...
- 111: Lowest priority.";
            sw = rw; hw = r;
            reset = 0x0;
        } rd_pri2[10:8];
        field {
            name = "reserved";
            desc = "Reserved.";
            sw = r; hw = w;
            reset = 0x0;
        } reserved_7_7[7:7];
        field {
            name = "rd_pri1";
            desc = "Priority configuration when the read command id is mapped to 1.
- 000: Highest priority. ......
- 111: Lowest priority.";
            sw = rw; hw = r;
            reset = 0x0;
        } rd_pri1[6:4];
        field {
            name = "reserved";
            desc = "Reserved.";
            sw = r; hw = w;
            reset = 0x0;
        } reserved_3_3[3:3];
        field {
            name = "rd_pri0";
            desc = "Priority configuration when the read command id is mapped to 0.
- 000: Highest priority; ......
- 111: Lowest priority.";
            sw = rw; hw = r;
            reset = 0x0;
        } rd_pri0[2:0];
    } AXI_RDPRI[7] @ 0x100 += 0x4;
    reg {
        name = "AXI_WRTOUT";
        desc = "AXI_WRTOUT is the DDRC write command timeout configuration register. AXI_WRTOUT (offset 0x140+0x4xports (ports = 0~6), total reset 0x0000_0000; PROVEN: Hi3535 data sheet, PDF page 609, section 4.1.5.2).";
        field {
            name = "wr_tout3";
            desc = "Write command timeout configuration (level 3). Configured the same way as wr_tout0.";
            sw = rw; hw = r;
            reset = 0x0;
        } wr_tout3[31:24];
        field {
            name = "wr_tout2";
            desc = "Write command timeout configuration (level 2). Configured in the same way as wr_tout0.";
            sw = rw; hw = r;
            reset = 0x0;
        } wr_tout2[23:16];
        field {
            name = "wr_tout1";
            desc = "Write command timeout configuration (level 1). Configured the same way as wr_tout0.";
            sw = rw; hw = r;
            reset = 0x0;
        } wr_tout1[15:8];
        field {
            name = "wr_tout0";
            desc = "Write command timeout configuration (level 0).
- 0x0: Disable the timeout function; 0x1 to 0xFF: n x 4 clock cycles. Note: The timeout configuration is 8 bits, but the actual count is 10 bits, that is, the lower two bits are fixed at 0.";
            sw = rw; hw = r;
            reset = 0x0;
        } wr_tout0[7:0];
    } AXI_WRTOUT[7] @ 0x140 += 0x4;
    reg {
        name = "AXI_RDTOUT";
        desc = "AXI_RDTOUT is the DDRC read command timeout configuration register. AXI_RDTOUT (offset 0x180+0x4xports (ports = 0~6), total reset 0x0000_0000; PROVEN: Hi3535 data sheet, PDF page 610, section 4.1.5.2).";
        field {
            name = "rd_tout3";
            desc = "Read command timeout configuration (level 3). Configured the same way as rd_tout0.";
            sw = rw; hw = r;
            reset = 0x0;
        } rd_tout3[31:24];
        field {
            name = "rd_tout2";
            desc = "Read command timeout configuration (level 2). Configured the same way as rd_tout0.";
            sw = rw; hw = r;
            reset = 0x0;
        } rd_tout2[23:16];
        field {
            name = "rd_tout1";
            desc = "Read command timeout configuration (level 1). Configured the same way as rd_tout0.";
            sw = rw; hw = r;
            reset = 0x0;
        } rd_tout1[15:8];
        field {
            name = "rd_tout0";
            desc = "Read command timeout configuration (level 0).
- 0x0: Disable the timeout function; 0x1 to 0xFF: n x 4 clock cycles. Note: The timeout configuration is 8 bits, but the actual count is 10 bits, that is, the lower two bits are fixed at zero.";
            sw = rw; hw = r;
            reset = 0x0;
        } rd_tout0[7:0];
    } AXI_RDTOUT[7] @ 0x180 += 0x4;
    reg {
        name = "AXI_OSTDCFG0";
        desc = "AXI_OSTDCFG0 is DDRC port command outstanding configuration register 0. AXI_OSTDCFG0 (offset 0x200+0x4xports (ports = 0~6), total reset 0x1F1F_1F1F; PROVEN: Hi3535 data sheet, PDF page 610, section 4.1.5.2).";
        field {
            name = "reserved";
            desc = "Reserved.";
            sw = r; hw = w;
            reset = 0x0;
        } reserved_31_29[31:29];
        field {
            name = "port_ostd_lvl3";
            desc = "Command ostd watermark from this port to channel 3 (to be used together with the AXI_OSTDCFG2 register). No setting is needed, because the Hi3535V100 is single-channel and has only channel 0.";
            sw = rw; hw = r;
            reset = 0x1f;
        } port_ostd_lvl3[28:24];
        field {
            name = "reserved";
            desc = "Reserved.";
            sw = r; hw = w;
            reset = 0x0;
        } reserved_23_21[23:21];
        field {
            name = "port_ostd_lvl2";
            desc = "ostd watermark of commands sent from this port to channel 2 (to be used together with the AXI_OSTDCFG2 register). No setting is needed because the Hi3535V100 has a single channel, channel 0.";
            sw = rw; hw = r;
            reset = 0x1f;
        } port_ostd_lvl2[20:16];
        field {
            name = "reserved";
            desc = "Reserved.";
            sw = r; hw = w;
            reset = 0x0;
        } reserved_15_13[15:13];
        field {
            name = "port_ostd_lvl1";
            desc = "Outstanding (ostd) watermark of commands sent from this port to channel 1 (to be used together with the AXI_OSTDCFG2 register). No setting is needed because the Hi3535V100 has a single channel, channel 0 only.";
            sw = rw; hw = r;
            reset = 0x1f;
        } port_ostd_lvl1[12:8];
        field {
            name = "reserved";
            desc = "Reserved.";
            sw = r; hw = w;
            reset = 0x0;
        } reserved_7_5[7:5];
        field {
            name = "port_ostd_lvl0";
            desc = "ostd watermark of commands sent from this port to channel 0 (to be used together with the AXI_OSTDCFG2 register).";
            sw = rw; hw = r;
            reset = 0x1f;
        } port_ostd_lvl0[4:0];
    } AXI_OSTDCFG0[7] @ 0x200 += 0x4;
    reg {
        name = "AXI_OSTDCFG1";
        desc = "AXI_OSTDCFG1 is DDRC port command outstanding configuration register 1. AXI_OSTDCFG1 (offset 0x240, total reset 0x1F1F_1F1F; PROVEN: Hi3535 data sheet, PDF page 611, section 4.1.5.2).";
        field {
            name = "reserved";
            desc = "Reserved.";
            sw = r; hw = w;
            reset = 0x0;
        } reserved_31_29[31:29];
        field {
            name = "dmc_ostd_lvl3";
            desc = "Cumulative ostd watermark of the commands sent from all ports to channel 3 (to be used together with the AXI_OSTDCFG2 register). No setting needed, because the Hi3535V100 has a single channel, channel 0 only.";
            sw = rw; hw = r;
            reset = 0x1f;
        } dmc_ostd_lvl3[28:24];
        field {
            name = "reserved";
            desc = "Reserved.";
            sw = r; hw = w;
            reset = 0x0;
        } reserved_23_21[23:21];
        field {
            name = "dmc_ostd_lvl2";
            desc = "Accumulated command ostd watermark from all ports to channel 2 (to be used together with the AXI_OSTDCFG2 register). No setting is needed, because the Hi3535V100 is single-channel and has only channel 0.";
            sw = rw; hw = r;
            reset = 0x1f;
        } dmc_ostd_lvl2[20:16];
        field {
            name = "reserved";
            desc = "Reserved.";
            sw = r; hw = w;
            reset = 0x0;
        } reserved_15_13[15:13];
        field {
            name = "dmc_ostd_lvl1";
            desc = "Accumulated ostd watermark of commands sent from all ports to channel 1 (to be used together with the AXI_OSTDCFG2 register). No setting is needed because the Hi3535V100 has a single channel, channel 0.";
            sw = rw; hw = r;
            reset = 0x1f;
        } dmc_ostd_lvl1[12:8];
        field {
            name = "reserved";
            desc = "Reserved.";
            sw = r; hw = w;
            reset = 0x0;
        } reserved_7_5[7:5];
        field {
            name = "dmc_ostd_lvl0";
            desc = "Cumulative ostd watermark of the commands sent from all ports to channel 0 (to be used together with the AXI_OSTDCFG2 register).";
            sw = rw; hw = r;
            reset = 0x1f;
        } dmc_ostd_lvl0[4:0];
    } AXI_OSTDCFG1 @ 0x240;
    reg {
        name = "AXI_OSTDCFG2";
        desc = "AXI_OSTDCFG2 is DDRC port command outstanding configuration register 2. AXI_OSTDCFG2 (offset 0x244, total reset 0x0000_0000; PROVEN: Hi3535 data sheet, PDF page 612, section 4.1.5.2).";
        field {
            name = "reserved";
            desc = "Reserved.";
            sw = r; hw = w;
            reset = 0x0;
        } reserved_31_14[31:14];
        field {
            name = "ostd_mode6";
            desc = "ostd mode of port 6. Same as the description for port 0.";
            sw = rw; hw = r;
            reset = 0x0;
        } ostd_mode6[13:12];
        field {
            name = "ostd_mode5";
            desc = "ostd mode of port 5. Same as the description for port 0.";
            sw = rw; hw = r;
            reset = 0x0;
        } ostd_mode5[11:10];
        field {
            name = "ostd_mode4";
            desc = "ostd mode of port 4. Same description as port 0.";
            sw = rw; hw = r;
            reset = 0x0;
        } ostd_mode4[9:8];
        field {
            name = "ostd_mode3";
            desc = "ostd mode of port 3. Same as the description of port 0.";
            sw = rw; hw = r;
            reset = 0x0;
        } ostd_mode3[7:6];
        field {
            name = "ostd_mode2";
            desc = "ostd mode of port 2. Same as the description for port 0.";
            sw = rw; hw = r;
            reset = 0x0;
        } ostd_mode2[5:4];
        field {
            name = "ostd_mode1";
            desc = "ostd mode of port 1. Same as the description of port 0.";
            sw = rw; hw = r;
            reset = 0x0;
        } ostd_mode1[3:2];
        field {
            name = "ostd_mode0";
            desc = "Ostd mode of port 0.
- 00: Disable ostd statistics of the current port itself.
- 01: Green port: (controlled per channel; when the port's own ostd reaches port_ostd_lvl, this port is blocked).
- 10: Non-green port mode 0: (controlled per channel; when the accumulated ostd of all ports reaches dmc_ostd_lvl, this port is blocked).
- 11: Non-green port mode 1: (controlled per channel; when the accumulated ostd of all ports reaches dmc_ostd_lvl, or when the port's own ostd reaches port_ostd_lvl, this port is blocked).";
            sw = rw; hw = r;
            reset = 0x0;
        } ostd_mode0[1:0];
    } AXI_OSTDCFG2 @ 0x244;
    reg {
        name = "AXI_OSTDSTATUS";
        desc = "AXI_OSTDSTATUS is the DDRC channel command outstanding status register. AXI_OSTDSTATUS (offset 0x248, total reset 0x0000_0000; PROVEN: Hi3535 data sheet, PDF page 613, section 4.1.5.2).";
        field {
            name = "reserved";
            desc = "Reserved.";
            sw = r; hw = w;
            reset = 0x0;
        } reserved_31_5[31:5];
        field {
            name = "ostd_st0";
            desc = "Command ostd status of channel 0 (this statistic is valid when at least one port is not in green-port mode).";
            sw = r; hw = w;
            reset = 0x0;
        } ostd_st0[4:0];
    } AXI_OSTDSTATUS @ 0x248;
    reg {
        name = "AXI_FLUX0";
        desc = "AXI_FLUX0 is the DDRC port bandwidth flow control configuration register (channel 0). AXI_FLUX0 (offset 0x280+0x4xports (ports = 0~6), total reset 0x0000_0000; PROVEN: Hi3535 data sheet, PDF page 614, section 4.1.5.2).";
        field {
            name = "reserved";
            desc = "Reserved.";
            sw = r; hw = w;
            reset = 0x0;
        } reserved_31_22[31:22];
        field {
            name = "flux_port_en0";
            desc = "AXI interface DDRC traffic statistics enable.
- 0: Disable the traffic control function;
- 1: Enable traffic control.";
            sw = rw; hw = r;
            reset = 0x0;
        } flux_port_en0[21:21];
        field {
            name = "flux_ovfl_en0";
            desc = "AXI interface traffic overflow allow enable.
- 0: Disable;
- 1: Enable. When set to 1, if the traffic of an AXI port exceeds its bandwidth limit, no AXI port without traffic overflow exists, and a command request is pending, this AXI port is allowed to exceed its configured bandwidth.";
            sw = rw; hw = r;
            reset = 0x0;
        } flux_ovfl_en0[20:20];
        field {
            name = "reserved";
            desc = "Reserved.";
            sw = r; hw = w;
            reset = 0x0;
        } reserved_19_17[19:17];
        field {
            name = "flux_ovfl_lvl0";
            desc = "Watermark allowing AXI interface traffic overflow. 0x0 to 0x10: DMC watermark depth at which traffic overflow is allowed; other values: reserved. When the traffic of an AXI port exceeds the bandwidth configured in flux, and flux_ovfl=1, a command may be sent only if the number of pending commands in the DMC is below this watermark. Otherwise it is not granted arbitration.";
            sw = rw; hw = r;
            reset = 0x0;
        } flux_ovfl_lvl0[16:12];
        field {
            name = "reserved";
            desc = "Reserved.";
            sw = r; hw = w;
            reset = 0x0;
        } reserved_11_10[11:10];
        field {
            name = "flux_cfg0";
            desc = "Allowed bandwidth configuration of the AXI interface. 0x0 to 0x3FF: Ratio of the maximum DDR bandwidth the AXI interface may access to the total bandwidth. The total bandwidth is 1024; the configured value is the share of the total bandwidth. Others: Reserved.";
            sw = rw; hw = r;
            reset = 0x0;
        } flux_cfg0[9:0];
    } AXI_FLUX0[7] @ 0x280 += 0x4;
};

`endif
