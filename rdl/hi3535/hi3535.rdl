

`include "../common/HISI_USB_HOST.rdl"
`include "iomux.rdl"
`include "iopad.rdl"
`include "crg.rdl"
`include "sys_ctrl.rdl"
`include "misc_ctrl.rdl"
`include "../common/HISI_CIPHER_MC.rdl"
`include "../common/HISI_TIMER_SP804.rdl"
`include "../common/HISI_WDG_SP805.rdl"
`include "../common/HISI_RTC_SPI.rdl"
`include "rtc_int.rdl"
`include "ddrc_axi.rdl"
`include "ddrc_dmc.rdl"
`include "ddrc_mux.rdl"
`include "ddrc_phy.rdl"
`include "../common/HISI_SFC_350.rdl"
`include "../common/HISI_NANDC.rdl"
`include "toe.rdl"
`include "../common/HISI_MOTION_DETECT.rdl"
`include "../common/HISI_IVE.rdl"
`include "vdp.rdl"
`include "aio.rdl"
`include "../common/HISI_I2C.rdl"
`include "../common/ARM_PL011.rdl"
`include "../common/HISI_IR.rdl"
`include "../common/ARM_PL061.rdl"
`include "usb3.rdl"
`include "pcie.rdl"
`include "sata.rdl"
`include "sata_port.rdl"
`include "pwm.rdl"

addrmap hi3535 {
    name = "hi3535 registers";
    desc = "
## Status

Register map of the Hi3535 (H.264 NVR codec processor: dual Cortex-A9, 2x GbE with TOE, PCIe, SATA 3.0, USB 3.0 and USB 2.0, VDP/HDMI, IVE, MDU). Everything below is taken from the HiSilicon Hi3535 H.264 codec processor user guide / data sheet (Issue 00B08, 2014-02-25, Chinese): the address map (table 1-2), the interrupt table (table 3-25) and the register tables of chapters 2 to 13.
The register blocks were extracted programmatically from the data sheet text (names, offsets, bit ranges, access, reset values; descriptions translated to English) and are labelled PROVEN (data sheet table). Blocks with the same layout as on the Hi3520D reuse the shared blocks in rdl/common (compared register by register, see docs/rdl-campaign/hi3535-datasheet.md of the workspace); where the data sheet differs from the Hi3520D (CRG, MISC, DDRC, IO, AIO, SATA ...) chip-local blocks were generated.
Not modelled because the data sheet has no register tables: HDMI, L2 cache controller, ARM debug, VDH/JPGE/JPGD/TDE/VPSS/VGS/VENC/DDRT/SCD registers, the Audio codec.
Nothing was verified on hardware.

## Addresses

| Start Address | End Address | Description | Documented Here |
|---------------|-------------|-------------|-----------------|
| 0x00000000 | 0x03FFFFFF | Address remapping window: points to the BOOTROM until remapping is cleared, then to the on-chip RAM; 64 MB | &#10060; |
| 0x04000000 | 0x0400FFFF | BOOTROM address space (4 KB actual); 64 KB | &#10060; |
| 0x04010000 | 0x0401FFFF | On-chip RAM address space (10 KB actual); 64 KB | &#10060; |
| 0x10000000 | 0x1000FFFF | NANDC registers; 64 KB | &#9989; NANDC (reused common block) |
| 0x10010000 | 0x1001FFFF | SFC registers; 64 KB | &#9989; SFC (reused common block) |
| 0x10030000 | 0x1003FFFF | USB OHCI registers; 64 KB | &#9989; OHCI (generated from the data sheet) |
| 0x10040000 | 0x1004FFFF | USB EHCI registers; 64 KB | &#9989; EHCI (reused common block) |
| 0x10050000 | 0x1005FFFF | CIPHER registers; 64 KB | &#9989; CIPHER (reused common block) |
| 0x10060000 | 0x1006FFFF | DMAC registers; 64 KB | &#10060; |
| 0x12000000 | 0x1200FFFF | USB 3.0 registers; 64 KB | &#9989; USB3 (generated from the data sheet) |
| 0x12010000 | 0x1201FFFF | SATA 3.0 registers; 64 KB | &#9989; SATA, SATA_PORT (generated from the data sheet) |
| 0x12020000 | 0x1203FFFF | TOE registers (GMAC and TOE); 128 KB | &#9989; TOE (generated from the data sheet) |
| 0x20000000 | 0x2000FFFF | Timer0 registers; 64 KB | &#9989; TIMER0, TIMER1 (reused common block) |
| 0x20010000 | 0x2001FFFF | Timer1 registers; 64 KB | &#9989; TIMER2, TIMER3 (reused common block) |
| 0x20030000 | 0x2003FFFF | CRG registers; 64 KB | &#9989; CRG (generated from the data sheet) |
| 0x20040000 | 0x2004FFFF | WDG registers; 64 KB | &#9989; WDG (reused common block) |
| 0x20050000 | 0x2005FFFF | SYS_CTRL registers; 64 KB | &#9989; SYS_CTRL (generated from the data sheet) |
| 0x20060000 | 0x2006FFFF | RTC registers; 64 KB | &#9989; RTC (reused common block) |
| 0x20070000 | 0x2007FFFF | IR registers; 64 KB | &#9989; IR (reused common block) |
| 0x20080000 | 0x2008FFFF | UART0 registers; 64 KB | &#9989; UART0 (reused common block) |
| 0x20090000 | 0x2009FFFF | UART1 registers; 64 KB | &#9989; UART1 (reused common block) |
| 0x200A0000 | 0x200AFFFF | UART2 registers; 64 KB | &#9989; UART2 (reused common block) |
| 0x200B0000 | 0x200BFFFF | UART3 registers; 64 KB | &#9989; UART3 (reused common block) |
| 0x200D0000 | 0x200DFFFF | I2C registers; 64 KB | &#9989; I2C (reused common block) |
| 0x200E0000 | 0x200EFFFF | PWM registers; 64 KB | &#9989; PWM (generated from the data sheet) |
| 0x200F0000 | 0x200F7FFF | Pin multiplexing registers; 32 KB | &#9989; IOMUX, IOPAD (generated from the data sheet) |
| 0x200F0800 | 0x200FFFFF | Pin control (drive strength) registers; 32 KB | &#9989; IOPAD (generated from the data sheet) |
| 0x20100000 | 0x2010FFFF | HDMI registers; 64 KB | &#10060; |
| 0x20110000 | 0x2011FFFF | DDRC registers; 64 KB | &#9989; DDRC_AXI, DDRC_DMC, DDRC_MUX, DDRC_PHY (generated from the data sheet) |
| 0x20120000 | 0x2012FFFF | MISC registers; 64 KB | &#9989; MISC_CTRL (generated from the data sheet) |
| 0x20130000 | 0x2013FFFF | Timer2 registers; 64 KB | &#9989; TIMER4, TIMER5 (reused common block) |
| 0x20140000 | 0x2014FFFF | Timer3 registers; 64 KB | &#9989; TIMER6, TIMER7 (reused common block) |
| 0x20150000 | 0x2022FFFF | GPIO0 to GPIO13 registers; 14 x 64 KB | &#9989; GPIO0, GPIO1, GPIO2, GPIO3, GPIO4, GPIO5 ... (reused common block) |
| 0x20230000 | 0x2023FFFF | GPIO14 registers; 64 KB | &#9989; GPIO14 (reused common block) |
| 0x20300000 | 0x2030FFFF | ARM WDG/timer/GIC and other internal registers; 64 KB | &#10060; |
| 0x20400000 | 0x2051FFFF | ARM DEBUG; 1152 KB (CoreSight debug APB window of the dual Cortex-A9, not described) | &#10060; |
| 0x205C0000 | 0x205CFFFF | VDP registers; 64 KB | &#9989; VDP (generated from the data sheet) |
| 0x205E0000 | 0x205EFFFF | IVE registers; 64 KB | &#9989; IVE (reused common block) |
| 0x20600000 | 0x2060FFFF | VPSS registers; 64 KB | &#10060; |
| 0x20610000 | 0x2061FFFF | TDE registers; 64 KB | &#10060; |
| 0x20620000 | 0x2062FFFF | VENC registers; 64 KB | &#10060; |
| 0x20630000 | 0x2063FFFF | VDH0 registers; 64 KB | &#10060; |
| 0x20650000 | 0x2065FFFF | VDH1 registers; 64 KB | &#10060; |
| 0x20660000 | 0x2066FFFF | JPGE registers; 64 KB | &#10060; |
| 0x20670000 | 0x2067FFFF | JPGD registers; 64 KB | &#10060; |
| 0x20680000 | 0x2068FFFF | AIO registers; 64 KB | &#9989; AIO (generated from the data sheet) |
| 0x206B0000 | 0x206BFFFF | VGS registers; 64 KB | &#10060; |
| 0x206C0000 | 0x206CFFFF | MD (motion detection) registers; 64 KB | &#9989; MDU (reused common block) |
| 0x206D0000 | 0x206DFFFF | DDRT registers; 64 KB | &#10060; |
| 0x20700000 | 0x207FFFFF | L2 cache space; 1 MB | &#10060; |
| 0x20800000 | 0x2080FFFF | PCIe registers; 64 KB | &#9989; PCIE (generated from the data sheet) |
| 0x30000000 | 0x3FFFFFFF | PCIe memory address space; 256 MB | &#10060; |
| 0x40000000 | 0x4FFFFFFF | PCIe configuration address space; 256 MB | &#10060; |
| 0x50000000 | 0x53FFFFFF | NANDC memory space; 64 MB | &#10060; |
| 0x58000000 | 0x5BFFFFFF | SPI flash memory space; 64 MB | &#10060; |
| 0x80000000 | 0xFFFFFFFF | DDR memory space (external DDR devices); 2 GB | &#10060; |

## Interrupts

Interrupt numbers of the interrupt controller (data sheet interrupt table); `Reserved` entries omitted.

| Interrupt | Source |
|-----------|--------|
| 0 | A9 internal use |
| 1 | A9 internal use |
| 2 | A9 internal use |
| 3 | A9 internal use |
| 4 | A9 internal use |
| 5 | A9 internal use |
| 6 | A9 internal use |
| 7 | A9 internal use |
| 8 | A9 internal use |
| 9 | A9 internal use |
| 10 | A9 internal use |
| 11 | A9 internal use |
| 12 | A9 internal use |
| 13 | A9 internal use |
| 14 | A9 internal use |
| 15 | A9 internal use |
| 16 | A9 internal use |
| 17 | A9 internal use |
| 18 | A9 internal use |
| 19 | A9 internal use |
| 20 | A9 internal use |
| 21 | A9 internal use |
| 22 | A9 internal use |
| 23 | A9 internal use |
| 24 | A9 internal use |
| 25 | A9 internal use |
| 26 | A9 internal use |
| 27 | A9 internal use |
| 28 | A9 internal use |
| 29 | A9 internal use |
| 30 | A9 internal use |
| 31 | A9 internal use |
| 32 | COMMTX[0] |
| 33 | COMMRX[0] |
| 34 | WatchDog |
| 35 | Timer0 |
| 36 | Timer1 |
| 37 | Timer2 |
| 38 | Timer3 |
| 39 | RTC |
| 40 | UART0 |
| 41 | UART1 |
| 42 | UART2 |
| 43 | UART3 |
| 44 | L2 Controller |
| 45 | A9 PMU[0] |
| 46 | DMAC |
| 47 | I2C |
| 48 | NFC |
| 49 | SFC |
| 50 | IR |
| 51 | Cipher |
| 53 | USB2.0 OHCI |
| 54 | USB2.0 EHCI |
| 55 | Temp Capture |
| 59 | TOE_INTR |
| 60 | TOE_LPI_INTR |
| 61 | Software Int |
| 63 | SATA |
| 64 | USB 3.0 |
| 65 | VDP |
| 66 | IVE |
| 67 | VDH0 |
| 68 | VENC |
| 69 | VPSS |
| 70 | JPGD |
| 71 | MD/DDRT |
| 72 | VDH1 |
| 73 | TDE |
| 74 | JPGE |
| 75 | VGS |
| 76 | AIO |
| 77 | HDMI |
| 78 | SCD0 |
| 79 | SCD1 |
| 80 | PCIE_INTA |
| 81 | PCIE_INTB |
| 82 | PCIE_INTC |
| 83 | PCIE_INTD |
| 84 | PCIE_DMA |
| 85 | PCIE_MSI |
| 86 | PCIE_LINK_DOWN |
| 90 | A9 PMU[1] |
| 91 | GPIO0~GPIO3 |
| 92 | GPIO4~GPIO8 |
| 93 | GPIO9~GPIO14 |
| 94 | COMMTX[1] |
| 95 | COMMRX[1] |

        <!-- overview:begin -->

        ### Diagrams

        ![Logic block diagram](assets/diagrams/hi3535-logic.svg)

        ![Register blocks by function](assets/diagrams/hi3535-blocks.svg)

        ![Clock tree](assets/diagrams/hi3535-clocks.svg)

        ![Boot flow](assets/diagrams/hi3535-boot.svg)

        ![Video pipeline](assets/diagrams/hi3535-video.svg)

        ![Interrupt topology](assets/diagrams/hi3535-irq.svg)

        ![Reset tree](assets/diagrams/hi3535-resets.svg)

        ![Power domains](assets/diagrams/hi3535-power.svg)

        ![CRG register map](assets/diagrams/hi3535-crgmap.svg)

        ![bus clock domains](assets/diagrams/hi3535-bus.svg)

        ![IP edition per chip](assets/diagrams/hi3535-family.svg)

        ### Key specifications (data sheet chapter 1; the data sheet is Chinese, translated)

        | | Hi3535 V100 |
        |---|---|
        | CPU | dual Cortex-A9, up to 1 GHz; 32 KB L1 I + 32 KB L1 D per core, 256 KB L2 |
        | DDR | one 32-bit DDR3 controller, up to 800 MHz, up to 2 GB |
        | Decode | H.264 BP/MP/HP L5.0, MPEG4 SP/ASP, MJPEG/JPEG baseline |
        | Encode | H.264 BP/MP/HP L4.2, MJPEG/JPEG baseline |
        | Performance examples | 5x1080p@30 decode + 1x1080p@30 encode; 9x720p@30 decode + 1x1080p@30 encode; 24xD1@30 decode + 1x1080p@30 encode |
        | Video output | 1 HDMI 1.4, 1 VGA (up to 1920x1200@60), 1 BT.1120, 1 CVBS; three full-screen GUI layers (two HD, one SD) and a 128x128 cursor |
        | Audio | integrated audio codec, 2 I2S (1 in, 1 out), software codecs |
        | Network | 2 gigabit Ethernet (RGMII/RMII/MII, TOE) |
        | Peripherals | 2 SATA 3.0, 1 PCIe 2.0 / SATA 3.0 shared port (RC and endpoint), 4 UART (2 with four wires), IR, I2C, GPIO, 2 USB 2.0 host, 1 USB 3.0 host |
        | Flash | SPI NOR (1/2/4 bit, 2 CS, 32 MB each), 8-bit NAND (SLC/MLC, 1/4/8/24 bit ECC) with NAND boot |
        | On-chip memory | 4 KB BOOTROM, 10 KB SRAM |
        | Package | EDHS-PBGA, 23 x 23 mm, 0.8 mm pitch; 3.5 W typical; core 1.1 V, CPU 1.2 V (down to 1.1 V), I/O 3.3 V, DDR3 1.5 V |

        ### Boot (data sheet 1.3, Table 1-1)

        | BOOTROM_SEL | BOOT_SEL1 | BOOT_SEL0 | Boot mode |
        |---|---|---|---|
        | 1 | X | X | BOOTROM (serial download) |
        | 0 | 0 | 0 | external SPI flash |
        | 0 | 1 | 0 | external NAND flash |
        | 0 | 0 | 1 | slave mode: the CPU does not start; a master chip loads the boot program into this chip's DDR over PCIe and releases its reset |

        BOOTROM_SEL is multiplexed with pin MDCK, BOOT_SEL1 with VOU1120_DATA10 and BOOT_SEL0 with VOU1120_DATA7. With BOOTROM_SEL = 1 the BOOTROM starts the serial download; if the serial link times out it evaluates BOOT_SEL1/BOOT_SEL0 (00 = SPI flash, 10 = NAND flash).

        ### Chip ID

        | Chip | System controller ID registers (0xEE0 .. 0xEEC) | Value read as SC_SYSID |
        |---|---|---|
        | hi3535 | SYSID0..3 reset values from the RDL | 0x35350100 |

        The four 8-bit registers form the 32-bit chip ID (SYSID3 is the most significant byte). The values are the reset values of the register descriptions: one data sheet documents one ID for all chips it covers, so the chips of a shared data sheet are not distinguished here (the real value of each variant is not stated).

        ### Memory map notes (data sheet 1.3, Table 1-2)

        * 0x00000000-0x03FFFFFF (64 MB) is the boot window: it points to the BOOTROM while the remap is active and to the on-chip RAM (10 KB) after the remap is cleared; BOOTROM window 0x04000000 (4 KB implemented), RAM window 0x04010000.
        * Flash windows: NAND controller memory space 0x50000000-0x53FFFFFF (64 MB), SPI flash memory space 0x58000000-0x5BFFFFFF (64 MB).
        * PCIe: memory space 0x30000000-0x3FFFFFFF (256 MB), configuration space 0x40000000-0x4FFFFFFF (256 MB); controller registers at 0x20800000. In slave boot mode a master chip writes the boot program into this chip's DDR over PCIe (boot table).
        * DDR: 0x80000000-0xFFFFFFFF (2 GB window; one 32-bit DDR3 controller up to 2 GB).
        * Dual Cortex-A9: private region (SCU, GIC, timers, watchdogs) 0x20300000, L2 cache controller 0x20700000, ARM DEBUG 0x20400000-0x2051FFFF.
        * The DMAC window 0x10060000 (IRQ 46) is in the memory map but the data sheet has no DMAC chapter: no request-line table (see DMA).

        ### DMA request lines

        The memory map lists a DMAC at 0x10060000 and the interrupt table lists DMAC as interrupt 46, but the data sheet contains no DMAC register chapter and no request-line table, and the RDL does not model the block. The Hi3520D V100 has no DMAC at all and the later chips use the PL080-style block; nothing here is inferred for the Hi3535 beyond its presence in the map.

        ### Pin multiplexing summary (IOMUX at 0x200F0000)

        Generated from the pin mux registers of this description (register offsets are relative to the block base; the function lists are the value-ordered choices of each register). Pads that repeat a pattern in consecutive registers are merged into one row.

        | Pads | Mux register (offset from 0x200F0000) | Function choices (value 0, 1, ...) |
        |---|---|---|
        | VGA_HS | muxctrl_reg0 @0x000 | 0=VGA_HS / 1=GPIO6_6 |
        | VGA_VS | muxctrl_reg1 @0x004 | 0=VGA_VS / 1=GPIO6_7 |
        | RGMII0_RXDV | muxctrl_reg2 @0x008 | 0=RGMII0_RXDV / 1=GPIO8_7 |
        | RGMII0_RXD0 ... RGMII0_RXD3 (4) | muxctrl_reg3 ... muxctrl_reg6 @0x00C ... 0x018 | 0=RGMII0_RXD0 / 1=GPIO9_0 (first pad; others the same pattern with the pad's own number) |
        | RGMII0_TXD0 ... RGMII0_TXD3 (4) | muxctrl_reg7 ... muxctrl_reg10 @0x01C ... 0x028 | 0=RGMII0_TXD0 / 1=GPIO9_4 (first pad; others the same pattern with the pad's own number) |
        | RGMII0_RXCK | muxctrl_reg11 @0x02C | 0=RGMII0_RXCK / 1=GPIO8_0 |
        | RGMII0_TXEN | muxctrl_reg12 @0x030 | 0=RGMII0_TXEN / 1=GPIO8_1 |
        | RGMII0_TXCK | muxctrl_reg13 @0x034 | 0=RGMII0_TXCK / 1=GPIO8_2 |
        | RGMII0_TXCKOUT | muxctrl_reg14 @0x038 | 0=RGMII0_TXCKOUT / 1=GPIO8_3 / 2=RMII0_CLK |
        | RGMII0_CRS | muxctrl_reg15 @0x03C | 0=RGMII0_CRS / 1=GPIO8_4 |
        | RGMII0_COL | muxctrl_reg16 @0x040 | 0=RGMII0_COL / 1=GPIO8_5 |
        | RGMII0_RXER | muxctrl_reg17 @0x044 | 0=RGMII0_RXER / 1=GPIO8_6 |
        | RGMII1_RXDV | muxctrl_reg18 @0x048 | 0=RGMII1_RXDV / 1=GPIO10_7 |
        | RGMII1_RXD0 ... RGMII1_RXD2 (3) | muxctrl_reg19 ... muxctrl_reg21 @0x04C ... 0x054 | 0=RGMII1_RXD0 / 1=GPIO2_0 / 2=DDRPHY_DEBUG_OUT4 (first pad; others the same pattern with the pad's own number) |
        | RGMII1_RXD3 | muxctrl_reg22 @0x058 | 0=RGMII1_RXD3 / 1=GPIO2_3 |
        | RGMII1_TXD0 | muxctrl_reg23 @0x05C | 0=RGMII1_TXD0 / 1=GPIO2_4 / 2=CLK_TEST_OUT0 / 3=CLK_TEST_OUT1 / 4=CLK_TEST_OUT2 / 5=CLK_TEST_OUT3 / 6=CLK_TEST_OUT4 / 7=RTC_TEST_CLK |
        | RGMII1_TXD1 | muxctrl_reg24 @0x060 | 0=RGMII1_TXD1 / 1=GPIO2_5 / 2=PLL_TEST_OUT0 / 3=PLL_TEST_OUT1 / 4=PLL_TEST_OUT2 |
        | RGMII1_TXD2 | muxctrl_reg25 @0x064 | 0=RGMII1_TXD2 / 1=GPIO2_6 / 2=DDRPHY_DEBUG_OUT0 |
        | RGMII1_TXD3 | muxctrl_reg26 @0x068 | 0=RGMII1_TXD3 |
        | RGMII1_RXCK | muxctrl_reg27 @0x06C | 0=RGMII1_RXCK / 1=GPIO10_0 |
        | RGMII1_TXEN | muxctrl_reg28 @0x070 | 0=RGMII1_TXEN / 1=GPIO10_1 |
        | RGMII1_TXCK | muxctrl_reg29 @0x074 | 0=RGMII1_TXCK / 1=GPIO10_2 / 2=DDRPHY_DEBUG_OUT2 |
        | RGMII1_TXCKOUT | muxctrl_reg30 @0x078 | 0=RGMII1_TXCKOUT / 1=GPIO10_3 / 2=RMII1_CLK / 3=DDRPHY_DEBUG_OUT3 |
        | RGMII1_CRS | muxctrl_reg31 @0x07C | 0=RGMII1_CRS / 1=GPIO10_4 |
        | RGMII1_COL | muxctrl_reg32 @0x080 | 0=RGMII1_COL / 1=GPIO10_5 |
        | RGMII1_RXER | muxctrl_reg33 @0x084 | 0=RGMII1_RXER / 1=GPIO10_6 |
        | MDCK | muxctrl_reg34 @0x088 | 0=MDCK / 1=BOOTROM_SEL |
        | MDIO | muxctrl_reg35 @0x08C | 0=MDIO / 1=GPIO11_3 |
        | IR_IN | muxctrl_reg36 @0x090 | 0=GPIO11_7 / 1=IR_IN |
        | SFC_DIO | muxctrl_reg37 @0x094 | 0=SFC_DIO / 1=GPIO4_0 |
        | SFC_WP_IO2 | muxctrl_reg38 @0x098 | 0=SFC_WP_IO2 / 1=GPIO4_1 |
        | SFC_DOI | muxctrl_reg39 @0x09C | 0=SFC_DOI / 1=GPIO4_2 |
        | SFC_HOLD_IO3 | muxctrl_reg40 @0x0A0 | 0=SFC_HOLD_IO3 / 1=GPIO4_3 |
        | SFC_CS0N ... SFC_CS1N (2) | muxctrl_reg41 ... muxctrl_reg42 @0x0A4 ... 0x0A8 | 0=SFC_CS0N / 1=GPIO4_4 (first pad; others the same pattern with the pad's own number) |
        | NF_DQ0 ... NF_DQ7 (8) | muxctrl_reg43 ... muxctrl_reg50 @0x0AC ... 0x0C8 | 0=NF_DQ0 / 1=GPIO3_0 (first pad; others the same pattern with the pad's own number) |
        | NF_CSN0 ... NF_CSN1 (2) | muxctrl_reg51 ... muxctrl_reg52 @0x0CC ... 0x0D0 | 0=NF_CSN0 / 1=GPIO12_5 (first pad; others the same pattern with the pad's own number) |
        | NF_RDY0 ... NF_RDY1 (2) | muxctrl_reg53 ... muxctrl_reg54 @0x0D4 ... 0x0D8 | 0=NF_RDY0 / 1=Reserved (first pad; others the same pattern with the pad's own number) |
        | USB2_OVRCUR0 | muxctrl_reg55 @0x0DC | 0=GPIO5_0 / 1=USB2_OVRCUR0 |
        | USB2_PWREN0 | muxctrl_reg56 @0x0E0 | 0=GPIO5_1 / 1=USB2_PWREN0 |
        | USB2_OVRCUR1 | muxctrl_reg57 @0x0E4 | 0=GPIO5_2 / 1=USB2_OVRCUR1 |
        | USB2_PWREN1 | muxctrl_reg58 @0x0E8 | 0=GPIO5_3 / 1=USB2_PWREN1 |
        | USB3_OVRCUR | muxctrl_reg59 @0x0EC | 0=GPIO5_4 / 1=USB3_OVRCUR |
        | USB3_PWREN | muxctrl_reg60 @0x0F0 | 0=GPIO5_5 / 1=USB3_PWREN |
        | HDMI_HOTPLUG | muxctrl_reg61 @0x0F4 | 0=GPIO6_0 / 1=HDMI_HOTPLUG |
        | HDMI_CEC | muxctrl_reg62 @0x0F8 | 0=GPIO6_1 / 1=HDMI_CEC |
        | HDMI_SDA | muxctrl_reg63 @0x0FC | 0=GPIO6_2 / 1=HDMI_SDA |
        | HDMI_SCL | muxctrl_reg64 @0x100 | 0=GPIO6_3 / 1=HDMI_SCL |
        | UART0_RTSN | muxctrl_reg65 @0x104 | 0=UART0_RTSN / 1=GPIO6_4 |
        | UART0_CTSN | muxctrl_reg66 @0x108 | 0=UART0_CTSN / 1=GPIO6_5 |
        | UART1_RTSN | muxctrl_reg67 @0x10C | 0=GPIO7_0 / 1=UART1_RTSN |
        | UART1_RXD | muxctrl_reg68 @0x110 | 0=GPIO7_1 / 1=UART1_RXD |
        | UART1_CTSN | muxctrl_reg69 @0x114 | 0=GPIO7_2 / 1=UART1_CTSN |
        | UART1_TXD | muxctrl_reg70 @0x118 | 0=GPIO7_3 / 1=UART1_TXD |
        | UART2_RXD | muxctrl_reg71 @0x11C | 0=GPIO7_4 / 1=UART2_RXD |
        | UART2_TXD | muxctrl_reg72 @0x120 | 0=GPIO7_5 / 1=UART2_TXD |
        | UART3_RXD | muxctrl_reg73 @0x124 | 0=GPIO7_6 / 1=UART3_RXD |
        | UART3_TXD | muxctrl_reg74 @0x128 | 0=GPIO7_7 / 1=UART3_TXD |
        | SATA_LED_N0 ... SATA_LED_N2 (3) | muxctrl_reg75 ... muxctrl_reg77 @0x12C ... 0x134 | 0=GPIO11_4 / 1=SATA_LED_N0 (first pad; others the same pattern with the pad's own number) |
        | I2C_SDA | muxctrl_reg78 @0x138 | 0=GPIO5_6 / 1=I2C_SDA |
        | I2C_SCL | muxctrl_reg79 @0x13C | 0=GPIO5_7 / 1=I2C_SCL |
        | PWM_SVB0 ... PWM_SVB1 (2) | muxctrl_reg80 ... muxctrl_reg81 @0x140 ... 0x144 | 0=PWM_SVB0 / 1=GPIO11_0 (first pad; others the same pattern with the pad's own number) |
        | GPIO0_5 | muxctrl_reg82 @0x148 | 0=GPIO0_5 / 1=TEMPER_DQ |
        | GPIO0_6 ... GPIO0_7 (2) | muxctrl_reg83 ... muxctrl_reg84 @0x14C ... 0x150 | 0=GPIO0_6 / 1=EPHY0_CLK (first pad; others the same pattern with the pad's own number) |
        | VOU1120_DATA0 ... VOU1120_DATA1 (2) | muxctrl_reg85 ... muxctrl_reg86 @0x154 ... 0x158 | 0=GPIO13_0 / 1=VOU1120_DATA0 (first pad; others the same pattern with the pad's own number) |
        | VOU1120_DATA2 | muxctrl_reg87 @0x15C | 0=GPIO13_2 / 1=VOU1120_DATA2 / 2=AIO_SD_RX |
        | VOU1120_DATA3 | muxctrl_reg88 @0x160 | 0=GPIO13_3 / 1=VOU1120_DATA3 / 2=AIO_SD_TX |
        | VOU1120_DATA4 | muxctrl_reg89 @0x164 | 0=GPIO13_4 / 1=VOU1120_DATA4 / 2=AIO_WS_TX |
        | VOU1120_DATA5 | muxctrl_reg90 @0x168 | 0=GPIO13_5 / 1=VOU1120_DATA5 / 2=AIO_BCLK_TX |
        | VOU1120_DATA6 | muxctrl_reg91 @0x16C | 0=GPIO13_6 / 1=VOU1120_DATA6 / 2=AIO_WS_RX |
        | VOU1120_DATA7 | muxctrl_reg92 @0x170 | 0=Reserved / 1=VOU1120_DATA7 / 2=AIO_MCLK / 3=BOOT_SEL0 |
        | VOU1120_DATA8 ... VOU1120_DATA9 (2) | muxctrl_reg93 ... muxctrl_reg94 @0x174 ... 0x178 | 0=GPIO14_0 / 1=VOU1120_DATA8 (first pad; others the same pattern with the pad's own number) |
        | VOU1120_DATA10 | muxctrl_reg95 @0x17C | 0=VOU1120_DATA10 / 1=BOOT_SEL1 |
        | VOU1120_DATA11 ... VOU1120_DATA12 (2) | muxctrl_reg96 ... muxctrl_reg97 @0x180 ... 0x184 | 0=GPIO14_3 / 1=VOU1120_DATA11 (first pad; others the same pattern with the pad's own number) |
        | VOU1120_DATA13 | muxctrl_reg98 @0x188 | 0=GPIO14_5 / 1=VOU1120_DATA13 / 2=AIO_BCLK_RX |
        | VOU1120_DATA14 ... VOU1120_DATA15 (2) | muxctrl_reg99 ... muxctrl_reg100 @0x18C ... 0x190 | 0=GPIO14_6 / 1=VOU1120_DATA14 (first pad; others the same pattern with the pad's own number) |
        | VOU1120_CLK | muxctrl_reg101 @0x194 | 0=GPIO12_7 / 1=VOU1120_CLK |

        Pad drive-strength and pull controls are in the separate pad control registers of the same description (not repeated here).

        ### Power, reset and system modes (data sheet 3.1, 3.2, 3.9)

        * Resets: same scheme as the Hi3520D V100: npor from the RSTN pin (low for more than 12 XIN cycles), global soft reset from the system controller (at least 360 system clock cycles), per-module soft resets in the PERI_CRG registers (hold-until-cleared). Slave boot mode keeps the CPU in reset (SYS_CTRL: cpu0 reset only valid in slave load mode, PERI_CRG description).
        * System modes: NORMAL (APLL enabled, ARM subsystem on the PLL), SLOW (APLL off, 24 MHz crystal), DOZE (APLL off, 46.875 kHz divided clock).
        * CPU frequency: PERI_CRG12[8] cpu_sc_sel (0 = APLL FOUTPOSTDIV, 1 = 750 MHz); dynamic frequency scaling by clock skipping: a9clk_skipcfg PERI_CRG10[24:20] (N = clock pulses removed per 32 cycles; with the 750 MHz source N = 1 gives 750 x 31 / 32 = 726.25 MHz) with the load strobe a9clk_loaden PERI_CRG10[25] (write the value, write loaden 0, then 1).
        * DDR source (slow mode only): PERI_CRG12[5:4] ddr_sc_sel (400 / 324 / 300 MHz or APLL FOUT1PH0); bus source (slow mode only): PERI_CRG12[2:0] bus_sc_sel (hpaxi 324 or 250 MHz, mdaaxi 324 or 250 MHz, sysaxi 250 or 200 MHz).
        * Six PLLs: APLL PERI_CRG0/1, BPLL PERI_CRG2/3, VPLL0 PERI_CRG4/5, VPLL1 PERI_CRG6/7, VPLL2 PERI_CRG72/73, EPLL PERI_CRG8/9; VCO must be 600 MHz to 2.4 GHz.
        * The data sheet has no separate power-domain table.

        ### Interrupts (Cortex-A9 GIC interrupt IDs, data sheet Table 3-25); the data sheet is Chinese, names translated

        | # | Source | # | Source | # | Source |
        |---|---|---|---|---|---|
        | 0-31 | For A9 internal use | 53 | USB2.0 OHCI | 75 | VGS |
        | 32 | COMMTX[0] | 54 | USB2.0 EHCI | 76 | AIO |
        | 33 | COMMRX[0] | 55 | Temp Capture | 77 | HDMI |
        | 34 | WatchDog | 56 | Reserved | 78 | SCD0 |
        | 35 | Timer0 | 57 | Reserved | 79 | SCD1 |
        | 36 | Timer1 | 58 | Reserved | 80 | PCIE_INTA |
        | 37 | Timer2 | 59 | TOE_INTR | 81 | PCIE_INTB |
        | 38 | Timer3 | 60 | TOE_LPI_INTR | 82 | PCIE_INTC |
        | 39 | RTC | 61 | Software Int | 83 | PCIE_INTD |
        | 40 | UART0 | 62 | Reserved | 84 | PCIE_DMA |
        | 41 | UART1 | 63 | SATA | 85 | PCIE_MSI |
        | 42 | UART2 | 64 | USB 3.0 | 86 | PCIE_LINK_DOWN |
        | 43 | UART3 | 65 | VDP | 87 | Reserved |
        | 44 | L2 Controller | 66 | IVE | 88 | Reserved |
        | 45 | A9 PMU[0] | 67 | VDH0 | 89 | Reserved |
        | 46 | DMAC | 68 | VENC | 90 | A9 PMU[1] |
        | 47 | I2C | 69 | VPSS | 91 | GPIO0~GPIO3 |
        | 48 | NFC | 70 | JPGD | 92 | GPIO4~GPIO8 |
        | 49 | SFC | 71 | MD/DDRT | 93 | GPIO9~GPIO14 |
        | 50 | IR | 72 | VDH1 | 94 | COMMTX[1] |
        | 51 | Cipher | 73 | TDE | 95 | COMMRX[1] |
        | 52 | Reserved | 74 | JPGE |  |  |

        ### Clock-gate and reset map (generated from the CRG registers)

        | Offset | Register | Description | Gate / reset fields |
        |---|---|---|---|
        | 0x028 | PERI_CRG10 | PERI_CRG10 | arm_srst_req_0, cluster_dbg_srst_req_0, sc_wd_srst_req_0, arm_srst_req_1, cluster_dbg_srst_req_1, sc_wd_srst_req_1, cluster_peri_srst_req, cluster_scu_srst_req, cs_srst_req, a9_peri_cken, ... |
        | 0x034 | PERI_CRG13 | PERI_CRG13 | vo_srst_req, hddac_cken, sddac_cken, vou_hcken, vou_hd0_cken, vou_hd1_cken, vou_sd_cken, vou_cken, bt1120_cken |
        | 0x038 | PERI_CRG14 | PERI_CRG14 | pwm_srst_req, pwm_cken |
        | 0x03C | PERI_CRG15 | PERI_CRG15 | hdmi_srst_req, hdmi_hrst_req, hdmi_bus_cken, hdmi_id_cken, hdmi_as_cken, hdmi_os_cken, hdmi_cec_cken, hdmi_mhl_cken |
        | 0x040 | PERI_CRG16 | PERI_CRG16 | vedu_srst_req, vedu_cken, sed_cken |
        | 0x048 | PERI_CRG18 | PERI_CRG18 | vps_srst_req, vps_cken |
        | 0x050 | PERI_CRG20 | PERI_CRG20 | vdh0_all_srst_req, vdh0_mfd_srst_req, vdh0_scd_srst_req, vdh0_cken |
        | 0x054 | PERI_CRG21 | PERI_CRG21 | vdh1_all_srst_req, vdh1_mfd_srst_req, vdh1_scd_srst_req, vdh1_cken |
        | 0x058 | PERI_CRG22 | PERI_CRG22 | tde_srst_req, tde_cken |
        | 0x05C | PERI_CRG23 | PERI_CRG23 | vgs_srst_req, vgs_cken |
        | 0x060 | PERI_CRG24 | PERI_CRG24 | jpge_srst_req, jpge_cken |
        | 0x064 | PERI_CRG25 | PERI_CRG25 | jpgd_srst_req, jpgd_cken |
        | 0x068 | PERI_CRG26 | PERI_CRG26 | mdu_srst_req, mdu_cken |
        | 0x06C | PERI_CRG27 | PERI_CRG27 | vapu_srst_req, vapu_cken |
        | 0x07C | PERI_CRG31 | PERI_CRG31 | cipher_srst_req, cipher_cken |
        | 0x08C | PERI_CRG35 | PERI_CRG35 | aio_hrst_req, aio_hcken |
        | 0x0AC | PERI_CRG43 | PERI_CRG43 | sata_phy0_ref_cken, sata_phy1_ref_cken, cmb_phy_ref_cken |
        | 0x0B0 | PERI_CRG44 | PERI_CRG44 | pcie_bus_cken, pcie_rx0_cken, pcie_aux_cken, pcie_cko_alive_cken, pcie_mpll_dword_cken, pcie_refclk_cken, pcie_bus_srst_req, pcie_cko_alive_srst_req |
        | 0x0B4 | PERI_CRG45 | PERI_CRG45 | sata_bus_cken, sata_rx0_cken, sata_rx1_cken, sata_rx2_cken, sata_cko_alive_cken, sata_mpll_dword0_cken, sata_refclk0_cken, sata_bus_srst_req, sata_cko_alive_srst_req, sata_mpll_dword1_cken, ... |
        | 0x0B8 | PERI_CRG46 | PERI_CRG46 | usb2_ahb_srst_req, usb2_cken, usb3_vcc_srst_req, usb3_phy_srst_req, usb3_phy_srst_treq, usb3_phy_ref_cken, usb3_ref_ssp_en, usb3_bus_cken, usb3_ref_cken, usb3_suspend_cken, ... |
        | 0x0C0 | PERI_CRG48 | PERI_CRG48 | sfc_srst_req, sfc_cken |
        | 0x0C8 | PERI_CRG50 | PERI_CRG50 | toe_srst_req, toe_cken, toe_hrst_req, toe_hcken, gmac0_if_srst_req, gmac0_if_cken, gmac1_if_srst_req, gmac1_if_cken |
        | 0x0D0 | PERI_CRG52 | PERI_CRG52 | nfc_srst_req, nfc_cken |
        | 0x0D8 | PERI_CRG54 | PERI_CRG54 | ddrtest_srst_req, ddrtest_cken |
        | 0x0E0 | PERI_CRG56 | PERI_CRG56 | dma_srst_req, dma_cken |
        | 0x0E4 | PERI_CRG57 | PERI_CRG57 | test_clk_en, i2c_srst_req, tcap_srst_req, ir_srst_req, ssp0_srst_req, ssp1_srst_req, uart0_srst_req, uart1_srst_req, uart2_srst_req, uart3_srst_req, ... |
        | 0x0F4 | PERI_CRG61 | PERI_CRG61 | vdh1_all_srst_ok, vdh1_mfd_srst_ok, vdh1_scd_srst_ok, vdh0_all_srst_ok, vdh0_mfd_srst_ok, vdh0_scd_srst_ok |
        | 0x12C | PERI_CRG75 | PERI_CRG75 | core_hpm_en, core_hpm_monitor_en, core_hpm_srst_req |
        | 0x13C | PERI_CRG79 | PERI_CRG79 | cpu_hpm_en, cpu_hpm_monitor_en, cpu_hpm_srst_req |

        Only fields whose names contain a clock-enable or reset keyword are listed; the field descriptions in the register pages give the polarity and the clocks they gate.

        ### Register blocks (generated from this description)

        | Base | Instance | Block | Register space |
        |---|---|---|---|
        | 0x10000000 | NANDC | HiSilicon parallel NAND flash controller (hinfc300/301/504 family) | 156 B |
        | 0x10010000 | SFC | System Flash Controller Registers | 1088 B |
        | 0x10030000 | OHCI | HiSilicon USB 2.0 host controller - OHCI | 92 B |
        | 0x10040000 | EHCI | HiSilicon USB 2.0 host controller - EHCI | 176 B |
        | 0x10050000 | CIPHER | CIPHER (8 channels) | 5184 B |
        | 0x12000000 | USB3 | USB 3.0 host | 50740 B |
        | 0x12010000 | SATA | SATA 3.0 AHCI generic host control | 252 B |
        | 0x12010100 | SATA_PORT[3] | SATA port configuration | 384 B |
        | 0x12020000 | TOE | GMAC and TOE (TCP offload engine) registers | 36880 B |
        | 0x20000000 | TIMER0 | Timer Registers | 28 B |
        | 0x20000020 | TIMER1 | Timer Registers | 28 B |
        | 0x20010000 | TIMER2 | Timer Registers | 28 B |
        | 0x20010020 | TIMER3 | Timer Registers | 28 B |
        | 0x20030000 | CRG | Clock and reset generator (CRG) | 332 B |
        | 0x20040000 | WDG | Watchdog Registers | 3076 B |
        | 0x20050000 | SYS_CTRL | System controller (SC) | 3824 B |
        | 0x20060000 | RTC | HiSilicon SPI-bridged RTC (APB registers) | 164 B |
        | 0x20060100 | RTC_INT | Internal RTC register file (device addresses reached through the RTC SPI interface, NOT memory mapped; the instance base 0x20060100 in the SoC map is a placeholder) | 91 B |
        | 0x20070000 | IR | HiSilicon IR receiver | 56 B |
        | 0x20080000 | UART0 | UART (ARM PrimeCell PL011) | 4 KB |
        | 0x20090000 | UART1 | UART (ARM PrimeCell PL011) | 4 KB |
        | 0x200A0000 | UART2 | UART (ARM PrimeCell PL011) | 4 KB |
        | 0x200B0000 | UART3 | UART (ARM PrimeCell PL011) | 4 KB |
        | 0x200D0000 | I2C | HiSilicon I2C Master Controller | 32 B |
        | 0x200E0000 | PWM | PWM | 60 B |
        | 0x200F0000 | IOMUX | Pin multiplexing registers (muxctrl_reg) | 408 B |
        | 0x200F0800 | IOPAD | Pin drive-strength / pad control registers (padctrl_reg) | 532 B |
        | 0x20110000 | DDRC_AXI | DDRC AXI module | 668 B |
        | 0x20111000 | DDRC_DMC | DDRC DMC module | 1208 B |
        | 0x20115000 | DDRC_MUX | DDRC MUX module | 516 B |
        | 0x20118000 | DDRC_PHY | DDRC DDRPHY module | 984 B |
        | 0x20120000 | MISC_CTRL | Peripheral (MISC) control registers | 304 B |
        | 0x20130000 | TIMER4 | Timer Registers | 28 B |
        | 0x20130020 | TIMER5 | Timer Registers | 28 B |
        | 0x20140000 | TIMER6 | Timer Registers | 28 B |
        | 0x20140020 | TIMER7 | Timer Registers | 28 B |
        | 0x20150000 | GPIO0 | ARM PL061 | 1053 B |
        | 0x20160000 | GPIO1 | ARM PL061 | 1053 B |
        | 0x20170000 | GPIO2 | ARM PL061 | 1053 B |
        | 0x20180000 | GPIO3 | ARM PL061 | 1053 B |
        | 0x20190000 | GPIO4 | ARM PL061 | 1053 B |
        | 0x201A0000 | GPIO5 | ARM PL061 | 1053 B |
        | 0x201B0000 | GPIO6 | ARM PL061 | 1053 B |
        | 0x201C0000 | GPIO7 | ARM PL061 | 1053 B |
        | 0x201D0000 | GPIO8 | ARM PL061 | 1053 B |
        | 0x201E0000 | GPIO9 | ARM PL061 | 1053 B |
        | 0x201F0000 | GPIO10 | ARM PL061 | 1053 B |
        | 0x20200000 | GPIO11 | ARM PL061 | 1053 B |
        | 0x20210000 | GPIO12 | ARM PL061 | 1053 B |
        | 0x20220000 | GPIO13 | ARM PL061 | 1053 B |
        | 0x20230000 | GPIO14 | ARM PL061 | 1053 B |
        | 0x205C0000 | VDP | Video display processor (VDP) | 62176 B |
        | 0x205E0000 | IVE | HiSilicon intelligent video engine | 28 B |
        | 0x20680000 | AIO | Audio interface (AIO) | 8624 B |
        | 0x206C0000 | MDU | Motion Detect Unit Registers | 188 B |
        | 0x20800000 | PCIE | PCIe controller registers: iATU and DMA (offsets from 0x20800000) | 2700 B |

        The table is generated from the elaborated root (instances at their absolute addresses; register space is the span of the block's registers, not the data sheet window).

        <!-- overview:end -->
    ";
    eHI3535_IOMUX              IOMUX          @ 0x200F0000;
    eHI3535_IOPAD              IOPAD          @ 0x200F0800;
    eHI3535_CRG                CRG            @ 0x20030000;
    eHI3535_SYS_CTRL           SYS_CTRL       @ 0x20050000;
    eHI3535_MISC_CTRL          MISC_CTRL      @ 0x20120000;
    eHISI_CIPHER_MC            CIPHER         @ 0x10050000;
    eHISI_TIMER_SP804          TIMER0         @ 0x20000000;
    eHISI_TIMER_SP804          TIMER1         @ 0x20000020;
    eHISI_TIMER_SP804          TIMER2         @ 0x20010000;
    eHISI_TIMER_SP804          TIMER3         @ 0x20010020;
    eHISI_TIMER_SP804          TIMER4         @ 0x20130000;
    eHISI_TIMER_SP804          TIMER5         @ 0x20130020;
    eHISI_TIMER_SP804          TIMER6         @ 0x20140000;
    eHISI_TIMER_SP804          TIMER7         @ 0x20140020;
    eHISI_WDG_SP805            WDG            @ 0x20040000;
    eHISI_RTC_SPI              RTC            @ 0x20060000;
    eHI3535_RTC_INT            RTC_INT        @ 0x20060100;
    eHI3535_DDRC_AXI           DDRC_AXI       @ 0x20110000;
    eHI3535_DDRC_DMC           DDRC_DMC       @ 0x20111000;
    eHI3535_DDRC_MUX           DDRC_MUX       @ 0x20115000;
    eHI3535_DDRC_PHY           DDRC_PHY       @ 0x20118000;
    eHISI_SFC_350              SFC            @ 0x10010000;
    eHISI_NANDC                NANDC          @ 0x10000000;
    eHI3535_TOE                TOE            @ 0x12020000;
    eMOTION_DETECT             MDU            @ 0x206C0000;
    eHISI_IVE                  IVE            @ 0x205E0000;
    eHI3535_VDP                VDP            @ 0x205C0000;
    eHI3535_AIO                AIO            @ 0x20680000;
    eHISI_I2C                  I2C            @ 0x200D0000;
    eARM_PL011                 UART0          @ 0x20080000;
    eARM_PL011                 UART1          @ 0x20090000;
    eARM_PL011                 UART2          @ 0x200A0000;
    eARM_PL011                 UART3          @ 0x200B0000;
    eHISI_IR                   IR             @ 0x20070000;
    eARM_PL061                 GPIO0          @ 0x20150000;
    eARM_PL061                 GPIO1          @ 0x20160000;
    eARM_PL061                 GPIO2          @ 0x20170000;
    eARM_PL061                 GPIO3          @ 0x20180000;
    eARM_PL061                 GPIO4          @ 0x20190000;
    eARM_PL061                 GPIO5          @ 0x201A0000;
    eARM_PL061                 GPIO6          @ 0x201B0000;
    eARM_PL061                 GPIO7          @ 0x201C0000;
    eARM_PL061                 GPIO8          @ 0x201D0000;
    eARM_PL061                 GPIO9          @ 0x201E0000;
    eARM_PL061                 GPIO10         @ 0x201F0000;
    eARM_PL061                 GPIO11         @ 0x20200000;
    eARM_PL061                 GPIO12         @ 0x20210000;
    eARM_PL061                 GPIO13         @ 0x20220000;
    eARM_PL061                 GPIO14         @ 0x20230000;
    eHISI_USB_EHCI             EHCI           @ 0x10040000;
    eHI3535_USB3               USB3           @ 0x12000000;
    eHI3535_PCIE               PCIE           @ 0x20800000;
    eHI3535_SATA               SATA           @ 0x12010000;
    eHI3535_SATA_PORT          SATA_PORT[3]   @ 0x12010100 += 0x80;
    eHI3535_PWM                PWM            @ 0x200E0000;
    eHISI_USB_OHCI             OHCI           @ 0x10030000;
};
