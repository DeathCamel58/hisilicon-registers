`ifndef EHI3535_MISC_CTRL_RDL
`define EHI3535_MISC_CTRL_RDL
regfile eHI3535_MISC_CTRL {
    name = "Peripheral (MISC) control registers";
    desc = "Peripheral (MISC) control registers. 64 registers extracted programmatically from the Hi3535 H.264 codec processor (Hi3535 user guide) data sheet (Issue 00B08, 2014-02-25); chapter 3.4.5, table 3-27. Field names, bit ranges, access types and reset values are taken from the register tables; reset values are the data sheet total reset values split onto the fields (per-field values where the table has them). Label: PROVEN. Hardware not verified here (no board).";
    reg {
        name = "MISC_CTRL0";
        desc = "MISC_CTRL0 is the CPU control register. This register is not reset by a system soft reset. MISC_CTRL0 (offset 0x0000, total reset 0x0000_0000; PROVEN: Hi3535 data sheet, PDF page 418, section 3.4.5.2).";
        field {
            name = "reserved";
            desc = "Reserved.";
            sw = r; hw = w;
            reset = 0x0;
        } reserved_31_6[31:6];
        field {
            name = "l2_spniden";
            desc = "Secure privileged non-invasive debug enable.";
            sw = rw; hw = r;
            reset = 0x0;
        } l2_spniden[5:5];
        field {
            name = "a9_cfgsdisable";
            desc = "Masks write access to the key internal configuration registers of the processor, including ICDDCR[0]=EnableSecure, the secure interrupts defined in ICDICTR, and ICCICR (excluding the EnableNS control bit).
- 0: Disable;
- 1: Enable";
            sw = rw; hw = r;
            reset = 0x0;
        } a9_cfgsdisable[4:4];
        field {
            name = "a9_cfgnmfi";
            desc = "CPU fast interrupt used as non-maskable interrupt enable.
- 00: Disable;
- 01: Enable the CPU0 fast interrupt as a non-maskable interrupt;
- 10: Enable the CPU1 fast interrupt as a non-maskable interrupt;
- 11: Enable the CPU0 and CPU1 fast interrupts as non-maskable interrupts.";
            sw = rw; hw = r;
            reset = 0x0;
        } a9_cfgnmfi[3:2];
        field {
            name = "a9_cp15sdiable";
            desc = "Mask write accesses to the processor's internal security registers, including c1 (SCTLR), c2 (TTBR0 and TTBCR), c3 (DACR), c10 (PRRR and NMRR), c12 (VBAR and MVBAR) and c13 (FCSEIDR) in the CP15 coprocessor.
- 00: Disable;
- 01: Enable for CPU0;
- 10: Enable for CPU1;
- 11: Enable for CPU0 and CPU1.";
            sw = rw; hw = r;
            reset = 0x0;
        } a9_cp15sdiable[1:0];
    } MISC_CTRL0 @ 0x0;
    reg {
        name = "MISC_CTRL1";
        desc = "MISC_CTRL1 is the peripheral function selection register. This register is not reset by a system soft reset. MISC_CTRL1 (offset 0x0004, total reset 0x0000_1C00; PROVEN: Hi3535 data sheet, PDF page 419, section 3.4.5.2).";
        field {
            name = "jtag_fun_sel";
            desc = "JTAG function selection. When JTAG_SEL_CPU is 0, this register determines the function of the JTAG pins.
- 00: USB3 PHY JTAG;
- 01: SATA3 PHY0 JTAG;
- 10: SATA3 PHY1 JTAG;
- 11: COMB PHY JTAG.";
            sw = rw; hw = r;
            reset = 0x0;
        } jtag_fun_sel[31:30];
        field {
            name = "reserved";
            desc = "Reserved.";
            sw = r; hw = w;
            reset = 0x0;
        } reserved_29_13[29:13];
        field {
            name = "pcie_sata_mode_sel";
            desc = "PCIe function enable.
- 0: PCIe function off; SATA Port2 is enabled.
- 1: PCIe function enabled; SATA Port2 is off.";
            sw = rw; hw = r;
            reset = 0x1;
        } pcie_sata_mode_sel[12:12];
        field {
            name = "hdmi_audio_tx_sel";
            desc = "HDMI audio channel select.
- 0: The HDMI audio channel is connected to AIO TX0;
- 1: The HDMI audio channel is connected to AIO TX1.";
            sw = rw; hw = r;
            reset = 0x1;
        } hdmi_audio_tx_sel[11:11];
        field {
            name = "pad_i2c_tx_sel";
            desc = "AIO pin TX channel select.
- 0: The AIO pin TX channel is connected to AIO TX0;
- 1: The AIO pin TX channel is connected to AIO TX1.";
            sw = rw; hw = r;
            reset = 0x1;
        } pad_i2c_tx_sel[10:10];
        field {
            name = "audiocodec_tx_sel";
            desc = "Audio Codec TX path selection.
- 0: The Audio Codec Tx channel is connected to AIO TX0;
- 1: The Audio Codec Tx channel is connected to AIO TX1.";
            sw = rw; hw = r;
            reset = 0x0;
        } audiocodec_tx_sel[9:9];
        field {
            name = "aio_rx_sel";
            desc = "AIO RX path select.
- 0: The AIO RX path is connected to the internal Audio Codec.
- 1: The AIO RX path is connected to the AIO pins.";
            sw = rw; hw = r;
            reset = 0x0;
        } aio_rx_sel[8:8];
        field {
            name = "reserved";
            desc = "Reserved.";
            sw = r; hw = w;
            reset = 0x0;
        } reserved_7_7[7:7];
        field {
            name = "rom_pgen";
            desc = "ROM power supply enable.
- 0: Enable;
- 1: Disable.";
            sw = rw; hw = r;
            reset = 0x0;
        } rom_pgen[6:6];
        field {
            name = "ram2_ck_gt_en";
            desc = "RAM2 clock gate enable.
- 0: Disable;
- 1: Enable.";
            sw = rw; hw = r;
            reset = 0x0;
        } ram2_ck_gt_en[5:5];
        field {
            name = "ram1_ck_gt_en";
            desc = "RAM1 clock gating enable.
- 0: Disable;
- 1: Enable.";
            sw = rw; hw = r;
            reset = 0x0;
        } ram1_ck_gt_en[4:4];
        field {
            name = "ram0_ck_gt_en";
            desc = "RAM0 clock gate enable.
- 0: Disable;
- 1: Enable.";
            sw = rw; hw = r;
            reset = 0x0;
        } ram0_ck_gt_en[3:3];
        field {
            name = "mdu_ddrt_mst_sel";
            desc = "MDU and DDRT function select.
- 0: MDU enabled, DDRT disabled.
- 1: DDRT enabled, MDU disabled.";
            sw = rw; hw = r;
            reset = 0x0;
        } mdu_ddrt_mst_sel[2:2];
        field {
            name = "reserved";
            desc = "Reserved.";
            sw = r; hw = w;
            reset = 0x0;
        } reserved_1_1[1:1];
        field {
            name = "reserved";
            desc = "Reserved.";
            sw = r; hw = w;
            reset = 0x0;
        } reserved_0_0[0:0];
    } MISC_CTRL1 @ 0x4;
    reg {
        name = "MISC_CTRL2";
        desc = "MISC_CTRL2 is the CPU Memory speed adjustment register. This register is not reset by a system soft reset. MISC_CTRL2 (offset 0x0008, total reset 0x0211_D5D5; PROVEN: Hi3535 data sheet, PDF page 421, section 3.4.5.2).";
        field {
            name = "reserved";
            desc = "Reserved.";
            sw = r; hw = w;
            reset = 0x0;
        } reserved_31_27[31:27];
        field {
            name = "l2_dataram_ema";
            desc = "MEM speed adjustment value, valid for both reads and writes. 000 is the fastest, 111 is the slowest. Note 1: this value can only be modified statically and must be set before the MEM runs. Note 2: setting this value below the default makes MEM reads and writes unreliable.";
            sw = rw; hw = r;
            reset = 0x2;
        } l2_dataram_ema[26:24];
        field {
            name = "l2_dataram_emaw";
            desc = "MEM write speed adjustment value. 00 is the fastest and 11 is the slowest. The total MEM write speed adjustment value is emaw+ema. Note 1: This value can only be modified statically and must be set before the MEM runs. Note 2: Setting this value lower than the default makes MEM reads and writes risky.";
            sw = rw; hw = r;
            reset = 0x0;
        } l2_dataram_emaw[23:22];
        field {
            name = "l2_tagram_delay";
            desc = "L2 TagRam speed adjustment control.";
            sw = rw; hw = r;
            reset = 0x1;
        } l2_tagram_delay[21:20];
        field {
            name = "a9_hsmem_adjust";
            desc = "A9 high-speed memory speed regulation control.";
            sw = rw; hw = r;
            reset = 0x1d5d5;
        } a9_hsmem_adjust[19:0];
    } MISC_CTRL2 @ 0x8;
    reg {
        name = "MISC_CTRL6";
        desc = "MISC_CTRL6 is system bus arbitration control register 0. MISC_CTRL6 (offset 0x0018, total reset 0x0000_0000; PROVEN: Hi3535 data sheet, PDF page 422, section 3.4.5.2).";
        field {
            name = "sys_timeout_en_m2";
            desc = "Timeout count enable of system bus port M2 (AHB_SUBSYS).
- 0: Disable;
- 1: Enable.";
            sw = rw; hw = r;
            reset = 0x0;
        } sys_timeout_en_m2[31:31];
        field {
            name = "sys_timeout_value_m2";
            desc = "Timeout count value of system bus port M2 (AHB_SUBSYS). Count value = sys_timeout_value_m2 x 2.";
            sw = rw; hw = r;
            reset = 0x0;
        } sys_timeout_value_m2[30:16];
        field {
            name = "sys_timeout_en_m1";
            desc = "Timeout counter enable for system bus port M1 (CPU).
- 0: Disable;
- 1: Enable.";
            sw = rw; hw = r;
            reset = 0x0;
        } sys_timeout_en_m1[15:15];
        field {
            name = "sys_timeout_value_m1";
            desc = "Timeout count value of system bus port M1 (CPU). Count value = sys_timeout_value_m1 x 2.";
            sw = rw; hw = r;
            reset = 0x0;
        } sys_timeout_value_m1[14:0];
    } MISC_CTRL6 @ 0x18;
    reg {
        name = "MISC_CTRL7";
        desc = "MISC_CTRL7 is system bus arbitration control register 1. MISC_CTRL7 (offset 0x001C, total reset 0x0000_0000; PROVEN: Hi3535 data sheet, PDF page 423, section 3.4.5.2).";
        field {
            name = "reserved";
            desc = "Reserved.";
            sw = r; hw = w;
            reset = 0x0;
        } reserved_31_16[31:16];
        field {
            name = "sys_timeout_en_m3";
            desc = "Timeout counter enable of system bus port M3 (PCIE).
- 0: Disable.
- 1: Enable.";
            sw = rw; hw = r;
            reset = 0x0;
        } sys_timeout_en_m3[15:15];
        field {
            name = "sys_timeout_value_m3";
            desc = "Timeout count value of system bus port M3 (PCIE). Count value = sys_timeout_value_m3 x 2.";
            sw = rw; hw = r;
            reset = 0x0;
        } sys_timeout_value_m3[14:0];
    } MISC_CTRL7 @ 0x1c;
    reg {
        name = "MISC_CTRL8";
        desc = "MISC_CTRL8 is system bus priority register 0. MISC_CTRL8 (offset 0x0020, total reset 0x0000_0012; PROVEN: Hi3535 data sheet, PDF page 423, section 3.4.5.2).";
        field {
            name = "reserved";
            desc = "Reserved.";
            sw = r; hw = w;
            reset = 0x0;
        } reserved_31_11[31:11];
        field {
            name = "sys_pri_m3";
            desc = "Priority of system bus port M3 (PCIE). 3 is the highest priority.";
            sw = rw; hw = r;
            reset = 0x0;
        } sys_pri_m3[10:8];
        field {
            name = "reserved";
            desc = "Reserved.";
            sw = r; hw = w;
            reset = 0x0;
        } reserved_7_7[7:7];
        field {
            name = "sys_pri_m2";
            desc = "Priority of system bus port M2 (AHB_SUBSYS). 3 is the highest priority.";
            sw = rw; hw = r;
            reset = 0x1;
        } sys_pri_m2[6:4];
        field {
            name = "reserved";
            desc = "Reserved.";
            sw = r; hw = w;
            reset = 0x0;
        } reserved_3_3[3:3];
        field {
            name = "sys_pri_m1";
            desc = "Priority of system bus M1 (CPU) port. 3 is the highest priority.";
            sw = rw; hw = r;
            reset = 0x2;
        } sys_pri_m1[2:0];
    } MISC_CTRL8 @ 0x20;
    reg {
        name = "MISC_CTRL9";
        desc = "MISC_CTRL9 is system bus priority register 1. MISC_CTRL9 (offset 0x0024, total reset 0x0001_2345; PROVEN: Hi3535 data sheet, PDF page 424, section 3.4.5.2).";
        field {
            name = "reserved";
            desc = "Reserved.";
            sw = r; hw = w;
            reset = 0x0;
        } reserved_31_23[31:23];
        field {
            name = "sys_pri_s6";
            desc = "Bus access priority of system bus port S6 (HP_PERI). 7 is the highest priority.";
            sw = rw; hw = r;
            reset = 0x0;
        } sys_pri_s6[22:20];
        field {
            name = "reserved";
            desc = "Reserved.";
            sw = r; hw = w;
            reset = 0x0;
        } reserved_19_19[19:19];
        field {
            name = "sys_pri_s5";
            desc = "Bus access priority of system bus port S5 (PCIE). 7 is the highest priority.";
            sw = rw; hw = r;
            reset = 0x1;
        } sys_pri_s5[18:16];
        field {
            name = "reserved";
            desc = "Reserved.";
            sw = r; hw = w;
            reset = 0x0;
        } reserved_15_15[15:15];
        field {
            name = "sys_pri_s4";
            desc = "Bus access priority of system bus port S4 (DDR). 7 is the highest priority.";
            sw = rw; hw = r;
            reset = 0x2;
        } sys_pri_s4[14:12];
        field {
            name = "reserved";
            desc = "Reserved.";
            sw = r; hw = w;
            reset = 0x0;
        } reserved_11_11[11:11];
        field {
            name = "sys_pri_s3";
            desc = "Bus access priority of system bus port S3 (MEDIA). 7 is the highest priority.";
            sw = rw; hw = r;
            reset = 0x3;
        } sys_pri_s3[10:8];
        field {
            name = "reserved";
            desc = "Reserved.";
            sw = r; hw = w;
            reset = 0x0;
        } reserved_7_7[7:7];
        field {
            name = "sys_pri_s2";
            desc = "Bus access priority of system bus port S2 (APB_SUBSYS). 7 is the highest priority.";
            sw = rw; hw = r;
            reset = 0x4;
        } sys_pri_s2[6:4];
        field {
            name = "reserved";
            desc = "Reserved.";
            sw = r; hw = w;
            reset = 0x0;
        } reserved_3_3[3:3];
        field {
            name = "sys_pri_s1";
            desc = "Bus access priority of system bus port S1 (AHB_SUBSYS). 7 is the highest priority.";
            sw = rw; hw = r;
            reset = 0x5;
        } sys_pri_s1[2:0];
    } MISC_CTRL9 @ 0x24;
    reg {
        name = "MISC_CTRL11";
        desc = "MISC_CTRL11 is MEDIA0 bus arbitration control register 0. MISC_CTRL11 (offset 0x002C, total reset 0x0000_0000; PROVEN: Hi3535 data sheet, PDF page 425, section 3.4.5.2).";
        field {
            name = "media0_timeout_en_m2";
            desc = "Timeout counting enable of MEDIA0 bus port M2 (VDH1).
- 0: Disable.
- 1: Enable.";
            sw = rw; hw = r;
            reset = 0x0;
        } media0_timeout_en_m2[31:31];
        field {
            name = "media0_timeout_value_m2";
            desc = "Timeout count value of MEDIA0 bus port M2 (VDH1). Count value = media0_timeout_value_m2 x 2.";
            sw = rw; hw = r;
            reset = 0x0;
        } media0_timeout_value_m2[30:16];
        field {
            name = "media0_timeout_en_m1";
            desc = "Timeout counter enable of MEDIA0 bus port M1 (VDH0).
- 0: Disable.
- 1: Enable.";
            sw = rw; hw = r;
            reset = 0x0;
        } media0_timeout_en_m1[15:15];
        field {
            name = "media0_timeout_value_m1";
            desc = "Timeout count value of MEDIA0 bus port M1 (VDH0). Count value = media0_timeout_value_m1 x 2.";
            sw = rw; hw = r;
            reset = 0x0;
        } media0_timeout_value_m1[14:0];
    } MISC_CTRL11 @ 0x2c;
    reg {
        name = "MISC_CTRL12";
        desc = "MISC_CTRL12 is MEDIA0 bus arbitration control register 1. MISC_CTRL12 (offset 0x0030, total reset 0x0000_0000; PROVEN: Hi3535 data sheet, PDF page 426, section 3.4.5.2).";
        field {
            name = "media0_timeout_en_m4";
            desc = "Timeout counting enable of MEDIA0 bus port M4 (JPGD).
- 0: Disable.
- 1: Enable.";
            sw = rw; hw = r;
            reset = 0x0;
        } media0_timeout_en_m4[31:31];
        field {
            name = "media0_timeout_value_m4";
            desc = "Timeout count value of MEDIA0 bus port M4 (JPGD). Count value = media0_timeout_value_m4 x 2.";
            sw = rw; hw = r;
            reset = 0x0;
        } media0_timeout_value_m4[30:16];
        field {
            name = "media0_timeout_en_m3";
            desc = "Timeout count enable of MEDIA0 bus port M3 (TDE).
- 0: Disable;
- 1: Enable.";
            sw = rw; hw = r;
            reset = 0x0;
        } media0_timeout_en_m3[15:15];
        field {
            name = "media0_timeout_value_m3";
            desc = "Timeout counter value of MEDIA0 bus port M3 (TDE). Count value = media0_timeout_value_m3 x 2.";
            sw = rw; hw = r;
            reset = 0x0;
        } media0_timeout_value_m3[14:0];
    } MISC_CTRL12 @ 0x30;
    reg {
        name = "MISC_CTRL13";
        desc = "MISC_CTRL13 is MEDIA0 bus arbitration control register 2. MISC_CTRL13 (offset 0x0034, total reset 0x0000_0000; PROVEN: Hi3535 data sheet, PDF page 427, section 3.4.5.2).";
        field {
            name = "reserved";
            desc = "Reserved.";
            sw = r; hw = w;
            reset = 0x0;
        } reserved_31_16[31:16];
        field {
            name = "media0_timeout_en_m5";
            desc = "Timeout count enable of MEDIA0 bus port M5 (MDU).
- 0: Disable;
- 1: Enable.";
            sw = rw; hw = r;
            reset = 0x0;
        } media0_timeout_en_m5[15:15];
        field {
            name = "media0_timeout_value_m5";
            desc = "Timeout count value of MEDIA0 bus port M5 (MDU). Count value = media0_timeout_value_m5 x 2.";
            sw = rw; hw = r;
            reset = 0x0;
        } media0_timeout_value_m5[14:0];
    } MISC_CTRL13 @ 0x34;
    reg {
        name = "MISC_CTRL14";
        desc = "MISC_CTRL14 is the MEDIA0 bus priority register. MISC_CTRL14 (offset 0x0038, total reset 0x0001_2345; PROVEN: Hi3535 data sheet, PDF page 427, section 3.4.5.2).";
        field {
            name = "reserved";
            desc = "Reserved.";
            sw = r; hw = w;
            reset = 0x0;
        } reserved_31_19[31:19];
        field {
            name = "media0_pri_m5";
            desc = "Priority of MEDIA0 bus port M5 (MDU). 7 is the highest priority.";
            sw = rw; hw = r;
            reset = 0x1;
        } media0_pri_m5[18:16];
        field {
            name = "reserved";
            desc = "Reserved.";
            sw = r; hw = w;
            reset = 0x0;
        } reserved_15_15[15:15];
        field {
            name = "media0_pri_m4";
            desc = "Priority of MEDIA0 bus port M4 (JPGD). 7 is the highest priority.";
            sw = rw; hw = r;
            reset = 0x2;
        } media0_pri_m4[14:12];
        field {
            name = "reserved";
            desc = "Reserved.";
            sw = r; hw = w;
            reset = 0x0;
        } reserved_11_11[11:11];
        field {
            name = "media0_pri_m3";
            desc = "Priority of MEDIA0 bus port M3 (TDE). 7 is the highest priority.";
            sw = rw; hw = r;
            reset = 0x3;
        } media0_pri_m3[10:8];
        field {
            name = "reserved";
            desc = "Reserved.";
            sw = r; hw = w;
            reset = 0x0;
        } reserved_7_7[7:7];
        field {
            name = "media0_pri_m2";
            desc = "MEDIA0 bus port M2 (VDH1) priority. 7 is the highest priority.";
            sw = rw; hw = r;
            reset = 0x4;
        } media0_pri_m2[6:4];
        field {
            name = "reserved";
            desc = "Reserved.";
            sw = r; hw = w;
            reset = 0x0;
        } reserved_3_3[3:3];
        field {
            name = "media0_pri_m1";
            desc = "Priority of MEDIA0 bus port M1 (VDH0). 7 is the highest priority.";
            sw = rw; hw = r;
            reset = 0x5;
        } media0_pri_m1[2:0];
    } MISC_CTRL14 @ 0x38;
    reg {
        name = "MISC_CTRL15";
        desc = "MISC_CTRL15 is MEDIA1 bus arbitration control register 0. MISC_CTRL15 (offset 0x003C, total reset 0x0000_0000; PROVEN: Hi3535 data sheet, PDF page 428, section 3.4.5.2).";
        field {
            name = "media1_timeout_en_m2";
            desc = "Timeout count enable of MEDIA1 bus port M2 (VENC).
- 0: Disable;
- 1: Enable.";
            sw = rw; hw = r;
            reset = 0x0;
        } media1_timeout_en_m2[31:31];
        field {
            name = "media1_timeout_value_m2";
            desc = "Timeout counter value of MEDIA1 bus port M2 (VENC). Count value = media0_timeout_value_m2 x 2.";
            sw = rw; hw = r;
            reset = 0x0;
        } media1_timeout_value_m2[30:16];
        field {
            name = "media1_timeout_en_m1";
            desc = "Timeout counting enable of MEDIA1 bus port M1 (VPSS).
- 0: Disable.
- 1: Enable.";
            sw = rw; hw = r;
            reset = 0x0;
        } media1_timeout_en_m1[15:15];
        field {
            name = "media1_timeout_value_m1";
            desc = "Timeout count value of MEDIA1 bus port M1 (VPSS). Count value = media0_timeout_value_m1 x 2.";
            sw = rw; hw = r;
            reset = 0x0;
        } media1_timeout_value_m1[14:0];
    } MISC_CTRL15 @ 0x3c;
    reg {
        name = "MISC_CTRL16";
        desc = "MISC_CTRL16 is MEDIA1 bus arbitration control register 1. MISC_CTRL16 (offset 0x0040, total reset 0x0000_0000; PROVEN: Hi3535 data sheet, PDF page 429, section 3.4.5.2).";
        field {
            name = "media1_timeout_en_m4";
            desc = "Timeout count enable of MEDIA1 bus port M4 (JPGE).
- 0: Disable;
- 1: Enable.";
            sw = rw; hw = r;
            reset = 0x0;
        } media1_timeout_en_m4[31:31];
        field {
            name = "media1_timeout_value_m4";
            desc = "Timeout count value of MEDIA1 bus port M4 (JPGE). Count value = media1_timeout_value_m4 x 2.";
            sw = rw; hw = r;
            reset = 0x0;
        } media1_timeout_value_m4[30:16];
        field {
            name = "media1_timeout_en_m3";
            desc = "Timeout counting enable of MEDIA1 bus port M3 (VGS).
- 0: Disable.
- 1: Enable.";
            sw = rw; hw = r;
            reset = 0x0;
        } media1_timeout_en_m3[15:15];
        field {
            name = "media1_timeout_value_m3";
            desc = "Timeout count value of MEDIA1 bus port M3 (VGS). Count value = media1_timeout_value_m3 x 2.";
            sw = rw; hw = r;
            reset = 0x0;
        } media1_timeout_value_m3[14:0];
    } MISC_CTRL16 @ 0x40;
    reg {
        name = "MISC_CTRL17";
        desc = "MISC_CTRL17 is MEDIA1 bus arbitration control register 2. MISC_CTRL17 (offset 0x0044, total reset 0x0000_0000; PROVEN: Hi3535 data sheet, PDF page 430, section 3.4.5.2).";
        field {
            name = "reserved";
            desc = "Reserved.";
            sw = r; hw = w;
            reset = 0x0;
        } reserved_31_16[31:16];
        field {
            name = "media1_timeout_en_m5";
            desc = "Timeout counting enable of MEDIA1 bus port M5 (AIO).
- 0: Disable.
- 1: Enable.";
            sw = rw; hw = r;
            reset = 0x0;
        } media1_timeout_en_m5[15:15];
        field {
            name = "media1_timeout_value_m5";
            desc = "Timeout count value of MEDIA1 bus port M5 (AIO). Count value = media1_timeout_value_m5 x 2.";
            sw = rw; hw = r;
            reset = 0x0;
        } media1_timeout_value_m5[14:0];
    } MISC_CTRL17 @ 0x44;
    reg {
        name = "MISC_CTRL18";
        desc = "MISC_CTRL18 is the MEDIA1 bus priority register. MISC_CTRL18 (offset 0x0048, total reset 0x0001_2345; PROVEN: Hi3535 data sheet, PDF page 430, section 3.4.5.2).";
        field {
            name = "reserved";
            desc = "Reserved.";
            sw = r; hw = w;
            reset = 0x0;
        } reserved_31_19[31:19];
        field {
            name = "media1_pri_m5";
            desc = "Priority of MEDIA1 bus port M5 (AIO). 7 is the highest priority.";
            sw = rw; hw = r;
            reset = 0x1;
        } media1_pri_m5[18:16];
        field {
            name = "reserved";
            desc = "Reserved.";
            sw = r; hw = w;
            reset = 0x0;
        } reserved_15_15[15:15];
        field {
            name = "media1_pri_m4";
            desc = "Priority of MEDIA1 bus port M4 (JPGE). 7 is the highest priority.";
            sw = rw; hw = r;
            reset = 0x2;
        } media1_pri_m4[14:12];
        field {
            name = "reserved";
            desc = "Reserved.";
            sw = r; hw = w;
            reset = 0x0;
        } reserved_11_11[11:11];
        field {
            name = "media1_pri_m3";
            desc = "Priority of MEDIA1 bus port M3 (VGS). 7 is the highest priority.";
            sw = rw; hw = r;
            reset = 0x3;
        } media1_pri_m3[10:8];
        field {
            name = "reserved";
            desc = "Reserved.";
            sw = r; hw = w;
            reset = 0x0;
        } reserved_7_7[7:7];
        field {
            name = "media1_pri_m2";
            desc = "Priority of MEDIA1 bus port M2 (VENC). 7 is the highest priority.";
            sw = rw; hw = r;
            reset = 0x4;
        } media1_pri_m2[6:4];
        field {
            name = "reserved";
            desc = "Reserved.";
            sw = r; hw = w;
            reset = 0x0;
        } reserved_3_3[3:3];
        field {
            name = "media1_pri_m1";
            desc = "Priority of MEDIA1 bus port M1 (VPSS). 7 is the highest priority.";
            sw = rw; hw = r;
            reset = 0x5;
        } media1_pri_m1[2:0];
    } MISC_CTRL18 @ 0x48;
    reg {
        name = "MISC_CTRL19";
        desc = "MISC_CTRL19 is HPPERI bus arbitration control register 0. MISC_CTRL19 (offset 0x004C, total reset 0x0000_0000; PROVEN: Hi3535 data sheet, PDF page 431, section 3.4.5.2).";
        field {
            name = "hpperi_timeout_en_m2";
            desc = "Timeout counter enable of HPPERI bus port M2 (USB3).
- 0: Disable.
- 1: Enable.";
            sw = rw; hw = r;
            reset = 0x0;
        } hpperi_timeout_en_m2[31:31];
        field {
            name = "hpperi_timeout_value_m2";
            desc = "Timeout count value of HPPERI bus port M2 (USB3). Count value = hpperi_timeout_value_m2 x 2.";
            sw = rw; hw = r;
            reset = 0x0;
        } hpperi_timeout_value_m2[30:16];
        field {
            name = "hpperi_timeout_en_m1";
            desc = "Timeout counter enable for HPPERI bus port M1 (SATA3).
- 0: Disable;
- 1: Enable.";
            sw = rw; hw = r;
            reset = 0x0;
        } hpperi_timeout_en_m1[15:15];
        field {
            name = "hpperi_timeout_value_m1";
            desc = "Timeout count value of HPPERI bus port M1 (SATA3). Count value = hpperi_timeout_value_m1 x 2.";
            sw = rw; hw = r;
            reset = 0x0;
        } hpperi_timeout_value_m1[14:0];
    } MISC_CTRL19 @ 0x4c;
    reg {
        name = "MISC_CTRL20";
        desc = "MISC_CTRL20 is HPPERI bus arbitration control register 1. MISC_CTRL20 (offset 0x0050, total reset 0x0000_0000; PROVEN: Hi3535 data sheet, PDF page 432, section 3.4.5.2).";
        field {
            name = "reserved";
            desc = "Reserved.";
            sw = r; hw = w;
            reset = 0x0;
        } reserved_31_16[31:16];
        field {
            name = "hpperi_timeout_en_m3";
            desc = "Timeout counter enable of HPPERI bus port M3 (VAPU).
- 0: Disable;
- 1: Enable.";
            sw = rw; hw = r;
            reset = 0x0;
        } hpperi_timeout_en_m3[15:15];
        field {
            name = "hpperi_timeout_value_m3";
            desc = "Timeout count value of HPPERI bus port M3 (VAPU). Count value = hpperi_timeout_value_m3 x 2.";
            sw = rw; hw = r;
            reset = 0x0;
        } hpperi_timeout_value_m3[14:0];
    } MISC_CTRL20 @ 0x50;
    reg {
        name = "MISC_CTRL21";
        desc = "MISC_CTRL21 is the HPPERI bus priority register. MISC_CTRL21 (offset 0x0054, total reset 0x0000_0123; PROVEN: Hi3535 data sheet, PDF page 433, section 3.4.5.2).";
        field {
            name = "reserved";
            desc = "Reserved.";
            sw = r; hw = w;
            reset = 0x0;
        } reserved_31_11[31:11];
        field {
            name = "hpperi_pri_m3";
            desc = "Priority of HPPERI bus port M3 (VAPU). 3 is the highest priority.";
            sw = rw; hw = r;
            reset = 0x1;
        } hpperi_pri_m3[10:8];
        field {
            name = "reserved";
            desc = "Reserved.";
            sw = r; hw = w;
            reset = 0x0;
        } reserved_7_7[7:7];
        field {
            name = "hpperi_pri_m2";
            desc = "Priority of HPPERI bus port M2 (USB3). 3 is the highest priority.";
            sw = rw; hw = r;
            reset = 0x2;
        } hpperi_pri_m2[6:4];
        field {
            name = "reserved";
            desc = "Reserved.";
            sw = r; hw = w;
            reset = 0x0;
        } reserved_3_3[3:3];
        field {
            name = "hpperi_pri_m1";
            desc = "Priority of HPPERI bus port M1 (SATA3). 3 is the highest priority.";
            sw = rw; hw = r;
            reset = 0x3;
        } hpperi_pri_m1[2:0];
    } MISC_CTRL21 @ 0x54;
    reg {
        name = "MISC_CTRL22";
        desc = "MISC_CTRL22 is DDRC priority control register 0. MISC_CTRL22 (offset 0x0058, total reset 0x7654_3210; PROVEN: Hi3535 data sheet, PDF page 433, section 3.4.5.2).";
        field {
            name = "reserved";
            desc = "Reserved.";
            sw = r; hw = w;
            reset = 0x0;
        } reserved_31_31[31:31];
        field {
            name = "cipher_qosmap";
            desc = "Qos value of the CIPHER in the MDDRC.";
            sw = rw; hw = r;
            reset = 0x7;
        } cipher_qosmap[30:28];
        field {
            name = "reserved";
            desc = "Reserved.";
            sw = r; hw = w;
            reset = 0x0;
        } reserved_27_27[27:27];
        field {
            name = "dma2_qosmap";
            desc = "QoS value of DMA2 in the MDDRC.";
            sw = rw; hw = r;
            reset = 0x6;
        } dma2_qosmap[26:24];
        field {
            name = "reserved";
            desc = "Reserved.";
            sw = r; hw = w;
            reset = 0x0;
        } reserved_23_23[23:23];
        field {
            name = "dma1_qosmap";
            desc = "QoS value of DMA1 in the MDDRC.";
            sw = rw; hw = r;
            reset = 0x5;
        } dma1_qosmap[22:20];
        field {
            name = "reserved";
            desc = "Reserved.";
            sw = r; hw = w;
            reset = 0x0;
        } reserved_19_19[19:19];
        field {
            name = "usb3_qosmap";
            desc = "QoS value of the USB3 in the MDDRC.";
            sw = rw; hw = r;
            reset = 0x4;
        } usb3_qosmap[18:16];
        field {
            name = "reserved";
            desc = "Reserved.";
            sw = r; hw = w;
            reset = 0x0;
        } reserved_15_15[15:15];
        field {
            name = "sata3_qosmap";
            desc = "Qos value of SATA3 in the MDDRC.";
            sw = rw; hw = r;
            reset = 0x3;
        } sata3_qosmap[14:12];
        field {
            name = "reserved";
            desc = "Reserved.";
            sw = r; hw = w;
            reset = 0x0;
        } reserved_11_11[11:11];
        field {
            name = "vapu_qosmap";
            desc = "QoS value of VAPU in the MDDRC.";
            sw = rw; hw = r;
            reset = 0x2;
        } vapu_qosmap[10:8];
        field {
            name = "reserved";
            desc = "Reserved.";
            sw = r; hw = w;
            reset = 0x0;
        } reserved_7_7[7:7];
        field {
            name = "gmac_qosmap";
            desc = "QoS value of the GMAC in the MDDRC.";
            sw = rw; hw = r;
            reset = 0x1;
        } gmac_qosmap[6:4];
        field {
            name = "reserved";
            desc = "Reserved.";
            sw = r; hw = w;
            reset = 0x0;
        } reserved_3_3[3:3];
        field {
            name = "a9_qosmap";
            desc = "QoS value of the A9 in the MDDRC.";
            sw = rw; hw = r;
            reset = 0x0;
        } a9_qosmap[2:0];
    } MISC_CTRL22 @ 0x58;
    reg {
        name = "MISC_CTRL23";
        desc = "MISC_CTRL23 is DDRC priority control register 1. MISC_CTRL23 (offset 0x005C, total reset 0x7654_3210; PROVEN: Hi3535 data sheet, PDF page 434, section 3.4.5.2).";
        field {
            name = "reserved";
            desc = "Reserved.";
            sw = r; hw = w;
            reset = 0x0;
        } reserved_31_31[31:31];
        field {
            name = "vedu_qosmap";
            desc = "Qos value of VEDU in the MDDRC.";
            sw = rw; hw = r;
            reset = 0x7;
        } vedu_qosmap[30:28];
        field {
            name = "reserved";
            desc = "Reserved.";
            sw = r; hw = w;
            reset = 0x0;
        } reserved_27_27[27:27];
        field {
            name = "vdh0_qosmap";
            desc = "Qos value of VDH0 in the MDDRC.";
            sw = rw; hw = r;
            reset = 0x6;
        } vdh0_qosmap[26:24];
        field {
            name = "reserved";
            desc = "Reserved.";
            sw = r; hw = w;
            reset = 0x0;
        } reserved_23_23[23:23];
        field {
            name = "vdp_qosmap";
            desc = "QoS value of VDP in MDDRC.";
            sw = rw; hw = r;
            reset = 0x5;
        } vdp_qosmap[22:20];
        field {
            name = "reserved";
            desc = "Reserved.";
            sw = r; hw = w;
            reset = 0x0;
        } reserved_19_19[19:19];
        field {
            name = "pcie_qosmap";
            desc = "QoS value of the PCIE in the MDDRC.";
            sw = rw; hw = r;
            reset = 0x4;
        } pcie_qosmap[18:16];
        field {
            name = "reserved";
            desc = "Reserved.";
            sw = r; hw = w;
            reset = 0x0;
        } reserved_15_15[15:15];
        field {
            name = "sfc_qosmap";
            desc = "QoS value of the SFC in the MDDRC.";
            sw = rw; hw = r;
            reset = 0x3;
        } sfc_qosmap[14:12];
        field {
            name = "reserved";
            desc = "Reserved.";
            sw = r; hw = w;
            reset = 0x0;
        } reserved_11_11[11:11];
        field {
            name = "usb2_qosmap";
            desc = "QoS value of USB2 in the MDDRC.";
            sw = rw; hw = r;
            reset = 0x2;
        } usb2_qosmap[10:8];
        field {
            name = "reserved";
            desc = "Reserved.";
            sw = r; hw = w;
            reset = 0x0;
        } reserved_7_7[7:7];
        field {
            name = "nandc_qosmap";
            desc = "QoS value of the NANDC in the MDDRC.";
            sw = rw; hw = r;
            reset = 0x1;
        } nandc_qosmap[6:4];
        field {
            name = "reserved";
            desc = "Reserved.";
            sw = r; hw = w;
            reset = 0x0;
        } reserved_3_3[3:3];
        field {
            name = "reserved";
            desc = "Reserved.";
            sw = r; hw = w;
            reset = 0x0;
        } reserved_2_0[2:0];
    } MISC_CTRL23 @ 0x5c;
    reg {
        name = "MISC_CTRL24";
        desc = "MISC_CTRL24 is DDRC priority control register 2. MISC_CTRL24 (offset 0x0060, total reset 0x7654_3210; PROVEN: Hi3535 data sheet, PDF page 435, section 3.4.5.2).";
        field {
            name = "reserved";
            desc = "Reserved.";
            sw = r; hw = w;
            reset = 0x0;
        } reserved_31_31[31:31];
        field {
            name = "aio_qosmap";
            desc = "QoS value of the AIO in the MDDRC.";
            sw = rw; hw = r;
            reset = 0x7;
        } aio_qosmap[30:28];
        field {
            name = "reserved";
            desc = "Reserved.";
            sw = r; hw = w;
            reset = 0x0;
        } reserved_27_27[27:27];
        field {
            name = "vgs_qosmap";
            desc = "QoS value of the VGS in the MDDRC.";
            sw = rw; hw = r;
            reset = 0x6;
        } vgs_qosmap[26:24];
        field {
            name = "reserved";
            desc = "Reserved.";
            sw = r; hw = w;
            reset = 0x0;
        } reserved_23_23[23:23];
        field {
            name = "jpge_qosmap";
            desc = "QoS value of the JPGE in the MDDRC.";
            sw = rw; hw = r;
            reset = 0x5;
        } jpge_qosmap[22:20];
        field {
            name = "reserved";
            desc = "Reserved.";
            sw = r; hw = w;
            reset = 0x0;
        } reserved_19_19[19:19];
        field {
            name = "tde_qosmap";
            desc = "QoS value of TDE in MDDRC.";
            sw = rw; hw = r;
            reset = 0x4;
        } tde_qosmap[18:16];
        field {
            name = "reserved";
            desc = "Reserved.";
            sw = rw; hw = r;
            reset = 0x0;
        } reserved_15_15[15:15];
        field {
            name = "vdh1_qosmap";
            desc = "Qos value of VDH1 in the MDDRC.";
            sw = rw; hw = r;
            reset = 0x3;
        } vdh1_qosmap[14:12];
        field {
            name = "reserved";
            desc = "Reserved.";
            sw = r; hw = w;
            reset = 0x0;
        } reserved_11_11[11:11];
        field {
            name = "md_ddrt_qosmap";
            desc = "QoS value of MD_DDRT in the MDDRC.";
            sw = rw; hw = r;
            reset = 0x2;
        } md_ddrt_qosmap[10:8];
        field {
            name = "reserved";
            desc = "Reserved.";
            sw = r; hw = w;
            reset = 0x0;
        } reserved_7_7[7:7];
        field {
            name = "jpgd_qosmap";
            desc = "QoS value of the JPGD in the MDDRC.";
            sw = rw; hw = r;
            reset = 0x1;
        } jpgd_qosmap[6:4];
        field {
            name = "reserved";
            desc = "Reserved.";
            sw = r; hw = w;
            reset = 0x0;
        } reserved_3_3[3:3];
        field {
            name = "vpss_qosmap";
            desc = "Qos value of VPSS in the MDDRC.";
            sw = rw; hw = r;
            reset = 0x0;
        } vpss_qosmap[2:0];
    } MISC_CTRL24 @ 0x60;
    reg {
        name = "MISC_CTRL25";
        desc = "MISC_CTRL25 is DDRC priority control register 3. MISC_CTRL25 (offset 0x0064, total reset 0x0000_0000; PROVEN: Hi3535 data sheet, PDF page 436, section 3.4.5.2).";
        field {
            name = "reserved";
            desc = "Reserved.";
            sw = r; hw = w;
            reset = 0x0;
        } reserved_31_30[31:30];
        field {
            name = "cipher_timeout";
            desc = "Timeout value of CIPHER in MDDRC.";
            sw = rw; hw = r;
            reset = 0x0;
        } cipher_timeout[29:28];
        field {
            name = "reserved";
            desc = "Reserved.";
            sw = r; hw = w;
            reset = 0x0;
        } reserved_27_26[27:26];
        field {
            name = "dma2_timeout";
            desc = "Timeout value of DMA2 in the MDDRC.";
            sw = rw; hw = r;
            reset = 0x0;
        } dma2_timeout[25:24];
        field {
            name = "reserved";
            desc = "Reserved.";
            sw = r; hw = w;
            reset = 0x0;
        } reserved_23_22[23:22];
        field {
            name = "dma1_timeout";
            desc = "Timeout value of DMA1 in the MDDRC.";
            sw = rw; hw = r;
            reset = 0x0;
        } dma1_timeout[21:20];
        field {
            name = "reserved";
            desc = "Reserved.";
            sw = r; hw = w;
            reset = 0x0;
        } reserved_19_18[19:18];
        field {
            name = "usb3_timeout";
            desc = "Timeout value of USB3 in MDDRC.";
            sw = rw; hw = r;
            reset = 0x0;
        } usb3_timeout[17:16];
        field {
            name = "reserved";
            desc = "Reserved.";
            sw = r; hw = w;
            reset = 0x0;
        } reserved_15_14[15:14];
        field {
            name = "sata3_timeout";
            desc = "Timeout value of the SATA3 in the MDDRC.";
            sw = rw; hw = r;
            reset = 0x0;
        } sata3_timeout[13:12];
        field {
            name = "reserved";
            desc = "Reserved.";
            sw = r; hw = w;
            reset = 0x0;
        } reserved_11_10[11:10];
        field {
            name = "vapu_timeout";
            desc = "Timeout value of VAPU in MDDRC.";
            sw = rw; hw = r;
            reset = 0x0;
        } vapu_timeout[9:8];
        field {
            name = "reserved";
            desc = "Reserved.";
            sw = r; hw = w;
            reset = 0x0;
        } reserved_7_6[7:6];
        field {
            name = "gmac_timeout";
            desc = "Timeout value of the GMAC in the MDDRC.";
            sw = rw; hw = r;
            reset = 0x0;
        } gmac_timeout[5:4];
        field {
            name = "reserved";
            desc = "Reserved.";
            sw = r; hw = w;
            reset = 0x0;
        } reserved_3_2[3:2];
        field {
            name = "a9_timeout";
            desc = "Timeout value of the A9 in the MDDRC.";
            sw = rw; hw = r;
            reset = 0x0;
        } a9_timeout[1:0];
    } MISC_CTRL25 @ 0x64;
    reg {
        name = "MISC_CTRL26";
        desc = "MISC_CTRL26 is DDRC priority control register 4. MISC_CTRL26 (offset 0x0068, total reset 0x0000_0000; PROVEN: Hi3535 data sheet, PDF page 437, section 3.4.5.2).";
        field {
            name = "reserved";
            desc = "Reserved.";
            sw = r; hw = w;
            reset = 0x0;
        } reserved_31_30[31:30];
        field {
            name = "vedu_timeout";
            desc = "Timeout value of the VEDU in the MDDRC.";
            sw = rw; hw = r;
            reset = 0x0;
        } vedu_timeout[29:28];
        field {
            name = "reserved";
            desc = "Reserved.";
            sw = r; hw = w;
            reset = 0x0;
        } reserved_27_26[27:26];
        field {
            name = "vdh0_timeout";
            desc = "Timeout value of VDH0 in the MDDRC.";
            sw = rw; hw = r;
            reset = 0x0;
        } vdh0_timeout[25:24];
        field {
            name = "reserved";
            desc = "Reserved.";
            sw = r; hw = w;
            reset = 0x0;
        } reserved_23_22[23:22];
        field {
            name = "vdp_timeout";
            desc = "Timeout value of the VDP in the MDDRC.";
            sw = rw; hw = r;
            reset = 0x0;
        } vdp_timeout[21:20];
        field {
            name = "reserved";
            desc = "Reserved.";
            sw = r; hw = w;
            reset = 0x0;
        } reserved_19_18[19:18];
        field {
            name = "pcie_timeout";
            desc = "Timeout value of the PCIE in the MDDRC.";
            sw = rw; hw = r;
            reset = 0x0;
        } pcie_timeout[17:16];
        field {
            name = "reserved";
            desc = "Reserved.";
            sw = r; hw = w;
            reset = 0x0;
        } reserved_15_14[15:14];
        field {
            name = "sfc_timeout";
            desc = "Timeout value of the SFC in the MDDRC.";
            sw = rw; hw = r;
            reset = 0x0;
        } sfc_timeout[13:12];
        field {
            name = "reserved";
            desc = "Reserved.";
            sw = r; hw = w;
            reset = 0x0;
        } reserved_11_10[11:10];
        field {
            name = "usb2_timeout";
            desc = "Timeout value of USB2 in the MDDRC.";
            sw = rw; hw = r;
            reset = 0x0;
        } usb2_timeout[9:8];
        field {
            name = "reserved";
            desc = "Reserved.";
            sw = r; hw = w;
            reset = 0x0;
        } reserved_7_6[7:6];
        field {
            name = "nandc_timeout";
            desc = "Timeout value of the NANDC in the MDDRC.";
            sw = rw; hw = r;
            reset = 0x0;
        } nandc_timeout[5:4];
        field {
            name = "reserved";
            desc = "Reserved.";
            sw = r; hw = w;
            reset = 0x0;
        } reserved_3_2[3:2];
        field {
            name = "reserved";
            desc = "Reserved.";
            sw = r; hw = w;
            reset = 0x0;
        } reserved_1_0[1:0];
    } MISC_CTRL26 @ 0x68;
    reg {
        name = "MISC_CTRL27";
        desc = "MISC_CTRL27 is DDRC priority control register 5. MISC_CTRL27 (offset 0x006C, total reset 0x0000_0000; PROVEN: Hi3535 data sheet, PDF page 438, section 3.4.5.2).";
        field {
            name = "reserved";
            desc = "Reserved.";
            sw = r; hw = w;
            reset = 0x0;
        } reserved_31_30[31:30];
        field {
            name = "aio_timeout";
            desc = "Timeout value of the AIO in the MDDRC.";
            sw = rw; hw = r;
            reset = 0x0;
        } aio_timeout[29:28];
        field {
            name = "reserved";
            desc = "Reserved.";
            sw = r; hw = w;
            reset = 0x0;
        } reserved_27_26[27:26];
        field {
            name = "vgs_timeout";
            desc = "Timeout value of VGS in the MDDRC.";
            sw = rw; hw = r;
            reset = 0x0;
        } vgs_timeout[25:24];
        field {
            name = "reserved";
            desc = "Reserved.";
            sw = r; hw = w;
            reset = 0x0;
        } reserved_23_22[23:22];
        field {
            name = "jpge_timeout";
            desc = "Timeout value of JPGE in MDDRC.";
            sw = rw; hw = r;
            reset = 0x0;
        } jpge_timeout[21:20];
        field {
            name = "reserved";
            desc = "Reserved.";
            sw = r; hw = w;
            reset = 0x0;
        } reserved_19_18[19:18];
        field {
            name = "tde_timeout";
            desc = "Timeout value of the TDE in the MDDRC.";
            sw = rw; hw = r;
            reset = 0x0;
        } tde_timeout[17:16];
        field {
            name = "reserved";
            desc = "Reserved.";
            sw = r; hw = w;
            reset = 0x0;
        } reserved_15_14[15:14];
        field {
            name = "vdh1_timeout";
            desc = "Timeout value of the VDH1 in the MDDRC.";
            sw = rw; hw = r;
            reset = 0x0;
        } vdh1_timeout[13:12];
        field {
            name = "reserved";
            desc = "Reserved.";
            sw = r; hw = w;
            reset = 0x0;
        } reserved_11_10[11:10];
        field {
            name = "md_ddrt_timeout";
            desc = "Timeout value of MD_DDRT in the MDDRC.";
            sw = rw; hw = r;
            reset = 0x0;
        } md_ddrt_timeout[9:8];
        field {
            name = "reserved";
            desc = "Reserved.";
            sw = r; hw = w;
            reset = 0x0;
        } reserved_7_6[7:6];
        field {
            name = "jpgd_timeout";
            desc = "Timeout value of JPGD in the MDDRC.";
            sw = rw; hw = r;
            reset = 0x0;
        } jpgd_timeout[5:4];
        field {
            name = "reserved";
            desc = "Reserved.";
            sw = r; hw = w;
            reset = 0x0;
        } reserved_3_2[3:2];
        field {
            name = "vpss_timeout";
            desc = "Timeout value of VPSS in MDDRC.";
            sw = rw; hw = r;
            reset = 0x0;
        } vpss_timeout[1:0];
    } MISC_CTRL27 @ 0x6c;
    reg {
        name = "MISC_CTRL28";
        desc = "MISC_CTRL28 is DDRC priority control register 6. MISC_CTRL28 (offset 0x0070, total reset 0x0000_0000; PROVEN: Hi3535 data sheet, PDF page 439, section 3.4.5.2).";
        field {
            name = "ddrphy_dbgmux_sel";
            desc = "DDR PHY debug signal output select.";
            sw = rw; hw = r;
            reset = 0x0;
        } ddrphy_dbgmux_sel[31:28];
        field {
            name = "reserved";
            desc = "Reserved.";
            sw = r; hw = w;
            reset = 0x0;
        } reserved_27_0[27:0];
    } MISC_CTRL28 @ 0x70;
    reg {
        name = "MISC_CTRL30";
        desc = "MISC_CTRL30 is USB 2.0 control register 0. MISC_CTRL30 (offset 0x0078, total reset 0x0003_33A8; PROVEN: Hi3535 data sheet, PDF page 439, section 3.4.5.2).";
        field {
            name = "reserved";
            desc = "Reserved.";
            sw = r; hw = w;
            reset = 0x0;
        } reserved_31_21[31:21];
        field {
            name = "preamble_sel";
            desc = "Selects the number of full-speed idle cycles after the full-speed signal preamble packet.
- 0: 5 full-speed idle cycles after the full-speed signal preamble packet;
- 1: 4 full-speed idle cycles after the full-speed signal preamble packet.";
            sw = rw; hw = r;
            reset = 0x0;
        } preamble_sel[20:20];
        field {
            name = "ovr_merge_en";
            desc = "The two ports share the same overcurrent signal enable (that is, the overcurrent signal of the port whose [phy1_ovrcur_en] or [phy0_ovrcur_en] is 1).
- 0: Disable;
- 1: Enable.";
            sw = rw; hw = r;
            reset = 0x0;
        } ovr_merge_en[19:19];
        field {
            name = "pwr_merge_en";
            desc = "As long as one port is powered on, both [phy1_pwr_en] and [phy0_pwr_en] are enabled.
- 0: Disable;
- 1: Enable.";
            sw = rw; hw = r;
            reset = 0x0;
        } pwr_merge_en[18:18];
        field {
            name = "usbovr_p_ctrl";
            desc = "Overcurrent protection polarity control.
- 0: Active low;
- 1: Active high.";
            sw = rw; hw = r;
            reset = 0x1;
        } usbovr_p_ctrl[17:17];
        field {
            name = "usbpwr_p_ctrl";
            desc = "Power enable polarity control.
- 0: Active low;
- 1: Active high.";
            sw = rw; hw = r;
            reset = 0x1;
        } usbpwr_p_ctrl[16:16];
        field {
            name = "phy1_ovrcur_en";
            desc = "USB 2.0 PORT1 overcurrent protection control.
- 0: Disable overcurrent protection;
- 1: Enable overcurrent protection.";
            sw = rw; hw = r;
            reset = 0x0;
        } phy1_ovrcur_en[15:15];
        field {
            name = "phy0_ovrcur_en";
            desc = "USB 2.0 PORT0 overcurrent protection off control.
- 0: Overcurrent protection off;
- 1: Overcurrent protection enabled.";
            sw = rw; hw = r;
            reset = 0x0;
        } phy0_ovrcur_en[14:14];
        field {
            name = "phy1_pwr_en";
            desc = "USB 2.0 PORT1 power-off control.
- 0: Power off.
- 1: Enable the power output of the USB2.0 controller.";
            sw = rw; hw = r;
            reset = 0x1;
        } phy1_pwr_en[13:13];
        field {
            name = "phy0_pwr_en";
            desc = "USB 2.0 PORT0 power control.
- 0: Power off.
- 1: Enable the power output of the USB2.0 controller.";
            sw = rw; hw = r;
            reset = 0x1;
        } phy0_pwr_en[12:12];
        field {
            name = "reserved";
            desc = "Reserved.";
            sw = r; hw = w;
            reset = 0x0;
        } reserved_11_10[11:10];
        field {
            name = "ss_ena_incr16_i";
            desc = "AHB burst16 enable signal.
- 0: Disable.
- 1: Enable.";
            sw = rw; hw = r;
            reset = 0x1;
        } ss_ena_incr16_i[9:9];
        field {
            name = "ss_ena_incr8_i";
            desc = "AHB burst8 enable signal.
- 0: Disable.
- 1: Enable.";
            sw = rw; hw = r;
            reset = 0x1;
        } ss_ena_incr8_i[8:8];
        field {
            name = "ss_ena_incr4_i";
            desc = "AHB burst4 enable signal.
- 0: Disable;
- 1: Enable.";
            sw = rw; hw = r;
            reset = 0x1;
        } ss_ena_incr4_i[7:7];
        field {
            name = "ss_ena_incrx_align_i";
            desc = "Burst alignment enable signal.
- 0: Disable;
- 1: Enable.";
            sw = rw; hw = r;
            reset = 0x0;
        } ss_ena_incrx_align_i[6:6];
        field {
            name = "ss_autoppd_on_overcur_en_i";
            desc = "Enable automatic port power shut-off on overcurrent.
- 0: Disable;
- 1: Enable.";
            sw = rw; hw = r;
            reset = 0x1;
        } ss_autoppd_on_overcur_en_i[5:5];
        field {
            name = "reserved";
            desc = "Reserved.";
            sw = r; hw = w;
            reset = 0x0;
        } reserved_4_4[4:4];
        field {
            name = "ulpi_bypass_en";
            desc = "ULPI bypass control. Must be set to 1.
- 0: ULPI mode.
- 1: UTMI mode.";
            sw = rw; hw = r;
            reset = 0x1;
        } ulpi_bypass_en[3:3];
        field {
            name = "app_start_clk_i";
            desc = "OHCI clock control signal.
- 0: OHCI operates normally;
- 1: Turn on the OHCI clock in suspend mode.";
            sw = rw; hw = r;
            reset = 0x0;
        } app_start_clk_i[2:2];
        field {
            name = "ohci_susp_lgcy_i";
            desc = "OHCI suspend strap input signal.";
            sw = rw; hw = r;
            reset = 0x0;
        } ohci_susp_lgcy_i[1:1];
        field {
            name = "wordinterface";
            desc = "UTMI interface data width select signal.
- 0: 8 bits.
- 1: 16 bits.";
            sw = rw; hw = r;
            reset = 0x0;
        } wordinterface[0:0];
    } MISC_CTRL30 @ 0x78;
    reg {
        name = "MISC_CTRL32";
        desc = "MISC_CTRL32 is USB2.0 control register 1. MISC_CTRL32 (offset 0x0080, total reset 0x0000_0000; PROVEN: Hi3535 data sheet, PDF page 442, section 3.4.5.2).";
        field {
            name = "reserved";
            desc = "Reserved. (data sheet access type C)";
            sw = rw; hw = r;
            reset = 0x0;
        } reserved_31_24[31:24];
        field {
            name = "usb2_phy_test_rddata";
            desc = "USB 2.0 PHY test register read data.";
            sw = r; hw = w;
            reset = 0x0;
        } usb2_phy_test_rddata[23:16];
        field {
            name = "usb2_phy_test_wrdata";
            desc = "USB 2.0 PHY test register write data.";
            sw = rw; hw = r;
            reset = 0x0;
        } usb2_phy_test_wrdata[15:8];
        field {
            name = "reserved";
            desc = "Reserved.";
            sw = r; hw = w;
            reset = 0x0;
        } reserved_7_6[7:6];
        field {
            name = "usb2_phy_test_wren";
            desc = "USB 2.0 PHY test register read/write control.";
            sw = rw; hw = r;
            reset = 0x0;
        } usb2_phy_test_wren[5:5];
        field {
            name = "usb2_phy_test_addr";
            desc = "USB 2.0 PHY test register address.";
            sw = rw; hw = r;
            reset = 0x0;
        } usb2_phy_test_addr[4:0];
    } MISC_CTRL32 @ 0x80;
    reg {
        name = "MISC_CTRL33";
        desc = "MISC_CTRL33 is USB3.0 control register 0. MISC_CTRL33 (offset 0x0084, total reset 0x0004_0F00; PROVEN: Hi3535 data sheet, PDF page 443, section 3.4.5.2).";
        field {
            name = "reserved";
            desc = "Reserved.";
            sw = r; hw = w;
            reset = 0x0;
        } reserved_31_25[31:25];
        field {
            name = "usb3_drvvbus";
            desc = "Whether to drive VBUS to 5V.
- 0: Do not drive;
- 1: Drive.";
            sw = rw; hw = r;
            reset = 0x0;
        } usb3_drvvbus[24:24];
        field {
            name = "usb3_reg_sel";
            desc = "USB register access control.
- 0x0: Register access;
- 0x4: Internal RAM0 access (debug mode);
- 0x8: Internal RAM1 access (debug mode);
- 0xC: Internal RAM2 access (debug mode).";
            sw = rw; hw = r;
            reset = 0x0;
        } usb3_reg_sel[23:20];
        field {
            name = "usb3_host_port_power_control_preset";
            desc = "Indicates whether the USB 3.0 port has power control.
- 0: The port has no power control switch; the USB device is always powered;
- 1: The port has a power control switch used to control the power supply of the USB device.";
            sw = rw; hw = r;
            reset = 0x0;
        } usb3_host_port_power_control_preset[19:19];
        field {
            name = "usb3_fladj_30mhz_reg";
            desc = "HS clock jitter control.";
            sw = rw; hw = r;
            reset = 0x20;
        } usb3_fladj_30mhz_reg[18:13];
        field {
            name = "usb3_host_msi_enable";
            desc = "Controls whether the USB 3.0 port interrupt signal is pulse type or level type.
- 0: Level type;
- 1: Pulse type.";
            sw = rw; hw = r;
            reset = 0x0;
        } usb3_host_msi_enable[12:12];
        field {
            name = "usb3_bus_filter_bypass";
            desc = "USB 3.0 bus filter bypass. This register must be set to 4.";
            sw = rw; hw = r;
            reset = 0xf;
        } usb3_bus_filter_bypass[11:8];
        field {
            name = "usb3_port_pwr_ovr_pol";
            desc = "USB 3.0 port overcurrent protection polarity control.
- 0: Active low;
- 1: Active high.";
            sw = rw; hw = r;
            reset = 0x0;
        } usb3_port_pwr_ovr_pol[7:7];
        field {
            name = "usb3_port_pwr_ctrl_pol";
            desc = "USB 3.0 port power enable polarity control.
- 0: Active low;
- 1: Active high.";
            sw = rw; hw = r;
            reset = 0x0;
        } usb3_port_pwr_ctrl_pol[6:6];
        field {
            name = "usb3_port_pwr_ovr_en";
            desc = "USB 3.0 port overcurrent protection enable.
- 0: Overcurrent protection disabled;
- 1: Overcurrent protection enabled.";
            sw = rw; hw = r;
            reset = 0x0;
        } usb3_port_pwr_ovr_en[5:5];
        field {
            name = "usb3_port_pwr_ctrl_en";
            desc = "USB 3.0 port power supply enable.
- 0: Port power control disabled;
- 1: Port power enable is output by the USB 3.0 controller.";
            sw = rw; hw = r;
            reset = 0x0;
        } usb3_port_pwr_ctrl_en[4:4];
        field {
            name = "usb3_host_u3_port_disable";
            desc = "USB 3.0 (SS) port disable.
- 0: USB 3.0 port enabled;
- 1: USB 3.0 port disabled.";
            sw = rw; hw = r;
            reset = 0x0;
        } usb3_host_u3_port_disable[3:3];
        field {
            name = "usb3_host_u2_port_disable";
            desc = "USB 2.0 (HS) port disable.
- 0: USB 2.0 port enabled;
- 1: USB 2.0 port disabled.";
            sw = rw; hw = r;
            reset = 0x0;
        } usb3_host_u2_port_disable[2:2];
        field {
            name = "usb3_hub_port_perm_attach";
            desc = "Indicates whether the downstream port device is permanently attached to the port.
- 0: Not permanently attached;
- 1: Permanently attached.";
            sw = rw; hw = r;
            reset = 0x0;
        } usb3_hub_port_perm_attach[1:0];
    } MISC_CTRL33 @ 0x84;
    reg {
        name = "MISC_CTRL34";
        desc = "MISC_CTRL34 is USB 3.0 control register 1. MISC_CTRL34 (offset 0x0088, total reset 0xB54D_0841; PROVEN: Hi3535 data sheet, PDF page 444, section 3.4.5.2).";
        field {
            name = "usb3_phy_los_bias";
            desc = "USB3 PHY loss-of-signal detection threshold level control. Must be set to 0x5.";
            sw = rw; hw = r;
            reset = 0x5;
        } usb3_phy_los_bias[31:29];
        field {
            name = "usb3_phy_fsel";
            desc = "USB3 PHY signal frequency selection. Selects the reference clock frequency. Must be set to 0x27 when the reference clock is 100MHz. Must be set to 0x2A when the reference clock is 24MHz.";
            sw = rw; hw = r;
            reset = 0x2a;
        } usb3_phy_fsel[28:23];
        field {
            name = "usb3_phy_refclk_sel";
            desc = "USB3 PHY PLL clock source select. Must be set to 0x2.";
            sw = rw; hw = r;
            reset = 0x2;
        } usb3_phy_refclk_sel[22:21];
        field {
            name = "usb3_phy_refclkdiv";
            desc = "USB3 PHY reference clock divider control. Must be set to 0x0.";
            sw = rw; hw = r;
            reset = 0x0;
        } usb3_phy_refclkdiv[20:20];
        field {
            name = "usb3_phy_mpll_multiplier";
            desc = "USB3 PHY PLL frequency multiplier control. When the reference clock is 24MHz, set to 0x68. When the reference clock is 100MHz, set to 0x19.";
            sw = rw; hw = r;
            reset = 0x68;
        } usb3_phy_mpll_multiplier[19:13];
        field {
            name = "usb3_phy_sscrefclksel";
            desc = "Clock spread spectrum adjustment. Set to 0x84 when the reference clock is 24 MHz. Set to 0x0 when the reference clock is 100 MHz.";
            sw = rw; hw = r;
            reset = 0x84;
        } usb3_phy_sscrefclksel[12:4];
        field {
            name = "usb3_phy_sscrange";
            desc = "Clock spread spectrum range.";
            sw = rw; hw = r;
            reset = 0x0;
        } usb3_phy_sscrange[3:1];
        field {
            name = "usb3_phy_sscen";
            desc = "Clock spread spectrum enable.";
            sw = rw; hw = r;
            reset = 0x1;
        } usb3_phy_sscen[0:0];
    } MISC_CTRL34 @ 0x88;
    reg {
        name = "MISC_CTRL35";
        desc = "MISC_CTRL35 is USB 3.0 control register 2. MISC_CTRL35 (offset 0x008C, total reset 0x66CC_1009; PROVEN: Hi3535 data sheet, PDF page 446, section 3.4.5.2).";
        field {
            name = "usb3_phy_mpll_refsscclken";
            desc = "Spread spectrum clock output enable.
- 0: No output.
- 1: Output.";
            sw = rw; hw = r;
            reset = 0x0;
        } usb3_phy_mpll_refsscclken[31:31];
        field {
            name = "usb3_phy_txhsxvtune";
            desc = "USB3 PHY high-speed mode eye diagram crossover point adjustment.";
            sw = rw; hw = r;
            reset = 0x3;
        } usb3_phy_txhsxvtune[30:29];
        field {
            name = "usb3_phy_txfslstune";
            desc = "USB3 PHY single-ended impedance adjustment for full-speed and high-speed modes.";
            sw = rw; hw = r;
            reset = 0x3;
        } usb3_phy_txfslstune[28:25];
        field {
            name = "usb3_phy_sqrxtune";
            desc = "USB3 PHY noise control level adjustment.";
            sw = rw; hw = r;
            reset = 0x3;
        } usb3_phy_sqrxtune[24:22];
        field {
            name = "usb3_phy_txvreftune";
            desc = "USB3 PHY high-speed mode DC level adjustment.";
            sw = rw; hw = r;
            reset = 0x3;
        } usb3_phy_txvreftune[21:18];
        field {
            name = "usb3_phy_tx0_term_offset";
            desc = "USB3 PHY transmitter termination resistance compensation.";
            sw = rw; hw = r;
            reset = 0x0;
        } usb3_phy_tx0_term_offset[17:13];
        field {
            name = "usb3_phy_compdistune";
            desc = "USB3 PHY disconnect level threshold adjustment.";
            sw = rw; hw = r;
            reset = 0x4;
        } usb3_phy_compdistune[12:10];
        field {
            name = "usb3_phy_acjtlevel";
            desc = "USB3 PHY JTAG interface receive sensitivity level setting.";
            sw = rw; hw = r;
            reset = 0x0;
        } usb3_phy_acjtlevel[9:5];
        field {
            name = "usb3_phy_los_level";
            desc = "USB3 PHY loss-of-signal detection level setting. Must be set to 0x9.";
            sw = rw; hw = r;
            reset = 0x9;
        } usb3_phy_los_level[4:0];
    } MISC_CTRL35 @ 0x8c;
    reg {
        name = "MISC_CTRL36";
        desc = "MISC_CTRL36 is USB 3.0 control register 3. MISC_CTRL36 (offset 0x0090, total reset 0x102B_7628; PROVEN: Hi3535 data sheet, PDF page 447, section 3.4.5.2).";
        field {
            name = "ubs3_phy_atereset";
            desc = "USB3 PHY ATE reset.
- 0: No reset.
- 1: Reset.";
            sw = rw; hw = r;
            reset = 0x0;
        } ubs3_phy_atereset[31:31];
        field {
            name = "usb3_pcs_tx2rx_loopbk";
            desc = "USB 3.0 port digital part loopback enable.
- 0: Disable;
- 1: Enable.";
            sw = rw; hw = r;
            reset = 0x0;
        } usb3_pcs_tx2rx_loopbk[30:30];
        field {
            name = "usb3_pcs_ext_pclk_req";
            desc = "pipe_pclk output request.
- 0: Do not output PIPE_PCLK.
- 1: Output PIPE_PCLK.";
            sw = rw; hw = r;
            reset = 0x0;
        } usb3_pcs_ext_pclk_req[29:29];
        field {
            name = "usb3_pcs_tx_deemph_6db";
            desc = "Reserved.";
            sw = r; hw = w;
            reset = 0x20;
        } usb3_pcs_tx_deemph_6db[28:23];
        field {
            name = "usb3_pcs_tx_deemph_3p5db";
            desc = "Reserved.";
            sw = r; hw = w;
            reset = 0x15;
        } usb3_pcs_tx_deemph_3p5db[22:17];
        field {
            name = "usb3_pcs_tx_swing_full";
            desc = "USB3 PHY transmitter swing control.";
            sw = rw; hw = r;
            reset = 0x5d;
        } usb3_pcs_tx_swing_full[16:10];
        field {
            name = "usb3_phy_txvboostlvl";
            desc = "USB3 PHY transmitter level drive.";
            sw = rw; hw = r;
            reset = 0x4;
        } usb3_phy_txvboostlvl[9:7];
        field {
            name = "usb3_phy_txrisetune";
            desc = "USB3 PHY transmitter rise and fall time. Each increment of this register value reduces the rise/fall time by 4%.";
            sw = rw; hw = r;
            reset = 0x1;
        } usb3_phy_txrisetune[6:5];
        field {
            name = "usb3_phy_txrestune";
            desc = "USB source impedance adjustment.";
            sw = rw; hw = r;
            reset = 0x1;
        } usb3_phy_txrestune[4:3];
        field {
            name = "usb3_phy_txpreemppulsesetune";
            desc = "USB3 PHY transmitter pre-emphasis duration control.";
            sw = rw; hw = r;
            reset = 0x0;
        } usb3_phy_txpreemppulsesetune[2:2];
        field {
            name = "usb3_phy_txpreempamptune";
            desc = "USB3 PHY transmitter pre-emphasis current control.";
            sw = rw; hw = r;
            reset = 0x0;
        } usb3_phy_txpreempamptune[1:0];
    } MISC_CTRL36 @ 0x90;
    reg {
        name = "MISC_CTRL37";
        desc = "MISC_CTRL37 is USB3.0 control register 4. MISC_CTRL37 (offset 0x0094, total reset 0x0000_40F0; PROVEN: Hi3535 data sheet, PDF page 448, section 3.4.5.2).";
        field {
            name = "usb3_phy_crwrite";
            desc = "USB3 PHY control register write enable.";
            sw = rw; hw = r;
            reset = 0x0;
        } usb3_phy_crwrite[31:31];
        field {
            name = "usb3_phy_crread";
            desc = "USB3 PHY control register read enable.
- 0: Disable;
- 1: Enable.";
            sw = rw; hw = r;
            reset = 0x0;
        } usb3_phy_crread[30:30];
        field {
            name = "usb3_phy_crcapdata";
            desc = "USB3 PHY control register data capture enable.
- 0: Disable.
- 1: Enable.";
            sw = rw; hw = r;
            reset = 0x0;
        } usb3_phy_crcapdata[29:29];
        field {
            name = "usb3_phy_crcapaddr";
            desc = "USB3 PHY control register address capture enable.
- 0: Disable;
- 1: Enable.";
            sw = rw; hw = r;
            reset = 0x0;
        } usb3_phy_crcapaddr[28:28];
        field {
            name = "reserved";
            desc = "Reserved.";
            sw = r; hw = w;
            reset = 0x0;
        } reserved_27_18[27:18];
        field {
            name = "usb3_phy_txenablen";
            desc = "USB1.1 data enable.
- 0: Enable.
- 1: Disable.";
            sw = rw; hw = r;
            reset = 0x0;
        } usb3_phy_txenablen[17:17];
        field {
            name = "usb3_phy_txbitstuffenh";
            desc = "USB 2.0 high-byte bit stuffing control.";
            sw = rw; hw = r;
            reset = 0x0;
        } usb3_phy_txbitstuffenh[16:16];
        field {
            name = "usb3_phy_txbitstuffen";
            desc = "USB 2.0 low-byte bit stuffing control.";
            sw = rw; hw = r;
            reset = 0x0;
        } usb3_phy_txbitstuffen[15:15];
        field {
            name = "usb3_phy_retenablen";
            desc = "Reserved.";
            sw = r; hw = w;
            reset = 0x1;
        } usb3_phy_retenablen[14:14];
        field {
            name = "usb3_phy_commononn";
            desc = "Whether the control and other modules are powered down when entering sleep mode.";
            sw = rw; hw = r;
            reset = 0x0;
        } usb3_phy_commononn[13:13];
        field {
            name = "usb3_phy_loopbacken";
            desc = "USB 3.0 PHY loopback test enable.";
            sw = rw; hw = r;
            reset = 0x0;
        } usb3_phy_loopbacken[12:12];
        field {
            name = "usb3_phy_testpowerdowmssp";
            desc = "USB 3.0 PHY SS function circuit power-down control.";
            sw = rw; hw = r;
            reset = 0x0;
        } usb3_phy_testpowerdowmssp[11:11];
        field {
            name = "usb3_phy_testpowerdowmhsp";
            desc = "USB 3.0 PHY HS function circuit power-down control.";
            sw = rw; hw = r;
            reset = 0x0;
        } usb3_phy_testpowerdowmhsp[10:10];
        field {
            name = "usb3_pcs_rx_los_mask_val";
            desc = "Reserved.";
            sw = r; hw = w;
            reset = 0xf0;
        } usb3_pcs_rx_los_mask_val[9:0];
    } MISC_CTRL37 @ 0x94;
    reg {
        name = "MISC_CTRL38";
        desc = "MISC_CTRL38 is USB3.0 control register 5. MISC_CTRL38 (offset 0x0098, total reset 0x0000_0000; PROVEN: Hi3535 data sheet, PDF page 449, section 3.4.5.2).";
        field {
            name = "usb3_phy_crdataout";
            desc = "USB3 PHY control register data output.";
            sw = rw; hw = r;
            reset = 0x0;
        } usb3_phy_crdataout[31:16];
        field {
            name = "usb3_phy_crdatain";
            desc = "USB3 PHY control register address and write data input.";
            sw = r; hw = w;
            reset = 0x0;
        } usb3_phy_crdatain[15:0];
    } MISC_CTRL38 @ 0x98;
    reg {
        name = "MISC_CTRL39";
        desc = "MISC_CTRL39 is SATA PHY0 control register 0. MISC_CTRL39 (offset 0x009C, total reset 0x0000_0000; PROVEN: Hi3535 data sheet, PDF page 450, section 3.4.5.2).";
        field {
            name = "reserved";
            desc = "Reserved.";
            sw = r; hw = w;
            reset = 0x0;
        } reserved_31_5[31:5];
        field {
            name = "sata_phy0_acjt_level";
            desc = "SATA PHY0 JTAG interface receive sensitivity level setting.";
            sw = rw; hw = r;
            reset = 0x0;
        } sata_phy0_acjt_level[4:0];
    } MISC_CTRL39 @ 0x9c;
    reg {
        name = "MISC_CTRL40";
        desc = "MISC_CTRL40 is SATA PHY0 control register 1. MISC_CTRL40 (offset 0x00A0, total reset 0x0000_0000; PROVEN: Hi3535 data sheet, PDF page 450, section 3.4.5.2).";
        field {
            name = "reserved";
            desc = "Reserved.";
            sw = r; hw = w;
            reset = 0x0;
        } reserved_31_4[31:4];
        field {
            name = "sata_phy0_crwrite";
            desc = "SATA PHY0 control register write enable.";
            sw = rw; hw = r;
            reset = 0x0;
        } sata_phy0_crwrite[3:3];
        field {
            name = "sata_phy0_crread";
            desc = "SATA PHY0 control register read enable.";
            sw = rw; hw = r;
            reset = 0x0;
        } sata_phy0_crread[2:2];
        field {
            name = "sata_phy0_crcapdata";
            desc = "SATA PHY0 control register data capture enable.";
            sw = rw; hw = r;
            reset = 0x0;
        } sata_phy0_crcapdata[1:1];
        field {
            name = "sata_phy0_crcapaddr";
            desc = "SATA PHY0 control register address capture enable.";
            sw = rw; hw = r;
            reset = 0x0;
        } sata_phy0_crcapaddr[0:0];
    } MISC_CTRL40 @ 0xa0;
    reg {
        name = "MISC_CTRL41";
        desc = "MISC_CTRL41 is SATA PHY0 control register 2. MISC_CTRL41 (offset 0x00A4, total reset 0x0000_0000; PROVEN: Hi3535 data sheet, PDF page 451, section 3.4.5.2).";
        field {
            name = "sata_phy0_crdataout";
            desc = "SATA PHY0 control register data output.";
            sw = r; hw = w;
            reset = 0x0;
        } sata_phy0_crdataout[31:16];
        field {
            name = "sata_phy0_crdatain";
            desc = "SATA PHY0 control register address and write data input.";
            sw = rw; hw = r;
            reset = 0x0;
        } sata_phy0_crdatain[15:0];
    } MISC_CTRL41 @ 0xa4;
    reg {
        name = "MISC_CTRL42";
        desc = "MISC_CTRL42 is SATA PHY1 control register 0. MISC_CTRL42 (offset 0x00A8, total reset 0x0000_0000; PROVEN: Hi3535 data sheet, PDF page 451, section 3.4.5.2).";
        field {
            name = "reserved";
            desc = "Reserved.";
            sw = r; hw = w;
            reset = 0x0;
        } reserved_31_5[31:5];
        field {
            name = "sata_phy1_acjt_level";
            desc = "SATA PHY1 JTAG interface receive sensitivity level setting.";
            sw = rw; hw = r;
            reset = 0x0;
        } sata_phy1_acjt_level[4:0];
    } MISC_CTRL42 @ 0xa8;
    reg {
        name = "MISC_CTRL43";
        desc = "MISC_CTRL43 is SATA PHY1 control register 1. MISC_CTRL43 (offset 0x00AC, total reset 0x0000_0000; PROVEN: Hi3535 data sheet, PDF page 452, section 3.4.5.2).";
        field {
            name = "reserved";
            desc = "Reserved.";
            sw = r; hw = w;
            reset = 0x0;
        } reserved_31_4[31:4];
        field {
            name = "sata_phy1_crwrite";
            desc = "SATA PHY1 control register write enable.";
            sw = rw; hw = r;
            reset = 0x0;
        } sata_phy1_crwrite[3:3];
        field {
            name = "sata_phy1_crread";
            desc = "SATA PHY1 control register read enable.";
            sw = rw; hw = r;
            reset = 0x0;
        } sata_phy1_crread[2:2];
        field {
            name = "sata_phy1_crcapdata";
            desc = "SATA PHY1 control register data capture enable.";
            sw = rw; hw = r;
            reset = 0x0;
        } sata_phy1_crcapdata[1:1];
        field {
            name = "sata_phy1_crcapaddr";
            desc = "SATA PHY1 control register address capture enable.";
            sw = rw; hw = r;
            reset = 0x0;
        } sata_phy1_crcapaddr[0:0];
    } MISC_CTRL43 @ 0xac;
    reg {
        name = "MISC_CTRL44";
        desc = "MISC_CTRL44 is SATA PHY1 control register 2. MISC_CTRL44 (offset 0x00B0, total reset 0x0000_0000; PROVEN: Hi3535 data sheet, PDF page 452, section 3.4.5.2).";
        field {
            name = "sata_phy1_crdataout";
            desc = "SATA PHY1 control register data output.";
            sw = r; hw = w;
            reset = 0x0;
        } sata_phy1_crdataout[31:16];
        field {
            name = "sata_phy1_crdatain";
            desc = "SATA PHY1 control register address and write data input.";
            sw = rw; hw = r;
            reset = 0x0;
        } sata_phy1_crdatain[15:0];
    } MISC_CTRL44 @ 0xb0;
    reg {
        name = "MISC_CTRL45";
        desc = "MISC_CTRL45 is COMB PHY1 control register 0. MISC_CTRL45 (offset 0x00B4, total reset 0x0000_0000; PROVEN: Hi3535 data sheet, PDF page 453, section 3.4.5.2).";
        field {
            name = "reserved";
            desc = "Reserved.";
            sw = r; hw = w;
            reset = 0x0;
        } reserved_31_5[31:5];
        field {
            name = "comb_phy_acjt_level";
            desc = "COMB PHY JTAG interface receive sensitivity level setting.";
            sw = rw; hw = r;
            reset = 0x0;
        } comb_phy_acjt_level[4:0];
    } MISC_CTRL45 @ 0xb4;
    reg {
        name = "MISC_CTRL46";
        desc = "MISC_CTRL46 is COMB PHY1 control register 1. MISC_CTRL46 (offset 0x00B8, total reset 0x0000_0000; PROVEN: Hi3535 data sheet, PDF page 453, section 3.4.5.2).";
        field {
            name = "reserved";
            desc = "Reserved.";
            sw = r; hw = w;
            reset = 0x0;
        } reserved_31_4[31:4];
        field {
            name = "comb_phy_crwrite";
            desc = "COMB PHY control register write enable.";
            sw = rw; hw = r;
            reset = 0x0;
        } comb_phy_crwrite[3:3];
        field {
            name = "comb_phy_crread";
            desc = "COMB PHY control register read enable.";
            sw = rw; hw = r;
            reset = 0x0;
        } comb_phy_crread[2:2];
        field {
            name = "comb_phy_crcapdata";
            desc = "COMB PHY control register data capture enable.";
            sw = rw; hw = r;
            reset = 0x0;
        } comb_phy_crcapdata[1:1];
        field {
            name = "comb_phy_crcapaddr";
            desc = "COMB PHY control register address capture enable.";
            sw = rw; hw = r;
            reset = 0x0;
        } comb_phy_crcapaddr[0:0];
    } MISC_CTRL46 @ 0xb8;
    reg {
        name = "MISC_CTRL47";
        desc = "MISC_CTRL47 is COMB PHY1 control register 2. MISC_CTRL47 (offset 0x00BC, total reset 0x0000_0000; PROVEN: Hi3535 data sheet, PDF page 454, section 3.4.5.2).";
        field {
            name = "comb_phy_crdataout";
            desc = "COMB PHY control register data output.";
            sw = r; hw = w;
            reset = 0x0;
        } comb_phy_crdataout[31:16];
        field {
            name = "comb_phy_crdatain";
            desc = "COMB PHY control register address and write data input.";
            sw = rw; hw = r;
            reset = 0x0;
        } comb_phy_crdatain[15:0];
    } MISC_CTRL47 @ 0xbc;
    reg {
        name = "MISC_CTRL49";
        desc = "MISC_CTRL49 is the TOE control register. MISC_CTRL49 (offset 0x00C4, total reset 0x0000_0011; PROVEN: Hi3535 data sheet, PDF page 454, section 3.4.5.2).";
        field {
            name = "reserved";
            desc = "Reserved.";
            sw = r; hw = w;
            reset = 0x0;
        } reserved_31_16[31:16];
        field {
            name = "sbd_data_endianess";
            desc = "TOE DMA data processing endian mode.
- 0: Little-endian mode;
- 1: Big-endian mode.";
            sw = rw; hw = r;
            reset = 0x0;
        } sbd_data_endianess[15:15];
        field {
            name = "reserved";
            desc = "Reserved.";
            sw = r; hw = w;
            reset = 0x0;
        } reserved_14_12[14:12];
        field {
            name = "mac1_emisc_pwr_down_ctrl";
            desc = "mac1 power off control signal, active high.";
            sw = rw; hw = r;
            reset = 0x0;
        } mac1_emisc_pwr_down_ctrl[11:11];
        field {
            name = "mac1_emisc_pwr_clamp_ctrl";
            desc = "VDD power control signal of the isolate cells of mac1, active high.";
            sw = rw; hw = r;
            reset = 0x0;
        } mac1_emisc_pwr_clamp_ctrl[10:10];
        field {
            name = "mac0_emisc_pwr_down_ctrl";
            desc = "Power off control signal of mac0, active high.";
            sw = rw; hw = r;
            reset = 0x0;
        } mac0_emisc_pwr_down_ctrl[9:9];
        field {
            name = "mac0_emisc_pwr_clamp_ctrl";
            desc = "VDD power control signal of the isolate cells of mac0, active high.";
            sw = rw; hw = r;
            reset = 0x0;
        } mac0_emisc_pwr_clamp_ctrl[8:8];
        field {
            name = "mac0_pmt_intr_enable";
            desc = "mac0 network wake-up interrupt enable signal, active high.";
            sw = rw; hw = r;
            reset = 0x0;
        } mac0_pmt_intr_enable[7:7];
        field {
            name = "mac0_lpi_intr_enable";
            desc = "Interrupt enable signal for mac0 exiting the LPI state, active high.";
            sw = rw; hw = r;
            reset = 0x0;
        } mac0_lpi_intr_enable[6:6];
        field {
            name = "mac1_pmt_intr_enable";
            desc = "mac1 network wake-up interrupt enable signal, active high.";
            sw = rw; hw = r;
            reset = 0x0;
        } mac1_pmt_intr_enable[5:5];
        field {
            name = "mac1_lpi_intr_enable";
            desc = "mac1 exit-LPI-state interrupt enable signal, active high.";
            sw = rw; hw = r;
            reset = 0x1;
        } mac1_lpi_intr_enable[4:4];
        field {
            name = "reserved";
            desc = "Reserved.";
            sw = r; hw = w;
            reset = 0x1;
        } reserved_3_0[3:0];
    } MISC_CTRL49 @ 0xc4;
    reg {
        name = "MISC_CTRL50";
        desc = "MISC_CTRL50 is Audio Codec control register 0. MISC_CTRL50 (offset 0x00C8, total reset 0xFCCC_0000; PROVEN: Hi3535 data sheet, PDF page 456, section 3.4.5.2).";
        field {
            name = "pd_adcl";
            desc = "ADCL power-down control signal.
- 0: ADCL works normally.
- 1: ADCL powered down.";
            sw = rw; hw = r;
            reset = 0x1;
        } pd_adcl[31:31];
        field {
            name = "pd_adcr";
            desc = "ADCR power-down control signal.
- 0: ADCR operates normally;
- 1: ADCR powered down.";
            sw = rw; hw = r;
            reset = 0x1;
        } pd_adcr[30:30];
        field {
            name = "pd_dacl";
            desc = "DACL power-down control signal.
- 0: DACL operates normally;
- 1: DACL powered down.";
            sw = rw; hw = r;
            reset = 0x1;
        } pd_dacl[29:29];
        field {
            name = "pd_dacr";
            desc = "DACR power-down control signal.
- 0: DACR operates normally.
- 1: DACR powered down.";
            sw = rw; hw = r;
            reset = 0x1;
        } pd_dacr[28:28];
        field {
            name = "pd_micbias";
            desc = "Microphone bias circuit power-down control signal.
- 0: Microphone bias operates normally.
- 1: Microphone bias powered down.";
            sw = rw; hw = r;
            reset = 0x1;
        } pd_micbias[27:27];
        field {
            name = "pd_vref";
            desc = "Reference voltage power-down control signal.
- 0: Reference voltage operates normally;
- 1: Reference voltage powered down.";
            sw = rw; hw = r;
            reset = 0x1;
        } pd_vref[26:26];
        field {
            name = "fstartup";
            desc = "Reference voltage fast power-up control signal.
- 0: Reference voltage powers up normally;
- 1: Reference voltage powers up quickly (0.1s).";
            sw = rw; hw = r;
            reset = 0x0;
        } fstartup[25:25];
        field {
            name = "ana_loop";
            desc = "Analog loopback control signal.
- 0: Normal mode;
- 1: Analog circuit loopback mode.";
            sw = rw; hw = r;
            reset = 0x0;
        } ana_loop[24:24];
        field {
            name = "mute_dacl";
            desc = "DACL analog mute control.
- 0: DACL operates normally;
- 1: DACL muted.";
            sw = rw; hw = r;
            reset = 0x1;
        } mute_dacl[23:23];
        field {
            name = "mute_dacr";
            desc = "DACR analog mute control.
- 0: DACR operates normally.
- 1: DACR muted.";
            sw = rw; hw = r;
            reset = 0x1;
        } mute_dacr[22:22];
        field {
            name = "pop_freel";
            desc = "DACL pop noise suppression control signal.
- 0: Pop suppression disabled;
- 1: Pop suppression enabled. When the reference voltage is powered up and no other path is open, the codec enters an ultra-low-power mode and charges the DACL output to AVDD/2.";
            sw = rw; hw = r;
            reset = 0x0;
        } pop_freel[21:21];
        field {
            name = "pop_freer";
            desc = "DACR pop noise suppression control signal.
- 0: Pop noise suppression off;
- 1: Pop noise suppression on. When the reference voltage is powered up and no other path is enabled, the device enters an ultra-low-power mode and charges the DACR output to AVDD/2.";
            sw = rw; hw = r;
            reset = 0x0;
        } pop_freer[20:20];
        field {
            name = "mute_adcl";
            desc = "ADCL analog mute control.
- 0: ADCL works normally.
- 1: ADCL muted.";
            sw = rw; hw = r;
            reset = 0x1;
        } mute_adcl[19:19];
        field {
            name = "mute_adcr";
            desc = "ADCR analog mute control.
- 0: ADCR operates normally;
- 1: ADCR muted.";
            sw = rw; hw = r;
            reset = 0x1;
        } mute_adcr[18:18];
        field {
            name = "mclk_ana_sel";
            desc = "MCLK clock edge select control.
- 0: Same edge as the digital MCLK.
- 1: Opposite edge to the digital MCLK.";
            sw = rw; hw = r;
            reset = 0x0;
        } mclk_ana_sel[17:17];
        field {
            name = "dacclk_sel";
            desc = "DAC clock edge control signal.
- 0: Same edge as CLK_ADC.
- 1: Opposite edge to CLK_ADC.";
            sw = rw; hw = r;
            reset = 0x0;
        } dacclk_sel[16:16];
        field {
            name = "lineinl_sel";
            desc = "LINEINL input signal select.
- 0: LINEINL input;
- 1: MICP_L input.";
            sw = rw; hw = r;
            reset = 0x0;
        } lineinl_sel[15:15];
        field {
            name = "gain_micl";
            desc = "LINEINL input gain control. Gain formula: ((gain_micl)*1.5-16.5) dB.";
            sw = rw; hw = r;
            reset = 0x0;
        } gain_micl[14:10];
        field {
            name = "gainboostl";
            desc = "LINEINL gain boost control.
- 0: 0db gain.
- 1: 26db gain.";
            sw = rw; hw = r;
            reset = 0x0;
        } gainboostl[9:9];
        field {
            name = "clk_timing_sel";
            desc = "ADC CLK timing select.
- 0: Select the first clock timing.
- 1: Select the second clock timing.";
            sw = rw; hw = r;
            reset = 0x0;
        } clk_timing_sel[8:8];
        field {
            name = "lineinr_sel";
            desc = "LINEINR input signal select.
- 0: LINEINR input;
- 1: MICP_R input.";
            sw = rw; hw = r;
            reset = 0x0;
        } lineinr_sel[7:7];
        field {
            name = "gain_micr";
            desc = "LINEINR input gain control. Gain formula: ((gain_micr)*1.5-16.5) dB.";
            sw = rw; hw = r;
            reset = 0x0;
        } gain_micr[6:2];
        field {
            name = "gainboostr";
            desc = "LINEINR gain boost control.
- 0: 0dB gain.
- 1: 26dB gain.";
            sw = rw; hw = r;
            reset = 0x0;
        } gainboostr[1:1];
        field {
            name = "clk_delay_sel";
            desc = "Whether to add delay to ADC CLK.
- 0: No delay;
- 1: Delay.";
            sw = rw; hw = r;
            reset = 0x0;
        } clk_delay_sel[0:0];
    } MISC_CTRL50 @ 0xc8;
    reg {
        name = "MISC_CTRL51";
        desc = "MISC_CTRL51 is Audio Codec control register 1. MISC_CTRL51 (offset 0x00CC, total reset 0x00F3_5A4A; PROVEN: Hi3535 data sheet, PDF page 458, section 3.4.5.2).";
        field {
            name = "dacl_rst_n";
            desc = "DACL reset signal.
- 0: Reset active.
- 1: Reset inactive.";
            sw = rw; hw = r;
            reset = 0x0;
        } dacl_rst_n[31:31];
        field {
            name = "dacr_rst_n";
            desc = "DACR reset signal.
- 0: Reset asserted.
- 1: Reset deasserted.";
            sw = rw; hw = r;
            reset = 0x0;
        } dacr_rst_n[30:30];
        field {
            name = "adcl_rst_n";
            desc = "ADCL reset signal.
- 0: Reset asserted.
- 1: Reset deasserted.";
            sw = rw; hw = r;
            reset = 0x0;
        } adcl_rst_n[29:29];
        field {
            name = "adcr_rst_n";
            desc = "ADCR reset signal.
- 0: Reset asserted;
- 1: Reset deasserted.";
            sw = rw; hw = r;
            reset = 0x0;
        } adcr_rst_n[28:28];
        field {
            name = "dacl_en";
            desc = "DACL enable signal.
- 0: Disable;
- 1: Enable.";
            sw = rw; hw = r;
            reset = 0x0;
        } dacl_en[27:27];
        field {
            name = "dacr_en";
            desc = "DACR enable signal.
- 0: Disable.
- 1: Enable.";
            sw = rw; hw = r;
            reset = 0x0;
        } dacr_en[26:26];
        field {
            name = "adcl_en";
            desc = "ADCL enable signal.
- 0: Disable;
- 1: Enable.";
            sw = rw; hw = r;
            reset = 0x0;
        } adcl_en[25:25];
        field {
            name = "adcr_en";
            desc = "ADCR enable signal.
- 0: Disable.
- 1: Enable.";
            sw = rw; hw = r;
            reset = 0x0;
        } adcr_en[24:24];
        field {
            name = "i2s1_data_bits";
            desc = "I2S channel 1 data interface width.
- 00: 16bit.
- 01: 18bit.
- 10: 20bit.
- 11: 24bit.";
            sw = rw; hw = r;
            reset = 0x3;
        } i2s1_data_bits[23:22];
        field {
            name = "i2s2_data_bits";
            desc = "I2S channel 2 data interface width.
- 00: 16bit;
- 01: 18bit;
- 10: 20bit;
- 11: 24bit.";
            sw = rw; hw = r;
            reset = 0x3;
        } i2s2_data_bits[21:20];
        field {
            name = "dig_bypass";
            desc = "Digital part bypass control, used for analog test mode.
- 0: The digital part works normally;
- 1: The digital part is bypassed.";
            sw = rw; hw = r;
            reset = 0x0;
        } dig_bypass[19:19];
        field {
            name = "dig_loop";
            desc = "Digital loopback control signal.
- 0: Digital loopback disabled.
- 1: Digital loopback enabled.";
            sw = rw; hw = r;
            reset = 0x0;
        } dig_loop[18:18];
        field {
            name = "i2s1_fs_sel";
            desc = "I2S channel 1 sample rate select.
- 00000: 8kHz, 16.896MHz mclk.
- 00001: 16kHz, 16.896MHz mclk.
- 00010: 32kHz, 16.896MHz mclk.
- 00011: 64kHz, 16.896MHz mclk. 001xx: 128kHz, 16.896MHz mclk.
- 01000: 11kHz, 16.896MHz mclk.
- 01001: 22kHz, 16.896MHz mclk.
- 01010: 44kHz, 16.896MHz mclk.
- 01011: 88kHz, 16.896MHz mclk. 011xx: 176kHz, 16.896MHz mclk.
- 10000: 12kHz, 16.896MHz mclk.
- 10001: 24kHz, 16.896MHz mclk.
- 10010: 48kHz, 16.896MHz mclk.
- 10011: 96kHz, 16.896MHz mclk. 101xx: 192kHz, 16.896MHz mclk.
- 11000: mclk/512/2.
- 11001: mclk/256/2.
- 11010: mclk/128/2.
- 11011: mclk/64/2. 111xx: mclk/32/2.";
            sw = rw; hw = r;
            reset = 0x1a;
        } i2s1_fs_sel[17:13];
        field {
            name = "i2s2_fs_sel";
            desc = "I2S channel 2 sampling rate select.
- 00000: 8kHz,16.896MHz mclk.
- 00001: 16kHz,16.896MHz mclk.
- 00010: 32kHz,16.896MHz mclk.
- 00011: 64kHz,16.896MHz mclk. 001xx: 128kHz,16.896MHz mclk.
- 01000: 11kHz,16.896MHz mclk.
- 01001: 22kHz,16.896MHz mclk.
- 01010: 44kHz,16.896MHz mclk.
- 01011: 88kHz,16.896MHz mclk. 011xx: 176kHz,16.896MHz mclk.
- 10000: 12kHz,16.896MHz mclk.
- 10001: 24kHz,16.896MHz mclk.
- 10010: 48kHz,16.896MHz mclk.
- 10011: 96kHz,16.896MHz mclk. 101xx: 192kHz,16.896MHz mclk.
- 11000: mclk/512/2.
- 11001: mclk/256/2.
- 11010: mclk/128/2.
- 11011: mclk/64/2. 111xx: mclk/32/2.";
            sw = rw; hw = r;
            reset = 0x1a;
        } i2s2_fs_sel[12:8];
        field {
            name = "ibadj_adc";
            desc = "ADC bias current control.
- 00: 3uA;
- 01: 5uA (recommended);
- 10: 7uA;
- 11: 9uA.";
            sw = rw; hw = r;
            reset = 0x1;
        } ibadj_adc[7:6];
        field {
            name = "ibadj_dac";
            desc = "DAC bias current control.
- 0: 5uA;
- 1: 9uA.";
            sw = rw; hw = r;
            reset = 0x0;
        } ibadj_dac[5:5];
        field {
            name = "ibadj_ctcm";
            desc = "CTCM, MICBIAS, LINEIN bias current control.
- 0: 5uA (recommended);
- 1: 9uA.";
            sw = rw; hw = r;
            reset = 0x0;
        } ibadj_ctcm[4:4];
        field {
            name = "adc_adatn";
            desc = "ADC_DAC VB control.
- 00: R=90%;
- 01: R=95%;
- 10: R=100%;
- 11: R=110%.";
            sw = rw; hw = r;
            reset = 0x2;
        } adc_adatn[3:2];
        field {
            name = "adc_flstn";
            desc = "FLASH VREF control signal.
- 0: 2.31V~0.99V, LSB=182mV.
- 1: 2.2V~1.1V, LSB=161mV.";
            sw = rw; hw = r;
            reset = 0x1;
        } adc_flstn[1:1];
        field {
            name = "rst";
            desc = "Analog circuit reset signal.
- 0: Normal operation.
- 1: Reset.";
            sw = rw; hw = r;
            reset = 0x0;
        } rst[0:0];
    } MISC_CTRL51 @ 0xcc;
    reg {
        name = "MISC_CTRL52";
        desc = "MISC_CTRL52 is Audio Codec control register 2. MISC_CTRL52 (offset 0x00D0, total reset 0x0000_0001; PROVEN: Hi3535 data sheet, PDF page 462, section 3.4.5.2).";
        field {
            name = "smutel";
            desc = "DACL soft-mute control.
- 0: Disable soft-mute;
- 1: Enable soft-mute.";
            sw = rw; hw = r;
            reset = 0x0;
        } smutel[31:31];
        field {
            name = "smuter";
            desc = "DACR soft-mute control bit.
- 0: Disable soft-mute;
- 1: Enable soft-mute.";
            sw = rw; hw = r;
            reset = 0x0;
        } smuter[30:30];
        field {
            name = "sunmutel";
            desc = "DACL soft-unmute control bit.
- 0: Disable soft-unmute;
- 1: Enable soft-unmute.";
            sw = rw; hw = r;
            reset = 0x0;
        } sunmutel[29:29];
        field {
            name = "sunmuter";
            desc = "DACR soft-unmute control.
- 0: Disable soft-unmute;
- 1: Enable soft-unmute.";
            sw = rw; hw = r;
            reset = 0x0;
        } sunmuter[28:28];
        field {
            name = "dacvu";
            desc = "DAC volume update control bit.
- 0: Do not update the volume;
- 1: Update the volume.";
            sw = rw; hw = r;
            reset = 0x0;
        } dacvu[27:27];
        field {
            name = "mutel_rate";
            desc = "DACL soft-mute rate control bits.
- 00: fs/2;
- 01: fs/8;
- 10: fs/32;
- 11: fs/64.";
            sw = rw; hw = r;
            reset = 0x0;
        } mutel_rate[26:25];
        field {
            name = "muter_rate";
            desc = "DACR soft-mute rate control bits.
- 00: fs/2;
- 01: fs/8;
- 10: fs/32;
- 11: fs/64.";
            sw = rw; hw = r;
            reset = 0x0;
        } muter_rate[24:23];
        field {
            name = "dacl_deemph";
            desc = "DACL de-emphasis control signal.
- 00: none;
- 01: 32kHz;
- 10: 44kHz;
- 11: 48kHz.";
            sw = rw; hw = r;
            reset = 0x0;
        } dacl_deemph[22:21];
        field {
            name = "dacr_deemph";
            desc = "DACR de-emphasis control signal.
- 00: none;
- 01: 32kHz;
- 10: 44kHz;
- 11: 48kHz.";
            sw = rw; hw = r;
            reset = 0x0;
        } dacr_deemph[20:19];
        field {
            name = "reserved";
            desc = "Reserved.";
            sw = rw; hw = r;
            reset = 0x0;
        } reserved_18_4[18:4];
        field {
            name = "dal_i2ssel";
            desc = "DACL I2S interface select.
- 0: Select I2S1;
- 1: Select I2S2.";
            sw = rw; hw = r;
            reset = 0x0;
        } dal_i2ssel[3:3];
        field {
            name = "dacl_lrsel";
            desc = "DACL left/right channel data select.
- 0: Select the left channel;
- 1: Select the right channel.";
            sw = rw; hw = r;
            reset = 0x0;
        } dacl_lrsel[2:2];
        field {
            name = "dacr_i2ssel";
            desc = "DACR I2S interface select.
- 0: Select I2S1.
- 1: Select I2S2.";
            sw = rw; hw = r;
            reset = 0x0;
        } dacr_i2ssel[1:1];
        field {
            name = "dacr_lrsel";
            desc = "DACR left/right channel data select.
- 0: Select the left channel.
- 1: Select the right channel.";
            sw = rw; hw = r;
            reset = 0x1;
        } dacr_lrsel[0:0];
    } MISC_CTRL52 @ 0xd0;
    reg {
        name = "MISC_CTRL53";
        desc = "MISC_CTRL53 is Audio Codec control register 3. MISC_CTRL53 (offset 0x00D4, total reset 0x0606_2424; PROVEN: Hi3535 data sheet, PDF page 464, section 3.4.5.2).";
        field {
            name = "dacl_mute";
            desc = "DACL digital mute control.
- 0: Normal operation;
- 1: Mute.";
            sw = rw; hw = r;
            reset = 0x0;
        } dacl_mute[31:31];
        field {
            name = "dacl_vol";
            desc = "DACL digital volume control. Formula: (6-dacl_vol x 1) dB. When dacl_vol is 0x7F, DACL is digitally muted.";
            sw = rw; hw = r;
            reset = 0x6;
        } dacl_vol[30:24];
        field {
            name = "dacr_mute";
            desc = "DACR digital mute control.
- 0: Normal operation;
- 1: Mute.";
            sw = rw; hw = r;
            reset = 0x0;
        } dacr_mute[23:23];
        field {
            name = "dacr_vol";
            desc = "DACR digital volume control. Formula: (6-dacr_vol x 1)db. When dacr_vol is 0x7F, DACR is digitally muted.";
            sw = rw; hw = r;
            reset = 0x6;
        } dacr_vol[22:16];
        field {
            name = "dacr2dacl_en";
            desc = "DACR2DACL mixer control signal.
- 0: Off;
- 1: On.";
            sw = rw; hw = r;
            reset = 0x0;
        } dacr2dacl_en[15:15];
        field {
            name = "dacr2dacl_vol";
            desc = "DACR to DACL volume control bits. Formula: (36-dacr2dacl_vol x 1)db.";
            sw = rw; hw = r;
            reset = 0x24;
        } dacr2dacl_vol[14:8];
        field {
            name = "dacl2dacr_en";
            desc = "DACL to DACR mixer control signal.
- 0: Off;
- 1: On.";
            sw = rw; hw = r;
            reset = 0x0;
        } dacl2dacr_en[7:7];
        field {
            name = "dacl2dacr_vol";
            desc = "DACL to DACR volume control bits. Formula: (36-dacl2dacr_vol x 1) dB.";
            sw = rw; hw = r;
            reset = 0x24;
        } dacl2dacr_vol[6:0];
    } MISC_CTRL53 @ 0xd4;
    reg {
        name = "MISC_CTRL54";
        desc = "MISC_CTRL54 is Audio Codec control register 4. MISC_CTRL54 (offset 0x00D8, total reset 0x1E1E_0001; PROVEN: Hi3535 data sheet, PDF page 465, section 3.4.5.2).";
        field {
            name = "adcl_mute";
            desc = "ADCL digital mute control bit.
- 0: ADCL unmute;
- 1: ADCL mute.";
            sw = rw; hw = r;
            reset = 0x0;
        } adcl_mute[31:31];
        field {
            name = "adcl_vol";
            desc = "ADCL volume control. Formula: (30-adcl_vol x 1) dB.";
            sw = rw; hw = r;
            reset = 0x1e;
        } adcl_vol[30:24];
        field {
            name = "adcr_mute";
            desc = "ADCR digital mute control bit.
- 0: ADCR not muted;
- 1: ADCR muted.";
            sw = rw; hw = r;
            reset = 0x0;
        } adcr_mute[23:23];
        field {
            name = "adcr_vol";
            desc = "ADCR volume control bits. Formula: (30-adcr_vol x 1) dB.";
            sw = rw; hw = r;
            reset = 0x1e;
        } adcr_vol[22:16];
        field {
            name = "adcl_hpf_en";
            desc = "ADCL high-pass filter enable control.
- 0: Disable the high-pass filter;
- 1: Enable the high-pass filter.";
            sw = rw; hw = r;
            reset = 0x0;
        } adcl_hpf_en[15:15];
        field {
            name = "adcr_hpf_en";
            desc = "ADCR high-pass filter enable control.
- 0: Disable the high-pass filter;
- 1: Enable the high-pass filter.";
            sw = rw; hw = r;
            reset = 0x0;
        } adcr_hpf_en[14:14];
        field {
            name = "reserved";
            desc = "Reserved.";
            sw = rw; hw = r;
            reset = 0x0;
        } reserved_13_4[13:4];
        field {
            name = "adcl_i2ssel";
            desc = "ADCL I2S interface select (high priority).
- 0: Select I2S1.
- 1: Select I2S2.";
            sw = rw; hw = r;
            reset = 0x0;
        } adcl_i2ssel[3:3];
        field {
            name = "adcl_lrsel";
            desc = "ADCL left/right channel data selection:
- 0: Select the left channel;
- 1: Select the right channel.";
            sw = rw; hw = r;
            reset = 0x0;
        } adcl_lrsel[2:2];
        field {
            name = "adcr_i2ssel";
            desc = "ADCR I2S interface select (low priority).
- 0: Select I2S1.
- 1: Select I2S2.";
            sw = rw; hw = r;
            reset = 0x0;
        } adcr_i2ssel[1:1];
        field {
            name = "adcr_lrsel";
            desc = "ADCR left/right channel data select.
- 0: Select the left channel.
- 1: Select the right channel.";
            sw = rw; hw = r;
            reset = 0x1;
        } adcr_lrsel[0:0];
    } MISC_CTRL54 @ 0xd8;
    reg {
        name = "MISC_CTRL55";
        desc = "MISC_CTRL55 is Audio Codec control register 5. MISC_CTRL55 (offset 0x00DC, total reset 0x2424_2424; PROVEN: Hi3535 data sheet, PDF page 466, section 3.4.5.2).";
        field {
            name = "adcl2dacl_en";
            desc = "ADCL to DACL mixer control signal.
- 0: Off;
- 1: On.";
            sw = rw; hw = r;
            reset = 0x0;
        } adcl2dacl_en[31:31];
        field {
            name = "adcl2dacl_vol";
            desc = "ADCL to DACL volume control bits. Calculated as (36-adcl2dacl_vol x 1) dB.";
            sw = rw; hw = r;
            reset = 0x24;
        } adcl2dacl_vol[30:24];
        field {
            name = "adcr2dacl_en";
            desc = "ADCR to DACL mixer control signal.
- 0: Off;
- 1: On.";
            sw = rw; hw = r;
            reset = 0x0;
        } adcr2dacl_en[23:23];
        field {
            name = "adcr2dacl_vol";
            desc = "ADCR to DACL volume control bits. Formula: (36-adcr2dacl_vol x 1)db.";
            sw = rw; hw = r;
            reset = 0x24;
        } adcr2dacl_vol[22:16];
        field {
            name = "adcl2dacr_en";
            desc = "ADCL to DACR mixer control signal.
- 0: Off.
- 1: On.";
            sw = rw; hw = r;
            reset = 0x0;
        } adcl2dacr_en[15:15];
        field {
            name = "adcl2dacr_vol";
            desc = "ADCL to DACR volume control bits. Formula: (36-adcl2dacr_vol x 1) dB.";
            sw = rw; hw = r;
            reset = 0x24;
        } adcl2dacr_vol[14:8];
        field {
            name = "adcr2dacr_en";
            desc = "ADCR to DACR mixer control signal.
- 0: Off.
- 1: On.";
            sw = rw; hw = r;
            reset = 0x0;
        } adcr2dacr_en[7:7];
        field {
            name = "adcr2dacr_vol";
            desc = "ADCR to DACR volume control. Formula: (36-adcr2dacr_vol x 1) dB.";
            sw = rw; hw = r;
            reset = 0x24;
        } adcr2dacr_vol[6:0];
    } MISC_CTRL55 @ 0xdc;
    reg {
        name = "MISC_CTRL56";
        desc = "MISC_CTRL56 is the SATA PORT0 loopback control register. MISC_CTRL56 (offset 0x00E0, total reset 0x0000_0000; PROVEN: Hi3535 data sheet, PDF page 467, section 3.4.5.2).";
        field {
            name = "sata_lpbk_match_cfg0";
            desc = "SATA PORT0 LOOPBACK configuration.";
            sw = rw; hw = r;
            reset = 0x0;
        } sata_lpbk_match_cfg0[31:0];
    } MISC_CTRL56 @ 0xe0;
    reg {
        name = "MISC_CTRL57";
        desc = "MISC_CTRL57 is the SATA PORT1 loopback control register. MISC_CTRL57 (offset 0x00E4, total reset 0x0000_0000; PROVEN: Hi3535 data sheet, PDF page 468, section 3.4.5.2).";
        field {
            name = "sata_lpbk_match_cfg1";
            desc = "SATA PORT1 LOOPBACK configuration.";
            sw = rw; hw = r;
            reset = 0x0;
        } sata_lpbk_match_cfg1[31:0];
    } MISC_CTRL57 @ 0xe4;
    reg {
        name = "MISC_CTRL58";
        desc = "MISC_CTRL58 is the SATA PORT2 loopback control register. MISC_CTRL58 (offset 0x00E8, total reset 0x0000_0000; PROVEN: Hi3535 data sheet, PDF page 468, section 3.4.5.2).";
        field {
            name = "sata_lpbk_match_cfg2";
            desc = "SATA PORT2 LOOPBACK configuration.";
            sw = rw; hw = r;
            reset = 0x0;
        } sata_lpbk_match_cfg2[31:0];
    } MISC_CTRL58 @ 0xe8;
    reg {
        name = "MISC_CTRL59";
        desc = "MISC_CTRL59 is the SATA loopback enable register. MISC_CTRL59 (offset 0x00EC, total reset 0x0000_0000; PROVEN: Hi3535 data sheet, PDF page 469, section 3.4.5.2).";
        field {
            name = "reserved";
            desc = "Reserved.";
            sw = rw; hw = r;
            reset = 0x0;
        } reserved_31_7[31:7];
        field {
            name = "sata_lobk_mode_sel2";
            desc = "SATA PORT2 loopback mode select.";
            sw = rw; hw = r;
            reset = 0x0;
        } sata_lobk_mode_sel2[6:6];
        field {
            name = "sata_lobk_mode_sel1";
            desc = "SATA PORT1 loopback mode selection.";
            sw = rw; hw = r;
            reset = 0x0;
        } sata_lobk_mode_sel1[5:5];
        field {
            name = "sata_lobk_mode_sel0";
            desc = "SATA PORT0 loopback mode select.";
            sw = rw; hw = r;
            reset = 0x0;
        } sata_lobk_mode_sel0[4:4];
        field {
            name = "reserved";
            desc = "Reserved.";
            sw = rw; hw = r;
            reset = 0x0;
        } reserved_3_3[3:3];
        field {
            name = "sata_lpbk_ctrl_en2";
            desc = "SATA PORT2 loopback enable.
- 0: Disable.
- 1: Enable.";
            sw = rw; hw = r;
            reset = 0x0;
        } sata_lpbk_ctrl_en2[2:2];
        field {
            name = "sata_lpbk_ctrl_en1";
            desc = "SATA PORT1 loopback enable.
- 0: Disable;
- 1: Enable.";
            sw = rw; hw = r;
            reset = 0x0;
        } sata_lpbk_ctrl_en1[1:1];
        field {
            name = "sata_lpbk_ctrl_en0";
            desc = "SATA PORT0 loopback enable.
- 0: Disable.
- 1: Enable.";
            sw = rw; hw = r;
            reset = 0x0;
        } sata_lpbk_ctrl_en0[0:0];
    } MISC_CTRL59 @ 0xec;
    reg {
        name = "MISC_CTRL60";
        desc = "MISC_CTRL60 is PCIE control register 0. MISC_CTRL60 (offset 0x00F0, total reset 0x0000_0000; PROVEN: Hi3535 data sheet, PDF page 470, section 3.4.5.2).";
        field {
            name = "pcie_device_type";
            desc = "PCIe controller mode.
- 0x0: PCI Express EP device;
- 0x1: Legacy PCI Express device;
- 0x4: PCI Express RC device;
Other values: reserved.";
            sw = rw; hw = r;
            reset = 0x0;
        } pcie_device_type[31:28];
        field {
            name = "pcie_slv_resp_err_map5";
            desc = "CPL TIMEOUT error mapping control of the PCIe bus SLV port.
- 0: Map the CPL TIMEOUT error to DEC_ERR;
- 1: Map the CPL TIMEOUT error to SLV_ERR.";
            sw = rw; hw = r;
            reset = 0x0;
        } pcie_slv_resp_err_map5[27:27];
        field {
            name = "pcie_slv_resp_err_map4";
            desc = "PCIe bus SLV port CPL ECRC error mapping control.
- 0: Map the CPL ECRC error to DEC_ERR;
- 1: Map the CPL ECRC error to SLV_ERR.";
            sw = rw; hw = r;
            reset = 0x0;
        } pcie_slv_resp_err_map4[26:26];
        field {
            name = "pcie_slv_resp_err_map3";
            desc = "PCIe bus SLV port CPL poisoned error mapping control.
- 0: Map the CPL poisoned error to DEC_ERR;
- 1: Map the CPL poisoned error to SLV_ERR.";
            sw = rw; hw = r;
            reset = 0x0;
        } pcie_slv_resp_err_map3[25:25];
        field {
            name = "pcie_slv_resp_err_map2";
            desc = "CPL CA error mapping control of the PCIe bus SLV port.
- 0: Map the CPL CA error to DEC_ERR.
- 1: Map the CPL CA error to SLV_ERR.";
            sw = rw; hw = r;
            reset = 0x0;
        } pcie_slv_resp_err_map2[24:24];
        field {
            name = "pcie_slv_resp_err_map1";
            desc = "CPL CRS error mapping control for the PCIe bus SLV port.
- 0: Map the CPL CRS error to DEC_ERR;
- 1: Map the CPL CRS error to SLV_ERR.";
            sw = rw; hw = r;
            reset = 0x0;
        } pcie_slv_resp_err_map1[23:23];
        field {
            name = "pcie_slv_resp_err_map0";
            desc = "PCIe bus SLV port CPL UR error mapping control.
- 0: Map the CPL UR error to DEC_ERR.
- 1: Map the CPL UR error to SLV_ERR.";
            sw = rw; hw = r;
            reset = 0x0;
        } pcie_slv_resp_err_map0[22:22];
        field {
            name = "reserved";
            desc = "Reserved.";
            sw = r; hw = w;
            reset = 0x0;
        } reserved_21_0[21:0];
    } MISC_CTRL60 @ 0xf0;
    reg {
        name = "MISC_CTRL61";
        desc = "MISC_CTRL61 is PCIE control register 1. MISC_CTRL61 (offset 0x00F4, total reset 0x0000_0000; PROVEN: Hi3535 data sheet, PDF page 471, section 3.4.5.2).";
        field {
            name = "reserved";
            desc = "Reserved.";
            sw = r; hw = w;
            reset = 0x0;
        } reserved_31_24[31:24];
        field {
            name = "pcie_app_clk_req_n";
            desc = "PCIe controller application layer clock request.
- 0: Request the clock;
- 1: Do not request the clock.";
            sw = rw; hw = r;
            reset = 0x0;
        } pcie_app_clk_req_n[23:23];
        field {
            name = "reserved";
            desc = "Reserved.";
            sw = r; hw = w;
            reset = 0x0;
        } reserved_22_0[22:0];
    } MISC_CTRL61 @ 0xf4;
    reg {
        name = "MISC_CTRL62";
        desc = "MISC_CTRL62 is PCIE control register 2. MISC_CTRL62 (offset 0x00F8, total reset 0x0000_0000; PROVEN: Hi3535 data sheet, PDF page 472, section 3.4.5.2).";
        field {
            name = "pcie_ven_msi_vector";
            desc = "PCIe controller MSI data adjustment control register. When the PCIe controller initiates an MSI interrupt request, the value of this register is the lowest 5 bits of the MSI data (the bitwise OR of this register and the MSI data register is the new MSI data).";
            sw = rw; hw = r;
            reset = 0x0;
        } pcie_ven_msi_vector[31:27];
        field {
            name = "pcie_ven_msi_req";
            desc = "Indicates whether the PCIe controller requests to send a message interrupt (MSI).
- 0: No request.
- 1: Request.";
            sw = rw; hw = r;
            reset = 0x0;
        } pcie_ven_msi_req[26:26];
        field {
            name = "reserved";
            desc = "Reserved.";
            sw = r; hw = w;
            reset = 0x0;
        } reserved_25_0[25:0];
    } MISC_CTRL62 @ 0xf8;
    reg {
        name = "MISC_CTRL63";
        desc = "MISC_CTRL63 is PCIE control register 3. MISC_CTRL63 (offset 0x00FC, total reset 0x0000_0000; PROVEN: Hi3535 data sheet, PDF page 472, section 3.4.5.2).";
        field {
            name = "pcie_ven_msg_code";
            desc = "When sending a vendor-defined message, this register specifies the vendor-defined message";
            sw = rw; hw = r;
            reset = 0x0;
        } pcie_ven_msg_code[31:24];
        field {
            name = "pcie_ven_msg_tag";
            desc = "When the PCIe controller initiates a PCIe vendor-defined message request, this register configures the TAG field of the request packet.";
            sw = rw; hw = r;
            reset = 0x0;
        } pcie_ven_msg_tag[23:16];
        field {
            name = "reserved";
            desc = "Reserved.";
            sw = r; hw = w;
            reset = 0x0;
        } reserved_15_12[15:12];
        field {
            name = "pcie_ven_msg_attr";
            desc = "When the PCIe controller initiates a PCIe vendor-defined message request, this register configures the ATTR field of the request packet.";
            sw = rw; hw = r;
            reset = 0x0;
        } pcie_ven_msg_attr[11:10];
        field {
            name = "pcie_ven_msg_ep";
            desc = "When the PCIe controller initiates a PCIe vendor-defined message request, this register configures the EP field of the request packet.";
            sw = rw; hw = r;
            reset = 0x0;
        } pcie_ven_msg_ep[9:9];
        field {
            name = "pcie_ven_msg_td";
            desc = "When the PCIe controller initiates a PCIe vendor-defined message request, this register configures the TD field of the request packet.";
            sw = rw; hw = r;
            reset = 0x0;
        } pcie_ven_msg_td[8:8];
        field {
            name = "pcie_ven_msg_type";
            desc = "When the PCIe controller initiates a PCIe vendor-defined message request, this register configures the TYPE field of the request packet.";
            sw = rw; hw = r;
            reset = 0x0;
        } pcie_ven_msg_type[7:3];
        field {
            name = "pcie_ven_msg_fmt";
            desc = "When the PCIe controller initiates a PCIe vendor-defined message request, this register configures the FMT field of the request packet.";
            sw = rw; hw = r;
            reset = 0x0;
        } pcie_ven_msg_fmt[2:1];
        field {
            name = "pcie_ven_msg_req";
            desc = "Indicates whether the PCIe controller requests to send a vendor-defined message.
- 0: No request;
- 1: Request.";
            sw = rw; hw = r;
            reset = 0x0;
        } pcie_ven_msg_req[0:0];
    } MISC_CTRL63 @ 0xfc;
    reg {
        name = "MISC_CTRL64";
        desc = "MISC_CTRL64 is PCIE control register 4. MISC_CTRL64 (offset 0x0100, total reset 0x0000_0000; PROVEN: Hi3535 data sheet, PDF page 473, section 3.4.5.2).";
        field {
            name = "pcie_ven_msg_data_low";
            desc = "For vendor-defined message transactions, this register is the third doubleword of the vendor-defined message transaction packet";
            sw = rw; hw = r;
            reset = 0x0;
        } pcie_ven_msg_data_low[31:0];
    } MISC_CTRL64 @ 0x100;
    reg {
        name = "MISC_CTRL65";
        desc = "MISC_CTRL65 is PCIE control register 5. MISC_CTRL65 (offset 0x0104, total reset 0x0000_0000; PROVEN: Hi3535 data sheet, PDF page 474, section 3.4.5.2).";
        field {
            name = "pcie_ven_msg_data_high";
            desc = "For a vendor-defined message transaction, this register holds the fourth double word of the vendor-defined message transaction packet.";
            sw = rw; hw = r;
            reset = 0x0;
        } pcie_ven_msg_data_high[31:0];
    } MISC_CTRL65 @ 0x104;
    reg {
        name = "MISC_CTRL67";
        desc = "MISC_CTRL67 is PCIE control register 7. MISC_CTRL67 (offset 0x010C, total reset 0x0000_0800; PROVEN: Hi3535 data sheet, PDF page 474, section 3.4.5.2).";
        field {
            name = "reserved";
            desc = "Reserved.";
            sw = rw; hw = r;
            reset = 0x0;
        } reserved_31_21[31:21];
        field {
            name = "pcie_cfg_l1_clk_removal_en";
            desc = "Reference clock control in the L1 state.
- 0: Removing the reference clock in the L1 state is not allowed.
- 1: Removing the reference clock in the L1 state is allowed.";
            sw = rw; hw = r;
            reset = 0x0;
        } pcie_cfg_l1_clk_removal_en[20:20];
        field {
            name = "reserved";
            desc = "Reserved.";
            sw = r; hw = w;
            reset = 0x0;
        } reserved_19_12[19:12];
        field {
            name = "pcie_app_ltssm_enable";
            desc = "PCIe controller enable.
- 0: Disable the PCIe controller;
- 1: Enable the PCIe controller.";
            sw = rw; hw = r;
            reset = 0x1;
        } pcie_app_ltssm_enable[11:11];
        field {
            name = "pcie_sys_aux_pwr_det";
            desc = "PCIe controller auxiliary power detection.
- 0: Auxiliary power not present;
- 1: Auxiliary power present.";
            sw = rw; hw = r;
            reset = 0x0;
        } pcie_sys_aux_pwr_det[10:10];
        field {
            name = "pcie_apps_pm_xmt_pme";
            desc = "PCIe controller low-power state wake-up.
- 0: No wake-up.
- 1: Wake up.";
            sw = rw; hw = r;
            reset = 0x0;
        } pcie_apps_pm_xmt_pme[9:9];
        field {
            name = "pcie_apps_pm_xmt_turnoff";
            desc = "PCIe controller PM_TRUN_OFF message request.
- 0: No request;
- 1: Request.";
            sw = rw; hw = r;
            reset = 0x0;
        } pcie_apps_pm_xmt_turnoff[8:8];
        field {
            name = "pcie_app_unlock_msg";
            desc = "PCIe controller Unlock message request.
- 0: No request;
- 1: Request.";
            sw = rw; hw = r;
            reset = 0x0;
        } pcie_app_unlock_msg[7:7];
        field {
            name = "pcie_outband_pwrup_cmd";
            desc = "PCIe controller low-power state wake-up.
- 0: No wake-up.
- 1: Wake up.";
            sw = rw; hw = r;
            reset = 0x0;
        } pcie_outband_pwrup_cmd[6:6];
        field {
            name = "pcie_sys_int";
            desc = "PCIe controller interrupt request. When this register changes from 0 to 1, the PCIe controller generates an Assert_INTx message; when it changes from 1 to 0, the PCIe controller generates a Deassert_INTx message.";
            sw = rw; hw = r;
            reset = 0x0;
        } pcie_sys_int[5:5];
        field {
            name = "pcie_app_req_retry_en";
            desc = "PCIe controller defers receiving configuration requests.
- 0: Invalid.
- 1: Valid.";
            sw = rw; hw = r;
            reset = 0x0;
        } pcie_app_req_retry_en[4:4];
        field {
            name = "pcie_app_req_exit_l1";
            desc = "PCIe controller application layer request to exit the L1 state.
- 0: No request.
- 1: Request.";
            sw = rw; hw = r;
            reset = 0x0;
        } pcie_app_req_exit_l1[3:3];
        field {
            name = "reserved";
            desc = "Reserved.";
            sw = r; hw = w;
            reset = 0x0;
        } reserved_2_2[2:2];
        field {
            name = "pcie_app_req_entr_l1";
            desc = "PCIe controller application layer request to enter the L1 state.
- 0: No request;
- 1: Request.";
            sw = rw; hw = r;
            reset = 0x0;
        } pcie_app_req_entr_l1[1:1];
        field {
            name = "pcie_app_init_rst";
            desc = "Changing this register from 0 to 1 causes the PCIe controller to send a HOT_RESET to the downstream device.";
            sw = rw; hw = r;
            reset = 0x0;
        } pcie_app_init_rst[0:0];
    } MISC_CTRL67 @ 0x10c;
    reg {
        name = "MISC_CTRL72";
        desc = "MISC_CTRL72 is PCIE control register 12. MISC_CTRL72 (offset 0x0120, total reset 0xA188_79F3; PROVEN: Hi3535 data sheet, PDF page 476, section 3.4.5.2).";
        field {
            name = "reserved";
            desc = "Reserved.";
            sw = r; hw = w;
            reset = 0x28621;
        } reserved_31_14[31:14];
        field {
            name = "pcie_cfg_pcs_tx_swing_full";
            desc = "Swing of the PCIe PHY transmitter (full swing mode).";
            sw = rw; hw = r;
            reset = 0x73;
        } pcie_cfg_pcs_tx_swing_full[13:7];
        field {
            name = "pcie_cfg_pcs_tx_swing_low";
            desc = "Swing of the PCIe PHY transmitter (low swing mode).";
            sw = rw; hw = r;
            reset = 0x73;
        } pcie_cfg_pcs_tx_swing_low[6:0];
    } MISC_CTRL72 @ 0x120;
    reg {
        name = "MISC_CTRL73";
        desc = "MISC_CTRL73 is PCIE control register 13. MISC_CTRL73 (offset 0x0124, total reset 0x0192_4014; PROVEN: Hi3535 data sheet, PDF page 477, section 3.4.5.2).";
        field {
            name = "pcie_pipe_tx2rx_lpbk";
            desc = "PCIe TX-to-RX loopback enable.
- 0: Disable.
- 1: Enable.";
            sw = rw; hw = r;
            reset = 0x0;
        } pcie_pipe_tx2rx_lpbk[31:31];
        field {
            name = "reserved";
            desc = "Reserved.";
            sw = r; hw = w;
            reset = 0x0;
        } reserved_30_30[30:30];
        field {
            name = "pcie_cfg_ref_use_pad";
            desc = "PCIe reference clock source selection.
- 0: From the on-chip ref_alt_clk_{p,m};
- 1: From the pin clock ref_pad_clk_{p,m}.";
            sw = rw; hw = r;
            reset = 0x0;
        } pcie_cfg_ref_use_pad[29:29];
        field {
            name = "reserved";
            desc = "Reserved.";
            sw = r; hw = w;
            reset = 0x0;
        } reserved_28_28[28:28];
        field {
            name = "pcie_cfg_ref_clkdiv2";
            desc = "PCIe PHY MPLL divider parameter setting. Must be set to 0x0.";
            sw = rw; hw = r;
            reset = 0x0;
        } pcie_cfg_ref_clkdiv2[27:27];
        field {
            name = "pcie_cfg_mpll_multiplier";
            desc = "PCIe PHY MPLL multiplier parameter setting. Must be set to 0x19.";
            sw = rw; hw = r;
            reset = 0x19;
        } pcie_cfg_mpll_multiplier[26:20];
        field {
            name = "reserved";
            desc = "Reserved.";
            sw = r; hw = w;
            reset = 0x0;
        } reserved_19_19[19:19];
        field {
            name = "pcie_cfg_los_level";
            desc = "Loss-of-signal sensitivity level. Must be set to 0x9.";
            sw = rw; hw = r;
            reset = 0x9;
        } pcie_cfg_los_level[18:14];
        field {
            name = "reserved";
            desc = "Reserved.";
            sw = r; hw = w;
            reset = 0x0;
        } reserved_13_6[13:6];
        field {
            name = "pcie_cfg_phy_los_bias";
            desc = "Loss-of-signal threshold level control. Must be set to 0x2.";
            sw = rw; hw = r;
            reset = 0x2;
        } pcie_cfg_phy_los_bias[5:3];
        field {
            name = "pcie_cfg_phy_tx_vboost_lvl";
            desc = "PCIe transmit level setting. Must be set to 0x4.";
            sw = rw; hw = r;
            reset = 0x4;
        } pcie_cfg_phy_tx_vboost_lvl[2:0];
    } MISC_CTRL73 @ 0x124;
    reg {
        name = "MISC_CTRL74";
        desc = "MISC_CTRL74 is PCIE control register 14. MISC_CTRL74 (offset 0x0128, total reset 0x0008_0000; PROVEN: Hi3535 data sheet, PDF page 478, section 3.4.5.2).";
        field {
            name = "reserved";
            desc = "Reserved.";
            sw = r; hw = w;
            reset = 0x0;
        } reserved_31_20[31:20];
        field {
            name = "pcie_pipe_port_sel";
            desc = "PCIe PIPE interface enable.
- 0: Disable.
- 1: Enable.";
            sw = rw; hw = r;
            reset = 0x1;
        } pcie_pipe_port_sel[19:19];
        field {
            name = "pcie_pcs_tx_common_mode_dis";
            desc = "Disable transmitter common mode.
- 0: Do not disable;
- 1: Disable.";
            sw = rw; hw = r;
            reset = 0x0;
        } pcie_pcs_tx_common_mode_dis[18:18];
        field {
            name = "pcie_pcs_rx_elecidle_dis";
            desc = "Disable receiver idle detection.
- 0: Do not disable;
- 1: Disable.";
            sw = rw; hw = r;
            reset = 0x0;
        } pcie_pcs_rx_elecidle_dis[17:17];
        field {
            name = "reserved";
            desc = "Reserved.";
            sw = r; hw = w;
            reset = 0x0;
        } reserved_16_7[16:7];
        field {
            name = "pcie_cfg_phy_test_powerdown";
            desc = "PCIe PHY power-down, used for IDDQ testing.
- 0: No power-down.
- 1: Power-down.";
            sw = rw; hw = r;
            reset = 0x0;
        } pcie_cfg_phy_test_powerdown[6:6];
        field {
            name = "reserved";
            desc = "Reserved.";
            sw = r; hw = w;
            reset = 0x0;
        } reserved_5_0[5:0];
    } MISC_CTRL74 @ 0x128;
    reg {
        name = "MISC_CTRL75";
        desc = "MISC_CTRL75 is PCIE status register 0. MISC_CTRL75 (offset 0x012C, total reset 0x0000_0000; PROVEN: Hi3535 data sheet, PDF page 479, section 3.4.5.2).";
        field {
            name = "reserved";
            desc = "Reserved.";
            sw = r; hw = w;
            reset = 0x0;
        } reserved_31_16[31:16];
        field {
            name = "pcie_xmlh_link_up";
            desc = "PCIe PHY link connection status indication.
- 0: Link disconnected;
- 1: Link established.";
            sw = r; hw = w;
            reset = 0x0;
        } pcie_xmlh_link_up[15:15];
        field {
            name = "reserved";
            desc = "Reserved.";
            sw = r; hw = w;
            reset = 0x0;
        } reserved_14_6[14:6];
        field {
            name = "pcie_rdlh_link_up";
            desc = "PCIe controller data link layer connection status indication.
- 0: Link is down;
- 1: Link is established.";
            sw = r; hw = w;
            reset = 0x0;
        } pcie_rdlh_link_up[5:5];
        field {
            name = "reserved";
            desc = "Reserved.";
            sw = r; hw = w;
            reset = 0x0;
        } reserved_4_0[4:0];
    } MISC_CTRL75 @ 0x12c;
};

`endif
