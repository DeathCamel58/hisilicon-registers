`ifndef EHI3535_DDRC_PHY_RDL
`define EHI3535_DDRC_PHY_RDL
regfile eHI3535_DDRC_PHY {
    name = "DDRC DDRPHY module";
    desc = "DDRC DDRPHY module. 64 registers extracted programmatically from the Hi3535 H.264 codec processor (Hi3535 user guide) data sheet (Issue 00B08, 2014-02-25); chapter 4.1.8, tables 4-6/4-7. Field names, bit ranges, access types and reset values are taken from the register tables; reset values are the data sheet total reset values split onto the fields (per-field values where the table has them). Label: PROVEN. Hardware not verified here (no board).";
    reg {
        name = "PACK_PHYINITCTRL";
        desc = "PACK_PHYINITCTRL is the PHY initialization control register. Writing this register has no effect when init_en is 1. PACK_PHYINITCTRL (offset 0x004, total reset 0x0000_000E; PROVEN: Hi3535 data sheet, PDF page 669, section 4.1.8.2).";
        field {
            name = "reserved";
            desc = "Reserved.";
            sw = r; hw = w;
            reset = 0x0;
        } reserved_31_16[31:16];
        field {
            name = "phyconn_rst";
            desc = "PHY counter reset. This field sets the PHY register reset signal. Set this field to 1 to send the reset signal to the PHY counters; clear it to deassert the reset signal. Note: the reset signal is connected to the A/C block counters and all data block counters.";
            sw = rw; hw = r;
            reset = 0x0;
        } phyconn_rst[15:15];
        field {
            name = "pack_rst";
            desc = "PACK reset. This field resets all digital circuits of the PACK (including the register file). When this field is set, all digital parts of the PHY, including the control registers, return to their default values. The reset is performed automatically, and this field is cleared when the reset ends.";
            sw = rw; hw = r;
            reset = 0x0;
        } pack_rst[14:14];
        field {
            name = "phy_rst";
            desc = "PHY reset. This field sets the PHY reset signal. To send the reset signal to the PHY, set this field to 1; to deassert the reset signal to the PHY, clear this field. Note: The reset signal is connected to the A/C block and all data blocks.";
            sw = rw; hw = r;
            reset = 0x0;
        } phy_rst[13:13];
        field {
            name = "dram_rst";
            desc = "DRAM reset. This field initiates the DRAM reset sequence. When this field is set, the RESET# and CKE signals are driven low for a period (t_dram_rst). After t_dram_rst, RESET# is driven high while CKE stays low for a period, after which CKE is driven high; after t_cke_high, this field is cleared automatically.";
            sw = rw; hw = r;
            reset = 0x0;
        } dram_rst[12:12];
        field {
            name = "reserved";
            desc = "Reserved.";
            sw = r; hw = w;
            reset = 0x0;
        } reserved_11_11[11:11];
        field {
            name = "dram_init_en";
            desc = "DRAM initialization enable. This field controls whether the internal DRAM initialization sequence is used after PHY initialization completes.";
            sw = rw; hw = r;
            reset = 0x0;
        } dram_init_en[10:10];
        field {
            name = "wdet_en";
            desc = "Write data eye training enable. Writing 1 to this field starts the write data eye training sequence. The field is cleared after the write data eye training completes.";
            sw = rw; hw = r;
            reset = 0x0;
        } wdet_en[9:9];
        field {
            name = "rdet_en";
            desc = "Read data eye training enable. Writing 1 to this field starts the read data eye training sequence. After read data eye training completes, this field is cleared.";
            sw = rw; hw = r;
            reset = 0x0;
        } rdet_en[8:8];
        field {
            name = "wl2_en";
            desc = "Second write leveling enable. Writing 1 to this field adjusts the write delay. The field clears itself after the adjustment completes. Note: write leveling adjustment applies to DDR3 only.";
            sw = rw; hw = r;
            reset = 0x0;
        } wl2_en[7:7];
        field {
            name = "gdst_en";
            desc = "PHY read data latch training enable. Writing 1 to this field starts read data latch position training. After the write leveling completes, this field is cleared.";
            sw = rw; hw = r;
            reset = 0x0;
        } gdst_en[6:6];
        field {
            name = "gt_en";
            desc = "Gating training enable. Writing 1 to this field starts the gating training sequence. This field is cleared after gating training completes.";
            sw = rw; hw = r;
            reset = 0x0;
        } gt_en[5:5];
        field {
            name = "wl_en";
            desc = "Write leveling enable. Writing 1 to this field starts the write leveling sequence. The field clears itself after write leveling completes. Note: write leveling applies to DDR3 only.";
            sw = rw; hw = r;
            reset = 0x0;
        } wl_en[4:4];
        field {
            name = "zcal_en";
            desc = "Impedance calibration enable. This field specifies whether to perform impedance calibration. The field is cleared after impedance calibration completes.";
            sw = rw; hw = r;
            reset = 0x1;
        } zcal_en[3:3];
        field {
            name = "dlymeas_en";
            desc = "Delay measurement enable. This field specifies whether the initial delay measurement of the read delay line is activated. Setting this field to 1 enables delay measurement.";
            sw = rw; hw = r;
            reset = 0x1;
        } dlymeas_en[2:2];
        field {
            name = "pll_init_en";
            desc = "PLL initialization enable. This field activates PLL initialization. If this field is 1, the PLL is reset and waits for the PLL to lock.";
            sw = rw; hw = r;
            reset = 0x1;
        } pll_init_en[1:1];
        field {
            name = "init_en";
            desc = "PHY initialization enable. Writing 1 to this field triggers the PHY initialization sequence. Bits 1-15 of this register specify the individual initialization operations. After PHY initialization completes, this field is cleared. Note: Writing 0 to this field has no effect.";
            sw = rw; hw = r;
            reset = 0x0;
        } init_en[0:0];
    } PACK_PHYINITCTRL @ 0x4;
    reg {
        name = "PACK_PHYSTS";
        desc = "PACK_PHYSTS is the PHY status register. PACK_PHYSTS (offset 0x008, total reset 0x0000_0000; PROVEN: Hi3535 data sheet, PDF page 671, section 4.1.8.2).";
        field {
            name = "reserved";
            desc = "Reserved.";
            sw = r; hw = w;
            reset = 0x0;
        } reserved_31_10[31:10];
        field {
            name = "wdet_err";
            desc = "Write data eye calibration error. This field indicates whether an error occurred while calibrating the write data eye. Writing 1 to this field clears the error status. (data sheet access type RWC)";
            sw = rw; hw = rw; onwrite = woclr;
            reset = 0x0;
        } wdet_err[9:9];
        field {
            name = "rdet_err";
            desc = "Read data eye calibration error. This field indicates whether an error occurred during read data eye calibration. Writing 1 to this field clears the error status. (data sheet access type RWC)";
            sw = rw; hw = rw; onwrite = woclr;
            reset = 0x0;
        } rdet_err[8:8];
        field {
            name = "wl2_err";
            desc = "Write leveling adjustment enable. This field indicates whether an error occurred during write leveling adjustment. Writing 1 to this field clears the error status. (data sheet access type RWC)";
            sw = rw; hw = rw; onwrite = woclr;
            reset = 0x0;
        } wl2_err[7:7];
        field {
            name = "gdst_err";
            desc = "PHY read data latch training error. This field indicates whether an error occurred during read data latch training. Writing 1 to this field clears the error status. (data sheet access type RWC)";
            sw = rw; hw = rw; onwrite = woclr;
            reset = 0x0;
        } gdst_err[6:6];
        field {
            name = "gt_err";
            desc = "Gate training error. This field indicates whether an error occurred during gate training. Writing 1 to this field clears the error status. (data sheet access type RWC)";
            sw = rw; hw = rw; onwrite = woclr;
            reset = 0x0;
        } gt_err[5:5];
        field {
            name = "wl_err";
            desc = "Write leveling error. This field indicates whether an error occurred during write leveling. Writing 1 to this field clears the error status. (data sheet access type RWC)";
            sw = rw; hw = rw; onwrite = woclr;
            reset = 0x0;
        } wl_err[4:4];
        field {
            name = "zcal_err";
            desc = "Impedance calibration error. This field indicates whether an error occurred during impedance calibration. Writing 1 to this field clears the error status. (data sheet access type RWC)";
            sw = rw; hw = rw; onwrite = woclr;
            reset = 0x0;
        } zcal_err[3:3];
        field {
            name = "dlymeas_err";
            desc = "Delay measurement failure. This field indicates whether an initial delay measurement failed. Writing 1 to this field clears the error status. (data sheet access type RWC)";
            sw = rw; hw = rw; onwrite = woclr;
            reset = 0x0;
        } dlymeas_err[2:2];
        field {
            name = "pll_lock_err";
            desc = "PLL lock failure. This field indicates that locking a PLL in the PHY failed after the t_pll_lock timer. Writing 1 to this field clears the error status. (data sheet access type RWC)";
            sw = rw; hw = rw; onwrite = woclr;
            reset = 0x0;
        } pll_lock_err[1:1];
        field {
            name = "reserved";
            desc = "Reserved.";
            sw = r; hw = w;
            reset = 0x0;
        } reserved_0_0[0:0];
    } PACK_PHYSTS @ 0x8;
    reg {
        name = "PACK_PHYTMR0";
        desc = "PACK_PHYTMR0 is PHY timing parameter register 0. PACK_PHYTMR0 (offset 0x010, total reset 0x0000_000F; PROVEN: Hi3535 data sheet, PDF page 672, section 4.1.8.2).";
        field {
            name = "reserved";
            desc = "Reserved.";
            sw = r; hw = w;
            reset = 0x0;
        } reserved_31_8[31:8];
        field {
            name = "t_dram_reset";
            desc = "DDR3 DRAM reset. This field specifies the time for sending the reset signal to the DRAM.";
            sw = rw; hw = r;
            reset = 0xf;
        } t_dram_reset[7:0];
    } PACK_PHYTMR0 @ 0x10;
    reg {
        name = "PACK_PHYTMR1";
        desc = "PACK_PHYTMR1 is PHY timing parameter register 1. PACK_PHYTMR1 (offset 0x014, total reset 0x4000_2000; PROVEN: Hi3535 data sheet, PDF page 673, section 4.1.8.2).";
        field {
            name = "t_dram_cke_high";
            desc = "DRAM CKE high initialization. This field specifies the number of clock cycles from CKE going high to the first DRAM command.";
            sw = rw; hw = r;
            reset = 0x4000;
        } t_dram_cke_high[31:16];
        field {
            name = "t_dram_cke_low";
            desc = "DRAM CKE low initialization. This field specifies the number of clock cycles CKE must be held low after power reset and clock stabilization.";
            sw = rw; hw = r;
            reset = 0x2000;
        } t_dram_cke_low[15:0];
    } PACK_PHYTMR1 @ 0x14;
    reg {
        name = "PACK_PLLCTRL";
        desc = "PACK_PLLCTRL is the PLL address/command and data block timing parameter control register. PACK_PLLCTRL (offset 0x018, total reset 0x0000_0000; PROVEN: Hi3535 data sheet, PDF page 673, section 4.1.8.2).";
        field {
            name = "reserved";
            desc = "Reserved.";
            sw = r; hw = w;
            reset = 0x0;
        } reserved_31_4[31:4];
        field {
            name = "pll_freq_range";
            desc = "PLL frequency range select. This field specifies the input frequency range of the PLL.";
            sw = rw; hw = r;
            reset = 0x0;
        } pll_freq_range[3:2];
        field {
            name = "pll_pwdn";
            desc = "PLL power-down. This field sets the power-down state of the PLL input. Setting this field to 1 enables the PLL power-down pin. Writing 0 to this field disables the PLL power-down pin.";
            sw = rw; hw = r;
            reset = 0x0;
        } pll_pwdn[1:1];
        field {
            name = "reserved";
            desc = "Reserved.";
            sw = r; hw = w;
            reset = 0x0;
        } reserved_0_0[0:0];
    } PACK_PLLCTRL @ 0x18;
    reg {
        name = "PACK_PLLTMR";
        desc = "PACK_PLLTMR is the PLL address/command and data block control register. PACK_PLLTMR (offset 0x01C, total reset 0x4E20_0080; PROVEN: Hi3535 data sheet, PDF page 674, section 4.1.8.2).";
        field {
            name = "t_pll_lock";
            desc = "PLL lock time. This field sets the number of clock cycles to wait for the PLL to lock.";
            sw = rw; hw = r;
            reset = 0x4e20;
        } t_pll_lock[31:16];
        field {
            name = "reserved";
            desc = "Reserved.";
            sw = r; hw = w;
            reset = 0x0;
        } reserved_15_8[15:8];
        field {
            name = "t_pll_rst";
            desc = "PLL reset time. This field sets the number of clock cycles for which the reset signal is sent to the PLL.";
            sw = rw; hw = r;
            reset = 0x80;
        } t_pll_rst[7:0];
    } PACK_PLLTMR @ 0x1c;
    reg {
        name = "PACK_DLYMEASCTRL";
        desc = "PACK_DLYMEASCTRL is the read delay line measurement control register. PACK_DLYMEASCTRL (offset 0x020, total reset 0x0000_0471; PROVEN: Hi3535 data sheet, PDF page 674, section 4.1.8.2).";
        field {
            name = "reserved";
            desc = "Reserved.";
            sw = r; hw = w;
            reset = 0x0;
        } reserved_31_15[31:15];
        field {
            name = "dly_track_limit";
            desc = "Delay tracking limit. This field sets the maximum cumulative number of taps supported during dynamic tracking.";
            sw = rw; hw = r;
            reset = 0x4;
        } dly_track_limit[14:8];
        field {
            name = "reserved";
            desc = "Reserved.";
            sw = rw; hw = r;
            reset = 0x0;
        } reserved_7_7[7:7];
        field {
            name = "phy_autoref_en";
            desc = "PHY auto-refresh tracking enable.";
            sw = rw; hw = r;
            reset = 0x1;
        } phy_autoref_en[6:6];
        field {
            name = "dynamic_dqsen";
            desc = "Dynamic DQS tracking enable.";
            sw = rw; hw = r;
            reset = 0x1;
        } dynamic_dqsen[5:5];
        field {
            name = "dynamic_dqsgen";
            desc = "Dynamic DQSG tracking enable.";
            sw = rw; hw = r;
            reset = 0x1;
        } dynamic_dqsgen[4:4];
        field {
            name = "dynamic_dqsgth";
            desc = "Dynamic DQSG update threshold. This field sets the accumulated number of taps before the RDQSG delay line is updated.";
            sw = rw; hw = r;
            reset = 0x0;
        } dynamic_dqsgth[3:2];
        field {
            name = "dly_track_type";
            desc = "Latency tracking type. This field specifies whether the priority updated from the PHY is used during dynamic tracking. Setting this field to 1 uses the priority updated from the PHY.";
            sw = rw; hw = r;
            reset = 0x0;
        } dly_track_type[1:1];
        field {
            name = "dly_meas_type";
            desc = "Delay measurement type. This field specifies whether the delay measurement is made over 1 clock cycle or half a clock cycle. Setting this field to 1 measures one full clock cycle.";
            sw = rw; hw = r;
            reset = 0x1;
        } dly_meas_type[0:0];
    } PACK_DLYMEASCTRL @ 0x20;
    reg {
        name = "PACK_ZCALCTRL";
        desc = "PACK_ZCALCTRL is the ZQ calibration control register. PACK_ZCALCTRL (offset 0x024, total reset 0x0000_0020; PROVEN: Hi3535 data sheet, PDF page 675, section 4.1.8.2).";
        field {
            name = "reserved";
            desc = "Reserved.";
            sw = r; hw = w;
            reset = 0x0;
        } reserved_31_6[31:6];
        field {
            name = "zcomp_rsp_dly";
            desc = "ZQ comparator response time. This field specifies the delay of the zcomp result after zctrl is used.";
            sw = rw; hw = r;
            reset = 0x20;
        } zcomp_rsp_dly[5:0];
    } PACK_ZCALCTRL @ 0x24;
    reg {
        name = "PACK_ZCAL_STATUS";
        desc = "PACK_ZCAL_STATUS is the ZQ calibration result register. PACK_ZCAL_STATUS (offset 0x028, total reset 0x0020_0020; PROVEN: Hi3535 data sheet, PDF page 676, section 4.1.8.2).";
        field {
            name = "reserved";
            desc = "Reserved.";
            sw = r; hw = w;
            reset = 0x0;
        } reserved_31_31[31:31];
        field {
            name = "zcode_pdrv_cal";
            desc = "P driver impedance calibration code. This field shows the P driver calibration code during impedance calibration.";
            sw = r; hw = w;
            reset = 0x0;
        } zcode_pdrv_cal[30:24];
        field {
            name = "pdrv_cal_result";
            desc = "P drive calibration result. This field is used to set the ZQ calibration result.
- 0: Calibration completed without error;
- 1: Calibration completed with an error. Writing 1 to this field clears it.";
            sw = r; hw = w;
            reset = 0x0;
        } pdrv_cal_result[23:23];
        field {
            name = "reserved";
            desc = "Reserved.";
            sw = r; hw = w;
            reset = 0x0;
        } reserved_22_22[22:22];
        field {
            name = "zcode_pdrv";
            desc = "P drive impedance control code. This field specifies the P drive impedance control code. This register is updated by the user or after each ZQ calibration completes.";
            sw = rw; hw = r;
            reset = 0x20;
        } zcode_pdrv[21:16];
        field {
            name = "reserved";
            desc = "Reserved.";
            sw = r; hw = w;
            reset = 0x0;
        } reserved_15_15[15:15];
        field {
            name = "zcode_ndrv_cal";
            desc = "N driver impedance calibration code. This field shows the N driver calibration code during impedance calibration.";
            sw = r; hw = w;
            reset = 0x0;
        } zcode_ndrv_cal[14:8];
        field {
            name = "ndrv_cal_result";
            desc = "N driver calibration result. This field is used to set the ZQ calibration result.
- 0: Calibration completed without error.
- 1: Calibration completed with error. Writing 1 to this field clears it.";
            sw = r; hw = w;
            reset = 0x0;
        } ndrv_cal_result[7:7];
        field {
            name = "reserved";
            desc = "Reserved.";
            sw = r; hw = w;
            reset = 0x0;
        } reserved_6_6[6:6];
        field {
            name = "zcode_ndrv";
            desc = "N drive impedance control code. This field specifies the N drive impedance control code. This register is updated by the user or after each ZQ calibration completes.";
            sw = rw; hw = r;
            reset = 0x20;
        } zcode_ndrv[5:0];
    } PACK_ZCAL_STATUS @ 0x28;
    reg {
        name = "PACK_DRAMCFG";
        desc = "PACK_DRAMCFG is the DRAM configuration system register. PACK_DRAMCFG (offset 0x02C, total reset 0x0000_0002; PROVEN: Hi3535 data sheet, PDF page 677, section 4.1.8.2).";
        field {
            name = "reserved";
            desc = "Reserved.";
            sw = r; hw = w;
            reset = 0x0;
        } reserved_31_7[31:7];
        field {
            name = "maddr_mir";
            desc = "Address mirroring. This field must be set to 0 for a single-rank configuration.";
            sw = rw; hw = r;
            reset = 0x0;
        } maddr_mir[6:6];
        field {
            name = "ma2t";
            desc = "Two address/command cycles. This field specifies whether the PHY controller that generates DRAM commands internally uses 2T timing.";
            sw = rw; hw = r;
            reset = 0x0;
        } ma2t[5:5];
        field {
            name = "nosra";
            desc = "No simultaneous rank access. This field specifies whether simultaneous rank accesses are allowed within the same clock cycle. Setting this field to 1 makes rank accesses take turns. Note: This field can be enabled only when the number of ranks is 2 or 4. It must be set to 0 for a single-rank configuration.";
            sw = rw; hw = r;
            reset = 0x0;
        } nosra[4:4];
        field {
            name = "reserved";
            desc = "Reserved.";
            sw = r; hw = w;
            reset = 0x0;
        } reserved_3_3[3:3];
        field {
            name = "dcfg_type";
            desc = "DRAM type enable. This field sets the DDR RAM type.
- 010: DDR3. Others: Reserved.";
            sw = rw; hw = r;
            reset = 0x2;
        } dcfg_type[2:0];
    } PACK_DRAMCFG @ 0x2c;
    reg {
        name = "PACK_DRAMTMR0";
        desc = "PACK_DRAMTMR0 is DRAM timing parameter register 0. The command delays set by this register apply only to commands issued internally from the PHY registers. PACK_DRAMTMR0 (offset 0x030, total reset 0x0000_0000; PROVEN: Hi3535 data sheet, PDF page 678, section 4.1.8.2).";
        field {
            name = "t_rc";
            desc = "Activate-to-activate command delay for the same bank.";
            sw = rw; hw = r;
            reset = 0x0;
        } t_rc[31:26];
        field {
            name = "t_rrd";
            desc = "Activate-to-activate command delay between different banks.";
            sw = rw; hw = r;
            reset = 0x0;
        } t_rrd[25:22];
        field {
            name = "t_ras";
            desc = "Activate-to-precharge command cycle.";
            sw = rw; hw = r;
            reset = 0x0;
        } t_ras[21:16];
        field {
            name = "t_rcd";
            desc = "Activate-to-read/write delay.";
            sw = rw; hw = r;
            reset = 0x0;
        } t_rcd[15:12];
        field {
            name = "t_rp";
            desc = "Precharge command cycles.";
            sw = rw; hw = r;
            reset = 0x0;
        } t_rp[11:8];
        field {
            name = "t_wtr";
            desc = "Write-to-read command cycles.";
            sw = rw; hw = r;
            reset = 0x0;
        } t_wtr[7:4];
        field {
            name = "t_rtp";
            desc = "Read-to-precharge command cycles.";
            sw = rw; hw = r;
            reset = 0x0;
        } t_rtp[3:0];
    } PACK_DRAMTMR0 @ 0x30;
    reg {
        name = "PACK_DRAMTMR1";
        desc = "PACK_DRAMTMR1 is DRAM timing parameter register 1. The command delays set by this register apply only to commands issued internally from the PHY registers. PACK_DRAMTMR1 (offset 0x034, total reset 0x0000_0000; PROVEN: Hi3535 data sheet, PDF page 678, section 4.1.8.2).";
        field {
            name = "reserved";
            desc = "Reserved.";
            sw = r; hw = w;
            reset = 0x0;
        } reserved_31_29[31:29];
        field {
            name = "t_rtw";
            desc = "Read-to-write command delay. This field specifies whether extra cycles are inserted between read and write commands. Normally this value is 3.";
            sw = rw; hw = r;
            reset = 0x0;
        } t_rtw[28:25];
        field {
            name = "t_rfc";
            desc = "Refresh-to-refresh command delay.";
            sw = rw; hw = r;
            reset = 0x0;
        } t_rfc[24:16];
        field {
            name = "reserved";
            desc = "Reserved.";
            sw = r; hw = w;
            reset = 0x0;
        } reserved_15_15[15:15];
        field {
            name = "t_faw";
            desc = "Four-bank activate window. This field is valid only for 8-rank devices.";
            sw = rw; hw = r;
            reset = 0x0;
        } t_faw[14:9];
        field {
            name = "t_mod";
            desc = "Load mode register to non-load-mode-register command delay. This field is valid only for DDR3.";
            sw = rw; hw = r;
            reset = 0x0;
        } t_mod[8:4];
        field {
            name = "t_mrd";
            desc = "Load mode register to load mode register command delay.";
            sw = rw; hw = r;
            reset = 0x0;
        } t_mrd[3:0];
    } PACK_DRAMTMR1 @ 0x34;
    reg {
        name = "PACK_DRAMTMR2";
        desc = "PACK_DRAMTMR2 is DRAM timing parameter register 2. The command delays set by this register apply only to commands issued from within the PHY registers. PACK_DRAMTMR2 (offset 0x038, total reset 0x0000_0000; PROVEN: Hi3535 data sheet, PDF page 679, section 4.1.8.2).";
        field {
            name = "t_ccd";
            desc = "Read-to-read and write-to-write command delay.
- 0 = BL/2 (for DDR3, this value should be 4)
- 1 = BL/2 + 1 (for DDR3, this value should be 5)";
            sw = rw; hw = r;
            reset = 0x0;
        } t_ccd[31:31];
        field {
            name = "reserved";
            desc = "Reserved.";
            sw = r; hw = w;
            reset = 0x0;
        } reserved_30_30[30:30];
        field {
            name = "t_dllk";
            desc = "DLL lock time.";
            sw = rw; hw = r;
            reset = 0x0;
        } t_dllk[29:20];
        field {
            name = "t_cke";
            desc = "CKE minimum pulse width.";
            sw = rw; hw = r;
            reset = 0x0;
        } t_cke[19:16];
        field {
            name = "reserved";
            desc = "Reserved.";
            sw = r; hw = w;
            reset = 0x0;
        } reserved_15_15[15:15];
        field {
            name = "t_xp";
            desc = "Power-down exit delay.";
            sw = rw; hw = r;
            reset = 0x0;
        } t_xp[14:10];
        field {
            name = "t_xs";
            desc = "Self-refresh exit delay.";
            sw = rw; hw = r;
            reset = 0x0;
        } t_xs[9:0];
    } PACK_DRAMTMR2 @ 0x38;
    reg {
        name = "PACK_DRAMTMR3";
        desc = "PACK_DRAMTMR3 is DRAM timing parameter register 3. The command delay set in this register applies only to commands issued from within the PHY registers. PACK_DRAMTMR3 (offset 0x03C, total reset 0x0010_0200; PROVEN: Hi3535 data sheet, PDF page 680, section 4.1.8.2).";
        field {
            name = "t_wr";
            desc = "Write recovery cycles.";
            sw = rw; hw = r;
            reset = 0x0;
        } t_wr[31:28];
        field {
            name = "t_wl";
            desc = "Write latency (AL+CWL).";
            sw = rw; hw = r;
            reset = 0x0;
        } t_wl[27:24];
        field {
            name = "t_init5";
            desc = "LPDDR device initialization time. This field specifies the time required for the LPDDR to set the DAI bit to 1.";
            sw = rw; hw = r;
            reset = 0x400;
        } t_init5[23:10];
        field {
            name = "t_zcal";
            desc = "ZQ calibration command delay. This field sets the number of clock cycles to wait after the initial ZQ calibration. For a normal full DDR3 ZQ calibration, divide the field value by 2; for DDR3 ZQ initialization calibration, divide it by 4; for LPDDR2/3, this field specifies the tZQINIT value at initialization.";
            sw = rw; hw = r;
            reset = 0x200;
        } t_zcal[9:0];
    } PACK_DRAMTMR3 @ 0x3c;
    reg {
        name = "PACK_DRAMTMR4";
        desc = "PACK_DRAMTMR4 is the DRAM write leveling timing parameter register. This field is valid only for DDR3 SDRAM. PACK_DRAMTMR4 (offset 0x040, total reset 0x0000_0000; PROVEN: Hi3535 data sheet, PDF page 681, section 4.1.8.2).";
        field {
            name = "reserved";
            desc = "Reserved.";
            sw = r; hw = w;
            reset = 0x0;
        } reserved_31_19[31:19];
        field {
            name = "t_odton";
            desc = "ODT turn-on delay (number of clock cycles from the write command to ODT assertion).";
            sw = rw; hw = r;
            reset = 0x0;
        } t_odton[18:15];
        field {
            name = "t_odt";
            desc = "ODT turn-on period.";
            sw = rw; hw = r;
            reset = 0x0;
        } t_odt[14:12];
        field {
            name = "t_wlo";
            desc = "Write leveling output delay. This field specifies the write leveling output delay (in cycles).";
            sw = rw; hw = r;
            reset = 0x0;
        } t_wlo[11:8];
        field {
            name = "reserved";
            desc = "Reserved.";
            sw = r; hw = w;
            reset = 0x0;
        } reserved_7_6[7:6];
        field {
            name = "t_wlmrd";
            desc = "Delay from the programmed write leveling mode (load mode register) to the first DQS/DQS# rising edge.";
            sw = rw; hw = r;
            reset = 0x0;
        } t_wlmrd[5:0];
    } PACK_DRAMTMR4 @ 0x40;
    reg {
        name = "PACK_ODTCR";
        desc = "PACK_ODTCR is the rank ODT control register for reads or writes to a specific rank. PACK_ODTCR (offset 0x044, total reset 0x0000_0000; PROVEN: Hi3535 data sheet, PDF page 681, section 4.1.8.2).";
        field {
            name = "reserved";
            desc = "Reserved.";
            sw = r; hw = w;
            reset = 0x0;
        } reserved_31_16[31:16];
        field {
            name = "wodt_rank3";
            desc = "Write rank 3 ODT control. This field specifies the ODT issued when writing rank 3.";
            sw = rw; hw = r;
            reset = 0x0;
        } wodt_rank3[15:12];
        field {
            name = "wodt_rank2";
            desc = "Write rank 2 ODT control. This field specifies the ODT issued when writing rank 2.";
            sw = rw; hw = r;
            reset = 0x0;
        } wodt_rank2[11:8];
        field {
            name = "wodt_rank1";
            desc = "Write rank 1 ODT control. This field specifies the ODT issued when writing rank 1.";
            sw = rw; hw = r;
            reset = 0x0;
        } wodt_rank1[7:4];
        field {
            name = "wodt_rank0";
            desc = "Write rank 0 ODT control. This field specifies the ODT issued when writing rank 0.";
            sw = rw; hw = r;
            reset = 0x0;
        } wodt_rank0[3:0];
    } PACK_ODTCR @ 0x44;
    reg {
        name = "PACK_TRCR0";
        desc = "PACK_TRCR0 is training control register 0. PACK_TRCR0 (offset 0x048, total reset 0x0010_0008; PROVEN: Hi3535 data sheet, PDF page 682, section 4.1.8.2).";
        field {
            name = "reserved";
            desc = "Reserved.";
            sw = r; hw = w;
            reset = 0x0;
        } reserved_31_22[31:22];
        field {
            name = "gtds_rspdly";
            desc = "Gating/read latch training response delay. This field specifies the wait time for checking the PHY response when performing gating and read latch training.";
            sw = rw; hw = r;
            reset = 0x10;
        } gtds_rspdly[21:16];
        field {
            name = "reserved";
            desc = "Reserved.";
            sw = r; hw = w;
            reset = 0x0;
        } reserved_15_4[15:4];
        field {
            name = "skip_eye_opening";
            desc = "Skip eye windowing during data eye training. This field specifies whether to skip eye windowing. If this field is 1, the eye windowing before data eye training is skipped. If this field is 0, eye windowing is performed before data eye training.";
            sw = rw; hw = r;
            reset = 0x1;
        } skip_eye_opening[3:3];
        field {
            name = "reserved";
            desc = "Reserved.";
            sw = r; hw = w;
            reset = 0x0;
        } reserved_2_2[2:2];
        field {
            name = "dtr_rank";
            desc = "Training rank. This field specifies the rank used for training. After training completes, this field is used to select the source of rank-specific settings.";
            sw = rw; hw = r;
            reset = 0x0;
        } dtr_rank[1:0];
    } PACK_TRCR0 @ 0x48;
    reg {
        name = "PACK_TRMADDR";
        desc = "PACK_TRMADDR is the data training memory start address register. The minimum memory space required for data training is 64 bytes, and the allocated memory must be 64-byte aligned. PACK_TRMADDR (offset 0x0050, total reset 0x0000_0000; PROVEN: Hi3535 data sheet, PDF page 683, section 4.1.8.2).";
        field {
            name = "dtrow";
            desc = "Data training row address. If necessary, this field can be used as the memory row address during data training.";
            sw = rw; hw = r;
            reset = 0x0;
        } dtrow[31:16];
        field {
            name = "dtcol";
            desc = "Data training column address. If necessary, this field can be used as the memory column address during data training.";
            sw = rw; hw = r;
            reset = 0x0;
        } dtcol[15:4];
        field {
            name = "reserved";
            desc = "Reserved.";
            sw = r; hw = w;
            reset = 0x0;
        } reserved_3_3[3:3];
        field {
            name = "dtbank";
            desc = "Data training bank address. If necessary, this field can be used as the memory bank address during data training.";
            sw = rw; hw = r;
            reset = 0x0;
        } dtbank[2:0];
    } PACK_TRMADDR @ 0x50;
    reg {
        name = "PACK_DRAM_MR01";
        desc = "PACK_DRAM_MR01 is the register holding the mode register contents. PACK_DRAM_MR01 (offset 0x0064, total reset 0x0000_0000; PROVEN: Hi3535 data sheet, PDF page 683, section 4.1.8.2).";
        field {
            name = "mr1";
            desc = "Mode register 1. For DDR/DDR2/DDR3/LPDDR, this field specifies the content of extended mode register 1. For LPDDR2/LPDDR3, this field defines MR3/MR9 of the mode registers.";
            sw = rw; hw = r;
            reset = 0x0;
        } mr1[31:16];
        field {
            name = "mr0";
            desc = "Mode register 0. For DDR/DDR2/DDR3/LPDDR, this field specifies the contents of mode register 0. For LPDDR2/LPDDR3, this field defines MR1/MR2 of the mode registers.";
            sw = rw; hw = r;
            reset = 0x0;
        } mr0[15:0];
    } PACK_DRAM_MR01 @ 0x64;
    reg {
        name = "PACK_DRAM_MR23";
        desc = "PACK_DRAM_MR23 is the register holding the mode register contents. PACK_DRAM_MR23 (offset 0x0068, total reset 0x0000_0000; PROVEN: Hi3535 data sheet, PDF page 684, section 4.1.8.2).";
        field {
            name = "mr3";
            desc = "Mode register 3. For DDR/DDR2/DDR3, this field specifies extended mode register 3.";
            sw = rw; hw = r;
            reset = 0x0;
        } mr3[31:16];
        field {
            name = "mr2";
            desc = "Mode register 2. For DDR/DDR2/DDR3, this field specifies extended mode register 2. For LPDDR2/LPDDR3, this field defines MR16/MR17.";
            sw = rw; hw = r;
            reset = 0x0;
        } mr2[15:0];
    } PACK_DRAM_MR23 @ 0x68;
    reg {
        name = "PACK_MISC";
        desc = "PACK_MISC is the miscellaneous control register. PACK_MISC (offset 0x0070, total reset 0x0008_0000; PROVEN: Hi3535 data sheet, PDF page 684, section 4.1.8.2).";
        field {
            name = "reserved";
            desc = "Reserved.";
            sw = r; hw = w;
            reset = 0x0;
        } reserved_31_21[31:21];
        field {
            name = "cfg_dlyupd";
            desc = "Transparent mode enable of the delay update module. When this field is 1, the delay settings in the registers are applied to the PHY immediately.";
            sw = rw; hw = r;
            reset = 0x0;
        } cfg_dlyupd[20:20];
        field {
            name = "addr_delay";
            desc = "1-T delay of address/command. When CWL is 5, this field must be set to 1.";
            sw = rw; hw = r;
            reset = 0x1;
        } addr_delay[19:19];
        field {
            name = "swap_en";
            desc = "Swap the address and data buses.";
            sw = r; hw = w;
            reset = 0x0;
        } swap_en[18:18];
        field {
            name = "addr_toggle";
            desc = "Toggle the address bus every clock cycle. Set this field to 1 only during burn-in testing.";
            sw = rw; hw = r;
            reset = 0x0;
        } addr_toggle[17:17];
        field {
            name = "sramb_en";
            desc = "Data scrambling enable. Setting this field to 1 enables the data scrambling function.";
            sw = rw; hw = r;
            reset = 0x0;
        } sramb_en[16:16];
        field {
            name = "reserved";
            desc = "Reserved.";
            sw = r; hw = w;
            reset = 0x0;
        } reserved_15_12[15:12];
        field {
            name = "cfg_rl";
            desc = "PHY read latency. This field sets the number of clock cycles from the read command to the assertion of rddata_en. The field value is (CL + AL - 2).";
            sw = rw; hw = r;
            reset = 0x0;
        } cfg_rl[11:7];
        field {
            name = "reserved";
            desc = "Reserved.";
            sw = r; hw = w;
            reset = 0x0;
        } reserved_6_5[6:5];
        field {
            name = "cfg_wl";
            desc = "PHY write latency. This field sets the number of clock cycles from the write command to the assertion of wrdata_en. The field value is (CWL + AL - 1). If the DFI clock ratio is 1:2, the field value must be greater than or equal to 2.";
            sw = rw; hw = r;
            reset = 0x0;
        } cfg_wl[4:0];
    } PACK_MISC @ 0x70;
    reg {
        name = "PACK_PHYDBG";
        desc = "PACK_PHYDBG is the PHY debug register. PACK_PHYDBG (offset 0x007C, total reset 0x0000_0000; PROVEN: Hi3535 data sheet, PDF page 685, section 4.1.8.2).";
        field {
            name = "reserved";
            desc = "Reserved.";
            sw = r; hw = w;
            reset = 0x0;
        } reserved_31_24[31:24];
        field {
            name = "dqsb_gated_error";
            desc = "DQSN gating error flag. It can be cleared only by sending the PHY reset signal.";
            sw = r; hw = w;
            reset = 0x0;
        } dqsb_gated_error[23:16];
        field {
            name = "reserved";
            desc = "Reserved.";
            sw = r; hw = w;
            reset = 0x0;
        } reserved_15_8[15:8];
        field {
            name = "dqs_gated_error";
            desc = "DQS gating error flag. Can only be cleared by sending the PHY reset signal.";
            sw = r; hw = w;
            reset = 0x0;
        } dqs_gated_error[7:0];
    } PACK_PHYDBG @ 0x7c;
    reg {
        name = "PACK_DMSEL";
        desc = "PACK_DMSEL is the DM swap select register. PACK_DMSEL (offset 0x084, total reset 0x0000_0000; PROVEN: Hi3535 data sheet, PDF page 686, section 4.1.8.2).";
        field {
            name = "reserved";
            desc = "Reserved.";
            sw = r; hw = w;
            reset = 0x0;
        } reserved_31_4[31:4];
        field {
            name = "xctl_dmswap_sel";
            desc = "Bit [3:2]: DM 1 swap select. Bit [1:0]: DM 0 swap select.";
            sw = rw; hw = r;
            reset = 0x0;
        } xctl_dmswap_sel[3:0];
    } PACK_DMSEL @ 0x84;
    reg {
        name = "PACK_SWTMODE";
        desc = "PACK_SWTMODE is the S/W training mode configuration register. PACK_SWTMODE (offset 0x00A0, total reset 0x0000_0000; PROVEN: Hi3535 data sheet, PDF page 686, section 4.1.8.2).";
        field {
            name = "reserved";
            desc = "Reserved.";
            sw = r; hw = w;
            reset = 0x0;
        } reserved_31_2[31:2];
        field {
            name = "sw_gtmode";
            desc = "Set this field to 1 when performing S/W gating training or GDS training.";
            sw = rw; hw = r;
            reset = 0x0;
        } sw_gtmode[1:1];
        field {
            name = "sw_wlmode";
            desc = "Set this field to 1 when performing S/W write leveling training.";
            sw = rw; hw = r;
            reset = 0x0;
        } sw_wlmode[0:0];
    } PACK_SWTMODE @ 0xa0;
    reg {
        name = "PACK_SWTWLDQS";
        desc = "PACK_SWTWLDQS is the write DQS launch register used during S/W write leveling training. PACK_SWTWLDQS (offset 0x0A4, total reset 0x0000_0000; PROVEN: Hi3535 data sheet, PDF page 687, section 4.1.8.2).";
        field {
            name = "reserved";
            desc = "Reserved.";
            sw = r; hw = w;
            reset = 0x0;
        } reserved_31_1[31:1];
        field {
            name = "sw_wl_dqs";
            desc = "Writing 1 to this field issues one DQS pulse from the PHY to the DRAM.";
            sw = w; hw = r;
            reset = 0x0;
        } sw_wl_dqs[0:0];
    } PACK_SWTWLDQS @ 0xa4;
    reg {
        name = "PACK_SWTRLT";
        desc = "PACK_SWTRLT is the S/W training result register. PACK_SWTRLT (offset 0x0A8, total reset 0x0000_0000; PROVEN: Hi3535 data sheet, PDF page 687, section 4.1.8.2).";
        field {
            name = "reserved";
            desc = "Reserved.";
            sw = r; hw = w;
            reset = 0x0;
        } reserved_31_24[31:24];
        field {
            name = "gds_result";
            desc = "Each bit corresponds to one byte lane.";
            sw = r; hw = w;
            reset = 0x0;
        } gds_result[23:16];
        field {
            name = "gt_result";
            desc = "Each bit corresponds to one byte lane.";
            sw = r; hw = w;
            reset = 0x0;
        } gt_result[15:8];
        field {
            name = "wl_dq_result";
            desc = "Each bit corresponds to one byte lane.";
            sw = r; hw = w;
            reset = 0x0;
        } wl_dq_result[7:0];
    } PACK_SWTRLT @ 0xa8;
    reg {
        name = "PACK_ACCMDBDL0";
        desc = "PACK_ACCMDBDL0 is AC command bit delay line configuration register 0. PACK_ACCMDBDL0 (offset 0x120, total reset 0x0000_0000; PROVEN: Hi3535 data sheet, PDF page 687, section 4.1.8.2).";
        field {
            name = "reserved";
            desc = "Reserved.";
            sw = r; hw = w;
            reset = 0x0;
        } reserved_31_21[31:21];
        field {
            name = "odt1_bdl";
            desc = "Bit delay line setting for ODT 1.";
            sw = rw; hw = r;
            reset = 0x0;
        } odt1_bdl[20:16];
        field {
            name = "reserved";
            desc = "Reserved.";
            sw = r; hw = w;
            reset = 0x0;
        } reserved_15_5[15:5];
        field {
            name = "odt0_bdl";
            desc = "Bit delay line setting of ODT 0.";
            sw = rw; hw = r;
            reset = 0x0;
        } odt0_bdl[4:0];
    } PACK_ACCMDBDL0 @ 0x120;
    reg {
        name = "PACK_ACCMDBDL1";
        desc = "PACK_ACCMDBDL1 is AC command bit delay line configuration register 1. PACK_ACCMDBDL1 (offset 0x124, total reset 0x0000_0000; PROVEN: Hi3535 data sheet, PDF page 688, section 4.1.8.2).";
        field {
            name = "reserved";
            desc = "Reserved.";
            sw = r; hw = w;
            reset = 0x0;
        } reserved_31_21[31:21];
        field {
            name = "odt3_bdl";
            desc = "Bit delay line setting of ODT 3.";
            sw = rw; hw = r;
            reset = 0x0;
        } odt3_bdl[20:16];
        field {
            name = "reserved";
            desc = "Reserved.";
            sw = r; hw = w;
            reset = 0x0;
        } reserved_15_5[15:5];
        field {
            name = "odt2_bdl";
            desc = "Bit delay line setting of ODT 2.";
            sw = rw; hw = r;
            reset = 0x0;
        } odt2_bdl[4:0];
    } PACK_ACCMDBDL1 @ 0x124;
    reg {
        name = "PACK_ACCMDBDL2";
        desc = "PACK_ACCMDBDL2 is AC command bit delay line configuration register 2. PACK_ACCMDBDL2 (offset 0x128, total reset 0x0000_0000; PROVEN: Hi3535 data sheet, PDF page 688, section 4.1.8.2).";
        field {
            name = "reserved";
            desc = "Reserved.";
            sw = r; hw = w;
            reset = 0x0;
        } reserved_31_21[31:21];
        field {
            name = "cs1_bdl";
            desc = "Bit delay line setting of CS 1.";
            sw = rw; hw = r;
            reset = 0x0;
        } cs1_bdl[20:16];
        field {
            name = "reserved";
            desc = "Reserved.";
            sw = r; hw = w;
            reset = 0x0;
        } reserved_15_5[15:5];
        field {
            name = "cs0_bdl";
            desc = "Bit delay line setting of CS 0.";
            sw = rw; hw = r;
            reset = 0x0;
        } cs0_bdl[4:0];
    } PACK_ACCMDBDL2 @ 0x128;
    reg {
        name = "PACK_ACCMDBDL3";
        desc = "PACK_ACCMDBDL3 is AC command bit delay line configuration register 3. PACK_ACCMDBDL3 (offset 0x12C, total reset 0x0000_0000; PROVEN: Hi3535 data sheet, PDF page 689, section 4.1.8.2).";
        field {
            name = "reserved";
            desc = "Reserved.";
            sw = r; hw = w;
            reset = 0x0;
        } reserved_31_21[31:21];
        field {
            name = "cs3_bdl";
            desc = "Bit delay line setting of CS 3.";
            sw = rw; hw = r;
            reset = 0x0;
        } cs3_bdl[20:16];
        field {
            name = "reserved";
            desc = "Reserved.";
            sw = r; hw = w;
            reset = 0x0;
        } reserved_15_5[15:5];
        field {
            name = "cs2_bdl";
            desc = "Bit delay line setting of CS 2.";
            sw = rw; hw = r;
            reset = 0x0;
        } cs2_bdl[4:0];
    } PACK_ACCMDBDL3 @ 0x12c;
    reg {
        name = "PACK_ACCMDBDL4";
        desc = "PACK_ACCMDBDL4 is AC command bit delay line configuration register 4. PACK_ACCMDBDL4 (offset 0x130, total reset 0x0000_0000; PROVEN: Hi3535 data sheet, PDF page 689, section 4.1.8.2).";
        field {
            name = "reserved";
            desc = "Reserved.";
            sw = r; hw = w;
            reset = 0x0;
        } reserved_31_21[31:21];
        field {
            name = "cke1_bdl";
            desc = "Bit delay line setting for CKE 1.";
            sw = rw; hw = r;
            reset = 0x0;
        } cke1_bdl[20:16];
        field {
            name = "reserved";
            desc = "Reserved.";
            sw = r; hw = w;
            reset = 0x0;
        } reserved_15_5[15:5];
        field {
            name = "cke0_bdl";
            desc = "Bit delay line setting of CKE 0.";
            sw = rw; hw = r;
            reset = 0x0;
        } cke0_bdl[4:0];
    } PACK_ACCMDBDL4 @ 0x130;
    reg {
        name = "PACK_ACCMDBDL5";
        desc = "PACK_ACCMDBDL5 is AC command bit delay line configuration register 5. PACK_ACCMDBDL5 (offset 0x134, total reset 0x0000_0000; PROVEN: Hi3535 data sheet, PDF page 690, section 4.1.8.2).";
        field {
            name = "reserved";
            desc = "Reserved.";
            sw = r; hw = w;
            reset = 0x0;
        } reserved_31_21[31:21];
        field {
            name = "cke3_bdl";
            desc = "Bit delay line setting of CKE 3.";
            sw = rw; hw = r;
            reset = 0x0;
        } cke3_bdl[20:16];
        field {
            name = "reserved";
            desc = "Reserved.";
            sw = r; hw = w;
            reset = 0x0;
        } reserved_15_5[15:5];
        field {
            name = "cke2_bdl";
            desc = "Bit delay line setting for CKE 2.";
            sw = rw; hw = r;
            reset = 0x0;
        } cke2_bdl[4:0];
    } PACK_ACCMDBDL5 @ 0x134;
    reg {
        name = "PACK_ACCMDBDL6";
        desc = "PACK_ACCMDBDL6 is AC command bit delay line configuration register 6. PACK_ACCMDBDL6 (offset 0x138, total reset 0x0000_0000; PROVEN: Hi3535 data sheet, PDF page 690, section 4.1.8.2).";
        field {
            name = "reserved";
            desc = "Reserved.";
            sw = r; hw = w;
            reset = 0x0;
        } reserved_31_21[31:21];
        field {
            name = "cas_bdl";
            desc = "Bit delay line setting of CAS.";
            sw = rw; hw = r;
            reset = 0x0;
        } cas_bdl[20:16];
        field {
            name = "reserved";
            desc = "Reserved.";
            sw = r; hw = w;
            reset = 0x0;
        } reserved_15_5[15:5];
        field {
            name = "we_bdl";
            desc = "Bit delay line setting for WE.";
            sw = rw; hw = r;
            reset = 0x0;
        } we_bdl[4:0];
    } PACK_ACCMDBDL6 @ 0x138;
    reg {
        name = "PACK_ACCMDBDL7";
        desc = "PACK_ACCMDBDL7 is AC command bit delay line configuration register 7. PACK_ACCMDBDL7 (offset 0x13C, total reset 0x0000_0000; PROVEN: Hi3535 data sheet, PDF page 691, section 4.1.8.2).";
        field {
            name = "reserved";
            desc = "Reserved.";
            sw = r; hw = w;
            reset = 0x0;
        } reserved_31_21[31:21];
        field {
            name = "resetn_bdl";
            desc = "Bit delay line setting of RESETN.";
            sw = rw; hw = r;
            reset = 0x0;
        } resetn_bdl[20:16];
        field {
            name = "reserved";
            desc = "Reserved.";
            sw = r; hw = w;
            reset = 0x0;
        } reserved_15_5[15:5];
        field {
            name = "ras_bdl";
            desc = "Bit delay line setting of RAS.";
            sw = rw; hw = r;
            reset = 0x0;
        } ras_bdl[4:0];
    } PACK_ACCMDBDL7 @ 0x13c;
    reg {
        name = "PACK_ACADDRBDL0";
        desc = "PACK_ACADDRBDL0 is AC address bit delay line configuration register 0. PACK_ACADDRBDL0 (offset 0x140, total reset 0x0000_0000; PROVEN: Hi3535 data sheet, PDF page 691, section 4.1.8.2).";
        field {
            name = "reserved";
            desc = "Reserved.";
            sw = r; hw = w;
            reset = 0x0;
        } reserved_31_21[31:21];
        field {
            name = "addr1_bdl";
            desc = "Bit delay line setting of ADDR1.";
            sw = rw; hw = r;
            reset = 0x0;
        } addr1_bdl[20:16];
        field {
            name = "reserved";
            desc = "Reserved.";
            sw = r; hw = w;
            reset = 0x0;
        } reserved_15_5[15:5];
        field {
            name = "addr0_bdl";
            desc = "Bit delay line setting of ADDR0.";
            sw = rw; hw = r;
            reset = 0x0;
        } addr0_bdl[4:0];
    } PACK_ACADDRBDL0 @ 0x140;
    reg {
        name = "PACK_ACADDRBDL1";
        desc = "PACK_ACADDRBDL1 is AC address bit delay line configuration register 1. PACK_ACADDRBDL1 (offset 0x144, total reset 0x0000_0000; PROVEN: Hi3535 data sheet, PDF page 691, section 4.1.8.2).";
        field {
            name = "reserved";
            desc = "Reserved.";
            sw = r; hw = w;
            reset = 0x0;
        } reserved_31_21[31:21];
        field {
            name = "addr3_bdl";
            desc = "Bit delay line setting for ADDR3.";
            sw = rw; hw = r;
            reset = 0x0;
        } addr3_bdl[20:16];
        field {
            name = "reserved";
            desc = "Reserved.";
            sw = r; hw = w;
            reset = 0x0;
        } reserved_15_5[15:5];
        field {
            name = "addr2_bdl";
            desc = "Bit delay line setting for ADDR2.";
            sw = rw; hw = r;
            reset = 0x0;
        } addr2_bdl[4:0];
    } PACK_ACADDRBDL1 @ 0x144;
    reg {
        name = "PACK_ACADDRBDL2";
        desc = "PACK_ACADDRBDL2 is AC address bit delay line configuration register 2. PACK_ACADDRBDL2 (offset 0x148, total reset 0x0000_0000; PROVEN: Hi3535 data sheet, PDF page 692, section 4.1.8.2).";
        field {
            name = "reserved";
            desc = "Reserved.";
            sw = r; hw = w;
            reset = 0x0;
        } reserved_31_21[31:21];
        field {
            name = "addr5_bdl";
            desc = "Bit delay line setting of ADDR5.";
            sw = rw; hw = r;
            reset = 0x0;
        } addr5_bdl[20:16];
        field {
            name = "reserved";
            desc = "Reserved.";
            sw = r; hw = w;
            reset = 0x0;
        } reserved_15_5[15:5];
        field {
            name = "addr4_bdl";
            desc = "Bit delay line setting of ADDR4.";
            sw = rw; hw = r;
            reset = 0x0;
        } addr4_bdl[4:0];
    } PACK_ACADDRBDL2 @ 0x148;
    reg {
        name = "PACK_ACADDRBDL3";
        desc = "PACK_ACADDRBDL3 is AC address bit delay line configuration register 3. PACK_ACADDRBDL3 (offset 0x14C, total reset 0x0000_0000; PROVEN: Hi3535 data sheet, PDF page 692, section 4.1.8.2).";
        field {
            name = "reserved";
            desc = "Reserved.";
            sw = r; hw = w;
            reset = 0x0;
        } reserved_31_21[31:21];
        field {
            name = "addr7_bdl";
            desc = "Bit delay line setting of ADDR7.";
            sw = rw; hw = r;
            reset = 0x0;
        } addr7_bdl[20:16];
        field {
            name = "reserved";
            desc = "Reserved.";
            sw = r; hw = w;
            reset = 0x0;
        } reserved_15_5[15:5];
        field {
            name = "addr6_bdl";
            desc = "Bit delay line setting of ADDR6.";
            sw = rw; hw = r;
            reset = 0x0;
        } addr6_bdl[4:0];
    } PACK_ACADDRBDL3 @ 0x14c;
    reg {
        name = "PACK_ACADDRBDL4";
        desc = "PACK_ACADDRBDL4 is AC address bit delay line configuration register 4. PACK_ACADDRBDL4 (offset 0x150, total reset 0x0000_0000; PROVEN: Hi3535 data sheet, PDF page 693, section 4.1.8.2).";
        field {
            name = "reserved";
            desc = "Reserved.";
            sw = r; hw = w;
            reset = 0x0;
        } reserved_31_21[31:21];
        field {
            name = "addr9_bdl";
            desc = "Bit delay line setting for ADDR9.";
            sw = rw; hw = r;
            reset = 0x0;
        } addr9_bdl[20:16];
        field {
            name = "reserved";
            desc = "Reserved.";
            sw = r; hw = w;
            reset = 0x0;
        } reserved_15_5[15:5];
        field {
            name = "addr8_bdl";
            desc = "Bit delay line setting for ADDR8.";
            sw = rw; hw = r;
            reset = 0x0;
        } addr8_bdl[4:0];
    } PACK_ACADDRBDL4 @ 0x150;
    reg {
        name = "PACK_ACADDRBDL5";
        desc = "PACK_ACADDRBDL5 is AC address bit delay line configuration register 5. PACK_ACADDRBDL5 (offset 0x154, total reset 0x0000_0000; PROVEN: Hi3535 data sheet, PDF page 693, section 4.1.8.2).";
        field {
            name = "reserved";
            desc = "Reserved.";
            sw = r; hw = w;
            reset = 0x0;
        } reserved_31_21[31:21];
        field {
            name = "addr11_bdl";
            desc = "Bit delay line setting for ADDR11.";
            sw = rw; hw = r;
            reset = 0x0;
        } addr11_bdl[20:16];
        field {
            name = "reserved";
            desc = "Reserved.";
            sw = r; hw = w;
            reset = 0x0;
        } reserved_15_5[15:5];
        field {
            name = "addr10_bdl";
            desc = "Bit delay line setting of ADDR10.";
            sw = rw; hw = r;
            reset = 0x0;
        } addr10_bdl[4:0];
    } PACK_ACADDRBDL5 @ 0x154;
    reg {
        name = "PACK_ACADDRBDL6";
        desc = "PACK_ACADDRBDL6 is AC address bit delay line configuration register 6. PACK_ACADDRBDL6 (offset 0x158, total reset 0x0000_0000; PROVEN: Hi3535 data sheet, PDF page 694, section 4.1.8.2).";
        field {
            name = "reserved";
            desc = "Reserved.";
            sw = r; hw = w;
            reset = 0x0;
        } reserved_31_21[31:21];
        field {
            name = "addr13_bdl";
            desc = "Bit delay line setting of ADDR13.";
            sw = rw; hw = r;
            reset = 0x0;
        } addr13_bdl[20:16];
        field {
            name = "reserved";
            desc = "Reserved.";
            sw = r; hw = w;
            reset = 0x0;
        } reserved_15_5[15:5];
        field {
            name = "addr12_bdl";
            desc = "Bit delay line setting of ADDR12.";
            sw = rw; hw = r;
            reset = 0x0;
        } addr12_bdl[4:0];
    } PACK_ACADDRBDL6 @ 0x158;
    reg {
        name = "PACK_ACADDRBDL7";
        desc = "PACK_ACADDRBDL7 is AC address bit delay line configuration register 7. PACK_ACADDRBDL7 (offset 0x15C, total reset 0x0000_0000; PROVEN: Hi3535 data sheet, PDF page 694, section 4.1.8.2).";
        field {
            name = "reserved";
            desc = "Reserved.";
            sw = r; hw = w;
            reset = 0x0;
        } reserved_31_21[31:21];
        field {
            name = "addr15_bdl";
            desc = "Bit delay line setting of ADDR15.";
            sw = rw; hw = r;
            reset = 0x0;
        } addr15_bdl[20:16];
        field {
            name = "reserved";
            desc = "Reserved.";
            sw = r; hw = w;
            reset = 0x0;
        } reserved_15_5[15:5];
        field {
            name = "addr14_bdl";
            desc = "Bit delay line setting of ADDR14.";
            sw = rw; hw = r;
            reset = 0x0;
        } addr14_bdl[4:0];
    } PACK_ACADDRBDL7 @ 0x15c;
    reg {
        name = "PACK_ACADDRBDL8";
        desc = "PACK_ACADDRBDL8 is AC address bit delay line configuration register 8. PACK_ACADDRBDL8 (offset 0x160, total reset 0x0000_0000; PROVEN: Hi3535 data sheet, PDF page 695, section 4.1.8.2).";
        field {
            name = "reserved";
            desc = "Reserved.";
            sw = r; hw = w;
            reset = 0x0;
        } reserved_31_21[31:21];
        field {
            name = "ba1_bdl";
            desc = "Bit delay line setting for BA1.";
            sw = rw; hw = r;
            reset = 0x0;
        } ba1_bdl[20:16];
        field {
            name = "reserved";
            desc = "Reserved.";
            sw = r; hw = w;
            reset = 0x0;
        } reserved_15_5[15:5];
        field {
            name = "ba0_bdl";
            desc = "Bit delay line setting of BA0.";
            sw = rw; hw = r;
            reset = 0x0;
        } ba0_bdl[4:0];
    } PACK_ACADDRBDL8 @ 0x160;
    reg {
        name = "PACK_ACADDRBDL9";
        desc = "PACK_ACADDRBDL9 is AC address bit delay line configuration register 9. PACK_ACADDRBDL9 (offset 0x164, total reset 0x0000_0000; PROVEN: Hi3535 data sheet, PDF page 695, section 4.1.8.2).";
        field {
            name = "reserved";
            desc = "Reserved.";
            sw = r; hw = w;
            reset = 0x0;
        } reserved_31_5[31:5];
        field {
            name = "ba2_bdl";
            desc = "Bit delay line setting of BA2.";
            sw = rw; hw = r;
            reset = 0x0;
        } ba2_bdl[4:0];
    } PACK_ACADDRBDL9 @ 0x164;
    reg {
        name = "PACK_ACCLKBDL";
        desc = "PACK_ACCLKBDL is the AC clock bit delay line configuration register. PACK_ACCLKBDL (offset 0x168, total reset 0x0000_0000; PROVEN: Hi3535 data sheet, PDF page 695, section 4.1.8.2).";
        field {
            name = "reserved";
            desc = "Reserved.";
            sw = r; hw = w;
            reset = 0x0;
        } reserved_31_29[31:29];
        field {
            name = "fbclk_bdl";
            desc = "Bit delay line setting of FBCLK.";
            sw = rw; hw = r;
            reset = 0x0;
        } fbclk_bdl[28:24];
        field {
            name = "reserved";
            desc = "Reserved.";
            sw = r; hw = w;
            reset = 0x0;
        } reserved_23_21[23:21];
        field {
            name = "refclk_bdl";
            desc = "Bit delay line setting of REFCLK.";
            sw = rw; hw = r;
            reset = 0x0;
        } refclk_bdl[20:16];
        field {
            name = "reserved";
            desc = "Reserved.";
            sw = r; hw = w;
            reset = 0x0;
        } reserved_15_13[15:13];
        field {
            name = "dramclk1_bdl";
            desc = "Bit delay line setting of dramclk1.";
            sw = rw; hw = r;
            reset = 0x0;
        } dramclk1_bdl[12:8];
        field {
            name = "reserved";
            desc = "Reserved.";
            sw = r; hw = w;
            reset = 0x0;
        } reserved_7_5[7:5];
        field {
            name = "dramclk0_bdl";
            desc = "Bit delay line setting for dramclk0.";
            sw = rw; hw = r;
            reset = 0x0;
        } dramclk0_bdl[4:0];
    } PACK_ACCLKBDL @ 0x168;
    reg {
        name = "PACK_ACPHYCTL";
        desc = "PACK_ACPHYCTL is the AC block PHY control register. This register is used for PHY control and must not be modified. PACK_ACPHYCTL (offset 0x180, total reset 0x0000_0000; PROVEN: Hi3535 data sheet, PDF page 696, section 4.1.8.2).";
        field {
            name = "timing2t_addr";
            desc = "PHY control register.";
            sw = rw; hw = r;
            reset = 0x0;
        } timing2t_addr[31:16];
        field {
            name = "reserved";
            desc = "Reserved.";
            sw = r; hw = w;
            reset = 0x0;
        } reserved_15_11[15:11];
        field {
            name = "timing2t_ba";
            desc = "PHY control register.";
            sw = rw; hw = r;
            reset = 0x0;
        } timing2t_ba[10:8];
        field {
            name = "reserved";
            desc = "Reserved.";
            sw = r; hw = w;
            reset = 0x0;
        } reserved_7_7[7:7];
        field {
            name = "timing2t_we";
            desc = "PHY control register.";
            sw = rw; hw = r;
            reset = 0x0;
        } timing2t_we[6:6];
        field {
            name = "timing2t_cas";
            desc = "PHY control register.";
            sw = rw; hw = r;
            reset = 0x0;
        } timing2t_cas[5:5];
        field {
            name = "timing2t_ras";
            desc = "PHY control register.";
            sw = rw; hw = r;
            reset = 0x0;
        } timing2t_ras[4:4];
        field {
            name = "timing2t_odt";
            desc = "PHY control register.";
            sw = rw; hw = r;
            reset = 0x0;
        } timing2t_odt[3:3];
        field {
            name = "timing2t_cke";
            desc = "PHY control register.";
            sw = rw; hw = r;
            reset = 0x0;
        } timing2t_cke[2:2];
        field {
            name = "timing2t_cs";
            desc = "PHY control register.";
            sw = rw; hw = r;
            reset = 0x0;
        } timing2t_cs[1:1];
        field {
            name = "timing2t_reset";
            desc = "PHY control register.";
            sw = rw; hw = r;
            reset = 0x0;
        } timing2t_reset[0:0];
    } PACK_ACPHYCTL @ 0x180;
    reg {
        name = "PACK_DXNBISTCTRL";
        desc = "PACK_DXNBISTCTRL is the loopback data comparison control register for data block BIST testing. PACK_DXNBISTCTRL (offset 0x200 + n x 0x80 (n = 0-3), total reset 0x0000_0000; PROVEN: Hi3535 data sheet, PDF page 697, section 4.1.8.2).";
        field {
            name = "lfsr_seed";
            desc = "LFSR seed value. This field specifies the initial seed value of the LFSR generator for this byte lane.";
            sw = rw; hw = r;
            reset = 0x0;
        } lfsr_seed[31:24];
        field {
            name = "reserved";
            desc = "Reserved.";
            sw = r; hw = w;
            reset = 0x0;
        } reserved_23_17[23:17];
        field {
            name = "dqm_cmp_mask";
            desc = "DQM loopback compare mask. This field controls whether the loopback data of the DQM bits is compared.
- 0: Do not compare;
- 1: Compare.";
            sw = rw; hw = r;
            reset = 0x0;
        } dqm_cmp_mask[16:16];
        field {
            name = "dq_cmp_mask";
            desc = "DQ loopback compare mask. This field controls whether the loopback data of the DQ bits is compared.
- 0: Do not compare;
- 1: Compare.";
            sw = rw; hw = r;
            reset = 0x0;
        } dq_cmp_mask[15:8];
        field {
            name = "reserved";
            desc = "Reserved.";
            sw = r; hw = w;
            reset = 0x0;
        } reserved_7_1[7:1];
        field {
            name = "bist_en";
            desc = "BIST enable. This signal specifies whether the data block is used during the loopback test when bist_op is BIST enable.";
            sw = rw; hw = r;
            reset = 0x0;
        } bist_en[0:0];
    } PACK_DXNBISTCTRL_0 @ 0x200;
    reg {
        name = "PACK_DXNBISTCTRL";
        desc = "PACK_DXNBISTCTRL is the loopback data comparison control register for data block BIST testing. PACK_DXNBISTCTRL (offset 0x200 + n x 0x80 (n = 0-3), total reset 0x0000_0000; PROVEN: Hi3535 data sheet, PDF page 697, section 4.1.8.2).";
        field {
            name = "lfsr_seed";
            desc = "LFSR seed value. This field specifies the initial seed value of the LFSR generator for this byte lane.";
            sw = rw; hw = r;
            reset = 0x0;
        } lfsr_seed[31:24];
        field {
            name = "reserved";
            desc = "Reserved.";
            sw = r; hw = w;
            reset = 0x0;
        } reserved_23_17[23:17];
        field {
            name = "dqm_cmp_mask";
            desc = "DQM loopback compare mask. This field controls whether the loopback data of the DQM bits is compared.
- 0: Do not compare;
- 1: Compare.";
            sw = rw; hw = r;
            reset = 0x0;
        } dqm_cmp_mask[16:16];
        field {
            name = "dq_cmp_mask";
            desc = "DQ loopback compare mask. This field controls whether the loopback data of the DQ bits is compared.
- 0: Do not compare;
- 1: Compare.";
            sw = rw; hw = r;
            reset = 0x0;
        } dq_cmp_mask[15:8];
        field {
            name = "reserved";
            desc = "Reserved.";
            sw = r; hw = w;
            reset = 0x0;
        } reserved_7_1[7:1];
        field {
            name = "bist_en";
            desc = "BIST enable. This signal specifies whether the data block is used during the loopback test when bist_op is BIST enable.";
            sw = rw; hw = r;
            reset = 0x0;
        } bist_en[0:0];
    } PACK_DXNBISTCTRL_1 @ 0x280;
    reg {
        name = "PACK_DXNBISTCTRL";
        desc = "PACK_DXNBISTCTRL is the loopback data comparison control register for data block BIST testing. PACK_DXNBISTCTRL (offset 0x200 + n x 0x80 (n = 0-3), total reset 0x0000_0000; PROVEN: Hi3535 data sheet, PDF page 697, section 4.1.8.2).";
        field {
            name = "lfsr_seed";
            desc = "LFSR seed value. This field specifies the initial seed value of the LFSR generator for this byte lane.";
            sw = rw; hw = r;
            reset = 0x0;
        } lfsr_seed[31:24];
        field {
            name = "reserved";
            desc = "Reserved.";
            sw = r; hw = w;
            reset = 0x0;
        } reserved_23_17[23:17];
        field {
            name = "dqm_cmp_mask";
            desc = "DQM loopback compare mask. This field controls whether the loopback data of the DQM bits is compared.
- 0: Do not compare;
- 1: Compare.";
            sw = rw; hw = r;
            reset = 0x0;
        } dqm_cmp_mask[16:16];
        field {
            name = "dq_cmp_mask";
            desc = "DQ loopback compare mask. This field controls whether the loopback data of the DQ bits is compared.
- 0: Do not compare;
- 1: Compare.";
            sw = rw; hw = r;
            reset = 0x0;
        } dq_cmp_mask[15:8];
        field {
            name = "reserved";
            desc = "Reserved.";
            sw = r; hw = w;
            reset = 0x0;
        } reserved_7_1[7:1];
        field {
            name = "bist_en";
            desc = "BIST enable. This signal specifies whether the data block is used during the loopback test when bist_op is BIST enable.";
            sw = rw; hw = r;
            reset = 0x0;
        } bist_en[0:0];
    } PACK_DXNBISTCTRL_2 @ 0x300;
    reg {
        name = "PACK_DXNBISTCTRL";
        desc = "PACK_DXNBISTCTRL is the loopback data comparison control register for data block BIST testing. PACK_DXNBISTCTRL (offset 0x200 + n x 0x80 (n = 0-3), total reset 0x0000_0000; PROVEN: Hi3535 data sheet, PDF page 697, section 4.1.8.2).";
        field {
            name = "lfsr_seed";
            desc = "LFSR seed value. This field specifies the initial seed value of the LFSR generator for this byte lane.";
            sw = rw; hw = r;
            reset = 0x0;
        } lfsr_seed[31:24];
        field {
            name = "reserved";
            desc = "Reserved.";
            sw = r; hw = w;
            reset = 0x0;
        } reserved_23_17[23:17];
        field {
            name = "dqm_cmp_mask";
            desc = "DQM loopback compare mask. This field controls whether the loopback data of the DQM bits is compared.
- 0: Do not compare;
- 1: Compare.";
            sw = rw; hw = r;
            reset = 0x0;
        } dqm_cmp_mask[16:16];
        field {
            name = "dq_cmp_mask";
            desc = "DQ loopback compare mask. This field controls whether the loopback data of the DQ bits is compared.
- 0: Do not compare;
- 1: Compare.";
            sw = rw; hw = r;
            reset = 0x0;
        } dq_cmp_mask[15:8];
        field {
            name = "reserved";
            desc = "Reserved.";
            sw = r; hw = w;
            reset = 0x0;
        } reserved_7_1[7:1];
        field {
            name = "bist_en";
            desc = "BIST enable. This signal specifies whether the data block is used during the loopback test when bist_op is BIST enable.";
            sw = rw; hw = r;
            reset = 0x0;
        } bist_en[0:0];
    } PACK_DXNBISTCTRL_3 @ 0x380;
    reg {
        name = "PACK_DXNBIST_STATUS";
        desc = "PACK_DXNBIST_STATUS is the BIST test result and status register. This register is read-only and can be reset only by setting the bist_op bits to BIST reset. PACK_DXNBIST_STATUS (offset 0x204 + n x 0x80 (n = 0-3), total reset 0x0000_0000; PROVEN: Hi3535 data sheet, PDF page 698, section 4.1.8.2).";
        field {
            name = "reserved";
            desc = "Reserved.";
            sw = r; hw = w;
            reset = 0x0;
        } reserved_31_17[31:17];
        field {
            name = "dqm_cmp_err";
            desc = "BIST error of the DQM.";
            sw = r; hw = w;
            reset = 0x0;
        } dqm_cmp_err[16:16];
        field {
            name = "dq_cmp_ferr";
            desc = "BIST error of DQ on the falling edge of DQS.";
            sw = r; hw = w;
            reset = 0x0;
        } dq_cmp_ferr[15:8];
        field {
            name = "dq_cmp_rerr";
            desc = "BIST error of DQ on the DQS rising edge.";
            sw = r; hw = w;
            reset = 0x0;
        } dq_cmp_rerr[7:0];
    } PACK_DXNBIST_STATUS_0 @ 0x204;
    reg {
        name = "PACK_DXNBIST_STATUS";
        desc = "PACK_DXNBIST_STATUS is the BIST test result and status register. This register is read-only and can be reset only by setting the bist_op bits to BIST reset. PACK_DXNBIST_STATUS (offset 0x204 + n x 0x80 (n = 0-3), total reset 0x0000_0000; PROVEN: Hi3535 data sheet, PDF page 698, section 4.1.8.2).";
        field {
            name = "reserved";
            desc = "Reserved.";
            sw = r; hw = w;
            reset = 0x0;
        } reserved_31_17[31:17];
        field {
            name = "dqm_cmp_err";
            desc = "BIST error of the DQM.";
            sw = r; hw = w;
            reset = 0x0;
        } dqm_cmp_err[16:16];
        field {
            name = "dq_cmp_ferr";
            desc = "BIST error of DQ on the falling edge of DQS.";
            sw = r; hw = w;
            reset = 0x0;
        } dq_cmp_ferr[15:8];
        field {
            name = "dq_cmp_rerr";
            desc = "BIST error of DQ on the DQS rising edge.";
            sw = r; hw = w;
            reset = 0x0;
        } dq_cmp_rerr[7:0];
    } PACK_DXNBIST_STATUS_1 @ 0x284;
    reg {
        name = "PACK_DXNBIST_STATUS";
        desc = "PACK_DXNBIST_STATUS is the BIST test result and status register. This register is read-only and can be reset only by setting the bist_op bits to BIST reset. PACK_DXNBIST_STATUS (offset 0x204 + n x 0x80 (n = 0-3), total reset 0x0000_0000; PROVEN: Hi3535 data sheet, PDF page 698, section 4.1.8.2).";
        field {
            name = "reserved";
            desc = "Reserved.";
            sw = r; hw = w;
            reset = 0x0;
        } reserved_31_17[31:17];
        field {
            name = "dqm_cmp_err";
            desc = "BIST error of the DQM.";
            sw = r; hw = w;
            reset = 0x0;
        } dqm_cmp_err[16:16];
        field {
            name = "dq_cmp_ferr";
            desc = "BIST error of DQ on the falling edge of DQS.";
            sw = r; hw = w;
            reset = 0x0;
        } dq_cmp_ferr[15:8];
        field {
            name = "dq_cmp_rerr";
            desc = "BIST error of DQ on the DQS rising edge.";
            sw = r; hw = w;
            reset = 0x0;
        } dq_cmp_rerr[7:0];
    } PACK_DXNBIST_STATUS_2 @ 0x304;
    reg {
        name = "PACK_DXNBIST_STATUS";
        desc = "PACK_DXNBIST_STATUS is the BIST test result and status register. This register is read-only and can be reset only by setting the bist_op bits to BIST reset. PACK_DXNBIST_STATUS (offset 0x204 + n x 0x80 (n = 0-3), total reset 0x0000_0000; PROVEN: Hi3535 data sheet, PDF page 698, section 4.1.8.2).";
        field {
            name = "reserved";
            desc = "Reserved.";
            sw = r; hw = w;
            reset = 0x0;
        } reserved_31_17[31:17];
        field {
            name = "dqm_cmp_err";
            desc = "BIST error of the DQM.";
            sw = r; hw = w;
            reset = 0x0;
        } dqm_cmp_err[16:16];
        field {
            name = "dq_cmp_ferr";
            desc = "BIST error of DQ on the falling edge of DQS.";
            sw = r; hw = w;
            reset = 0x0;
        } dq_cmp_ferr[15:8];
        field {
            name = "dq_cmp_rerr";
            desc = "BIST error of DQ on the DQS rising edge.";
            sw = r; hw = w;
            reset = 0x0;
        } dq_cmp_rerr[7:0];
    } PACK_DXNBIST_STATUS_3 @ 0x384;
    reg {
        name = "PACK_DXNCTRL";
        desc = "PACK_DXNCTRL is the data block control register. PACK_DXNCTRL (offset 0x208 + n x 0x80 (n = 0-3), total reset 0x0000_0000; PROVEN: Hi3535 data sheet, PDF page 698, section 4.1.8.2).";
        field {
            name = "reserved";
            desc = "Reserved.";
            sw = r; hw = w;
            reset = 0x0;
        } reserved_31_2[31:2];
        field {
            name = "dm_dis";
            desc = "Data mask disable. This field specifies whether the corresponding write data mask (DM) is enabled. If this field is 1, the corresponding DM is not used or calibrated during training operations.";
            sw = rw; hw = r;
            reset = 0x0;
        } dm_dis[1:1];
        field {
            name = "bl_dis";
            desc = "Byte lane disable. This field indicates whether the corresponding byte lane is in use. If the corresponding byte lane is not used, its PLL/DDL is powered down and its output drivers are turned off.";
            sw = rw; hw = r;
            reset = 0x0;
        } bl_dis[0:0];
    } PACK_DXNCTRL_0 @ 0x208;
    reg {
        name = "PACK_DXNCTRL";
        desc = "PACK_DXNCTRL is the data block control register. PACK_DXNCTRL (offset 0x208 + n x 0x80 (n = 0-3), total reset 0x0000_0000; PROVEN: Hi3535 data sheet, PDF page 698, section 4.1.8.2).";
        field {
            name = "reserved";
            desc = "Reserved.";
            sw = r; hw = w;
            reset = 0x0;
        } reserved_31_2[31:2];
        field {
            name = "dm_dis";
            desc = "Data mask disable. This field specifies whether the corresponding write data mask (DM) is enabled. If this field is 1, the corresponding DM is not used or calibrated during training operations.";
            sw = rw; hw = r;
            reset = 0x0;
        } dm_dis[1:1];
        field {
            name = "bl_dis";
            desc = "Byte lane disable. This field indicates whether the corresponding byte lane is in use. If the corresponding byte lane is not used, its PLL/DDL is powered down and its output drivers are turned off.";
            sw = rw; hw = r;
            reset = 0x0;
        } bl_dis[0:0];
    } PACK_DXNCTRL_1 @ 0x288;
    reg {
        name = "PACK_DXNCTRL";
        desc = "PACK_DXNCTRL is the data block control register. PACK_DXNCTRL (offset 0x208 + n x 0x80 (n = 0-3), total reset 0x0000_0000; PROVEN: Hi3535 data sheet, PDF page 698, section 4.1.8.2).";
        field {
            name = "reserved";
            desc = "Reserved.";
            sw = r; hw = w;
            reset = 0x0;
        } reserved_31_2[31:2];
        field {
            name = "dm_dis";
            desc = "Data mask disable. This field specifies whether the corresponding write data mask (DM) is enabled. If this field is 1, the corresponding DM is not used or calibrated during training operations.";
            sw = rw; hw = r;
            reset = 0x0;
        } dm_dis[1:1];
        field {
            name = "bl_dis";
            desc = "Byte lane disable. This field indicates whether the corresponding byte lane is in use. If the corresponding byte lane is not used, its PLL/DDL is powered down and its output drivers are turned off.";
            sw = rw; hw = r;
            reset = 0x0;
        } bl_dis[0:0];
    } PACK_DXNCTRL_2 @ 0x308;
    reg {
        name = "PACK_DXNCTRL";
        desc = "PACK_DXNCTRL is the data block control register. PACK_DXNCTRL (offset 0x208 + n x 0x80 (n = 0-3), total reset 0x0000_0000; PROVEN: Hi3535 data sheet, PDF page 698, section 4.1.8.2).";
        field {
            name = "reserved";
            desc = "Reserved.";
            sw = r; hw = w;
            reset = 0x0;
        } reserved_31_2[31:2];
        field {
            name = "dm_dis";
            desc = "Data mask disable. This field specifies whether the corresponding write data mask (DM) is enabled. If this field is 1, the corresponding DM is not used or calibrated during training operations.";
            sw = rw; hw = r;
            reset = 0x0;
        } dm_dis[1:1];
        field {
            name = "bl_dis";
            desc = "Byte lane disable. This field indicates whether the corresponding byte lane is in use. If the corresponding byte lane is not used, its PLL/DDL is powered down and its output drivers are turned off.";
            sw = rw; hw = r;
            reset = 0x0;
        } bl_dis[0:0];
    } PACK_DXNCTRL_3 @ 0x388;
    reg {
        name = "PACK_DXNWDQBDL0";
        desc = "PACK_DXNWDQBDL0 is data block bit delay line control register 0. PACK_DXNWDQBDL0 (offset 0x210 + n x 0x80 (n = 0-3), total reset 0x0000_0000; PROVEN: Hi3535 data sheet, PDF page 699, section 4.1.8.2).";
        field {
            name = "reserved";
            desc = "Reserved.";
            sw = r; hw = w;
            reset = 0x0;
        } reserved_31_29[31:29];
        field {
            name = "wdq3bdl";
            desc = "WDQ 3 delay selection. This field specifies the delay value of the bit delay line on the DQ 3 write path.";
            sw = rw; hw = r;
            reset = 0x0;
        } wdq3bdl[28:24];
        field {
            name = "reserved";
            desc = "Reserved.";
            sw = r; hw = w;
            reset = 0x0;
        } reserved_23_21[23:21];
        field {
            name = "wdq2bdl";
            desc = "WDQ 2 delay select. This field specifies the delay value of the bit delay line on the DQ 2 write path.";
            sw = rw; hw = r;
            reset = 0x0;
        } wdq2bdl[20:16];
        field {
            name = "reserved";
            desc = "Reserved.";
            sw = r; hw = w;
            reset = 0x0;
        } reserved_15_13[15:13];
        field {
            name = "wdq1bdl";
            desc = "WDQ 1 delay select. This field specifies the delay value of the bit delay line on the DQ 1 write path.";
            sw = rw; hw = r;
            reset = 0x0;
        } wdq1bdl[12:8];
        field {
            name = "reserved";
            desc = "Reserved.";
            sw = r; hw = w;
            reset = 0x0;
        } reserved_7_5[7:5];
        field {
            name = "wdq0bdl";
            desc = "WDQ 0 delay selection. This field specifies the delay value of the bit delay line on the DQ 0 write path.";
            sw = rw; hw = r;
            reset = 0x0;
        } wdq0bdl[4:0];
    } PACK_DXNWDQBDL0_0 @ 0x210;
    reg {
        name = "PACK_DXNWDQBDL0";
        desc = "PACK_DXNWDQBDL0 is data block bit delay line control register 0. PACK_DXNWDQBDL0 (offset 0x210 + n x 0x80 (n = 0-3), total reset 0x0000_0000; PROVEN: Hi3535 data sheet, PDF page 699, section 4.1.8.2).";
        field {
            name = "reserved";
            desc = "Reserved.";
            sw = r; hw = w;
            reset = 0x0;
        } reserved_31_29[31:29];
        field {
            name = "wdq3bdl";
            desc = "WDQ 3 delay selection. This field specifies the delay value of the bit delay line on the DQ 3 write path.";
            sw = rw; hw = r;
            reset = 0x0;
        } wdq3bdl[28:24];
        field {
            name = "reserved";
            desc = "Reserved.";
            sw = r; hw = w;
            reset = 0x0;
        } reserved_23_21[23:21];
        field {
            name = "wdq2bdl";
            desc = "WDQ 2 delay select. This field specifies the delay value of the bit delay line on the DQ 2 write path.";
            sw = rw; hw = r;
            reset = 0x0;
        } wdq2bdl[20:16];
        field {
            name = "reserved";
            desc = "Reserved.";
            sw = r; hw = w;
            reset = 0x0;
        } reserved_15_13[15:13];
        field {
            name = "wdq1bdl";
            desc = "WDQ 1 delay select. This field specifies the delay value of the bit delay line on the DQ 1 write path.";
            sw = rw; hw = r;
            reset = 0x0;
        } wdq1bdl[12:8];
        field {
            name = "reserved";
            desc = "Reserved.";
            sw = r; hw = w;
            reset = 0x0;
        } reserved_7_5[7:5];
        field {
            name = "wdq0bdl";
            desc = "WDQ 0 delay selection. This field specifies the delay value of the bit delay line on the DQ 0 write path.";
            sw = rw; hw = r;
            reset = 0x0;
        } wdq0bdl[4:0];
    } PACK_DXNWDQBDL0_1 @ 0x290;
    reg {
        name = "PACK_DXNWDQBDL0";
        desc = "PACK_DXNWDQBDL0 is data block bit delay line control register 0. PACK_DXNWDQBDL0 (offset 0x210 + n x 0x80 (n = 0-3), total reset 0x0000_0000; PROVEN: Hi3535 data sheet, PDF page 699, section 4.1.8.2).";
        field {
            name = "reserved";
            desc = "Reserved.";
            sw = r; hw = w;
            reset = 0x0;
        } reserved_31_29[31:29];
        field {
            name = "wdq3bdl";
            desc = "WDQ 3 delay selection. This field specifies the delay value of the bit delay line on the DQ 3 write path.";
            sw = rw; hw = r;
            reset = 0x0;
        } wdq3bdl[28:24];
        field {
            name = "reserved";
            desc = "Reserved.";
            sw = r; hw = w;
            reset = 0x0;
        } reserved_23_21[23:21];
        field {
            name = "wdq2bdl";
            desc = "WDQ 2 delay select. This field specifies the delay value of the bit delay line on the DQ 2 write path.";
            sw = rw; hw = r;
            reset = 0x0;
        } wdq2bdl[20:16];
        field {
            name = "reserved";
            desc = "Reserved.";
            sw = r; hw = w;
            reset = 0x0;
        } reserved_15_13[15:13];
        field {
            name = "wdq1bdl";
            desc = "WDQ 1 delay select. This field specifies the delay value of the bit delay line on the DQ 1 write path.";
            sw = rw; hw = r;
            reset = 0x0;
        } wdq1bdl[12:8];
        field {
            name = "reserved";
            desc = "Reserved.";
            sw = r; hw = w;
            reset = 0x0;
        } reserved_7_5[7:5];
        field {
            name = "wdq0bdl";
            desc = "WDQ 0 delay selection. This field specifies the delay value of the bit delay line on the DQ 0 write path.";
            sw = rw; hw = r;
            reset = 0x0;
        } wdq0bdl[4:0];
    } PACK_DXNWDQBDL0_2 @ 0x310;
    reg {
        name = "PACK_DXNWDQBDL0";
        desc = "PACK_DXNWDQBDL0 is data block bit delay line control register 0. PACK_DXNWDQBDL0 (offset 0x210 + n x 0x80 (n = 0-3), total reset 0x0000_0000; PROVEN: Hi3535 data sheet, PDF page 699, section 4.1.8.2).";
        field {
            name = "reserved";
            desc = "Reserved.";
            sw = r; hw = w;
            reset = 0x0;
        } reserved_31_29[31:29];
        field {
            name = "wdq3bdl";
            desc = "WDQ 3 delay selection. This field specifies the delay value of the bit delay line on the DQ 3 write path.";
            sw = rw; hw = r;
            reset = 0x0;
        } wdq3bdl[28:24];
        field {
            name = "reserved";
            desc = "Reserved.";
            sw = r; hw = w;
            reset = 0x0;
        } reserved_23_21[23:21];
        field {
            name = "wdq2bdl";
            desc = "WDQ 2 delay select. This field specifies the delay value of the bit delay line on the DQ 2 write path.";
            sw = rw; hw = r;
            reset = 0x0;
        } wdq2bdl[20:16];
        field {
            name = "reserved";
            desc = "Reserved.";
            sw = r; hw = w;
            reset = 0x0;
        } reserved_15_13[15:13];
        field {
            name = "wdq1bdl";
            desc = "WDQ 1 delay select. This field specifies the delay value of the bit delay line on the DQ 1 write path.";
            sw = rw; hw = r;
            reset = 0x0;
        } wdq1bdl[12:8];
        field {
            name = "reserved";
            desc = "Reserved.";
            sw = r; hw = w;
            reset = 0x0;
        } reserved_7_5[7:5];
        field {
            name = "wdq0bdl";
            desc = "WDQ 0 delay selection. This field specifies the delay value of the bit delay line on the DQ 0 write path.";
            sw = rw; hw = r;
            reset = 0x0;
        } wdq0bdl[4:0];
    } PACK_DXNWDQBDL0_3 @ 0x390;
    reg {
        name = "PACK_DXNWDQBDL1";
        desc = "PACK_DXNWDQBDL1 is data block bit delay line control register 1. PACK_DXNWDQBDL1 (offset 0x214 + n x 0x80 (n = 0-3), total reset 0x0000_0000; PROVEN: Hi3535 data sheet, PDF page 700, section 4.1.8.2).";
        field {
            name = "reserved";
            desc = "Reserved.";
            sw = r; hw = w;
            reset = 0x0;
        } reserved_31_29[31:29];
        field {
            name = "wdq7bdl";
            desc = "WDQ 7 delay selection. This field specifies the delay value of the bit delay line on the DQ 3 write path.";
            sw = rw; hw = r;
            reset = 0x0;
        } wdq7bdl[28:24];
        field {
            name = "reserved";
            desc = "Reserved.";
            sw = r; hw = w;
            reset = 0x0;
        } reserved_23_21[23:21];
        field {
            name = "wdq6bdl";
            desc = "WDQ 6 delay select. This field specifies the delay value of the bit delay line on the DQ 2 write path.";
            sw = rw; hw = r;
            reset = 0x0;
        } wdq6bdl[20:16];
        field {
            name = "reserved";
            desc = "Reserved.";
            sw = r; hw = w;
            reset = 0x0;
        } reserved_15_13[15:13];
        field {
            name = "wdq5bdl";
            desc = "WDQ 5 delay select. This field specifies the delay value of the bit delay line on the DQ 1 write path.";
            sw = rw; hw = r;
            reset = 0x0;
        } wdq5bdl[12:8];
        field {
            name = "reserved";
            desc = "Reserved.";
            sw = r; hw = w;
            reset = 0x0;
        } reserved_7_5[7:5];
        field {
            name = "wdq4bdl";
            desc = "WDQ 4 delay select. This field specifies the delay value of the bit delay line on the DQ 0 write path.";
            sw = rw; hw = r;
            reset = 0x0;
        } wdq4bdl[4:0];
    } PACK_DXNWDQBDL1_0 @ 0x214;
    reg {
        name = "PACK_DXNWDQBDL1";
        desc = "PACK_DXNWDQBDL1 is data block bit delay line control register 1. PACK_DXNWDQBDL1 (offset 0x214 + n x 0x80 (n = 0-3), total reset 0x0000_0000; PROVEN: Hi3535 data sheet, PDF page 700, section 4.1.8.2).";
        field {
            name = "reserved";
            desc = "Reserved.";
            sw = r; hw = w;
            reset = 0x0;
        } reserved_31_29[31:29];
        field {
            name = "wdq7bdl";
            desc = "WDQ 7 delay selection. This field specifies the delay value of the bit delay line on the DQ 3 write path.";
            sw = rw; hw = r;
            reset = 0x0;
        } wdq7bdl[28:24];
        field {
            name = "reserved";
            desc = "Reserved.";
            sw = r; hw = w;
            reset = 0x0;
        } reserved_23_21[23:21];
        field {
            name = "wdq6bdl";
            desc = "WDQ 6 delay select. This field specifies the delay value of the bit delay line on the DQ 2 write path.";
            sw = rw; hw = r;
            reset = 0x0;
        } wdq6bdl[20:16];
        field {
            name = "reserved";
            desc = "Reserved.";
            sw = r; hw = w;
            reset = 0x0;
        } reserved_15_13[15:13];
        field {
            name = "wdq5bdl";
            desc = "WDQ 5 delay select. This field specifies the delay value of the bit delay line on the DQ 1 write path.";
            sw = rw; hw = r;
            reset = 0x0;
        } wdq5bdl[12:8];
        field {
            name = "reserved";
            desc = "Reserved.";
            sw = r; hw = w;
            reset = 0x0;
        } reserved_7_5[7:5];
        field {
            name = "wdq4bdl";
            desc = "WDQ 4 delay select. This field specifies the delay value of the bit delay line on the DQ 0 write path.";
            sw = rw; hw = r;
            reset = 0x0;
        } wdq4bdl[4:0];
    } PACK_DXNWDQBDL1_1 @ 0x294;
    reg {
        name = "PACK_DXNWDQBDL1";
        desc = "PACK_DXNWDQBDL1 is data block bit delay line control register 1. PACK_DXNWDQBDL1 (offset 0x214 + n x 0x80 (n = 0-3), total reset 0x0000_0000; PROVEN: Hi3535 data sheet, PDF page 700, section 4.1.8.2).";
        field {
            name = "reserved";
            desc = "Reserved.";
            sw = r; hw = w;
            reset = 0x0;
        } reserved_31_29[31:29];
        field {
            name = "wdq7bdl";
            desc = "WDQ 7 delay selection. This field specifies the delay value of the bit delay line on the DQ 3 write path.";
            sw = rw; hw = r;
            reset = 0x0;
        } wdq7bdl[28:24];
        field {
            name = "reserved";
            desc = "Reserved.";
            sw = r; hw = w;
            reset = 0x0;
        } reserved_23_21[23:21];
        field {
            name = "wdq6bdl";
            desc = "WDQ 6 delay select. This field specifies the delay value of the bit delay line on the DQ 2 write path.";
            sw = rw; hw = r;
            reset = 0x0;
        } wdq6bdl[20:16];
        field {
            name = "reserved";
            desc = "Reserved.";
            sw = r; hw = w;
            reset = 0x0;
        } reserved_15_13[15:13];
        field {
            name = "wdq5bdl";
            desc = "WDQ 5 delay select. This field specifies the delay value of the bit delay line on the DQ 1 write path.";
            sw = rw; hw = r;
            reset = 0x0;
        } wdq5bdl[12:8];
        field {
            name = "reserved";
            desc = "Reserved.";
            sw = r; hw = w;
            reset = 0x0;
        } reserved_7_5[7:5];
        field {
            name = "wdq4bdl";
            desc = "WDQ 4 delay select. This field specifies the delay value of the bit delay line on the DQ 0 write path.";
            sw = rw; hw = r;
            reset = 0x0;
        } wdq4bdl[4:0];
    } PACK_DXNWDQBDL1_2 @ 0x314;
    reg {
        name = "PACK_DXNWDQBDL1";
        desc = "PACK_DXNWDQBDL1 is data block bit delay line control register 1. PACK_DXNWDQBDL1 (offset 0x214 + n x 0x80 (n = 0-3), total reset 0x0000_0000; PROVEN: Hi3535 data sheet, PDF page 700, section 4.1.8.2).";
        field {
            name = "reserved";
            desc = "Reserved.";
            sw = r; hw = w;
            reset = 0x0;
        } reserved_31_29[31:29];
        field {
            name = "wdq7bdl";
            desc = "WDQ 7 delay selection. This field specifies the delay value of the bit delay line on the DQ 3 write path.";
            sw = rw; hw = r;
            reset = 0x0;
        } wdq7bdl[28:24];
        field {
            name = "reserved";
            desc = "Reserved.";
            sw = r; hw = w;
            reset = 0x0;
        } reserved_23_21[23:21];
        field {
            name = "wdq6bdl";
            desc = "WDQ 6 delay select. This field specifies the delay value of the bit delay line on the DQ 2 write path.";
            sw = rw; hw = r;
            reset = 0x0;
        } wdq6bdl[20:16];
        field {
            name = "reserved";
            desc = "Reserved.";
            sw = r; hw = w;
            reset = 0x0;
        } reserved_15_13[15:13];
        field {
            name = "wdq5bdl";
            desc = "WDQ 5 delay select. This field specifies the delay value of the bit delay line on the DQ 1 write path.";
            sw = rw; hw = r;
            reset = 0x0;
        } wdq5bdl[12:8];
        field {
            name = "reserved";
            desc = "Reserved.";
            sw = r; hw = w;
            reset = 0x0;
        } reserved_7_5[7:5];
        field {
            name = "wdq4bdl";
            desc = "WDQ 4 delay select. This field specifies the delay value of the bit delay line on the DQ 0 write path.";
            sw = rw; hw = r;
            reset = 0x0;
        } wdq4bdl[4:0];
    } PACK_DXNWDQBDL1_3 @ 0x394;
    reg {
        name = "PACK_DXNWDQBDL2";
        desc = "PACK_DXNWDQBDL2 is data block bit delay line control register 2. PACK_DXNWDQBDL2 (offset 0x218 + n x 0x80 (n = 0-3), total reset 0x0000_0000; PROVEN: Hi3535 data sheet, PDF page 701, section 4.1.8.2).";
        field {
            name = "reserved";
            desc = "Reserved.";
            sw = r; hw = w;
            reset = 0x0;
        } reserved_31_5[31:5];
        field {
            name = "wdmbdl";
            desc = "WDQM delay select. This field specifies the delay value of the bit delay line of DQM.";
            sw = rw; hw = r;
            reset = 0x0;
        } wdmbdl[4:0];
    } PACK_DXNWDQBDL2_0 @ 0x218;
    reg {
        name = "PACK_DXNWDQBDL2";
        desc = "PACK_DXNWDQBDL2 is data block bit delay line control register 2. PACK_DXNWDQBDL2 (offset 0x218 + n x 0x80 (n = 0-3), total reset 0x0000_0000; PROVEN: Hi3535 data sheet, PDF page 701, section 4.1.8.2).";
        field {
            name = "reserved";
            desc = "Reserved.";
            sw = r; hw = w;
            reset = 0x0;
        } reserved_31_5[31:5];
        field {
            name = "wdmbdl";
            desc = "WDQM delay select. This field specifies the delay value of the bit delay line of DQM.";
            sw = rw; hw = r;
            reset = 0x0;
        } wdmbdl[4:0];
    } PACK_DXNWDQBDL2_1 @ 0x298;
    reg {
        name = "PACK_DXNWDQBDL2";
        desc = "PACK_DXNWDQBDL2 is data block bit delay line control register 2. PACK_DXNWDQBDL2 (offset 0x218 + n x 0x80 (n = 0-3), total reset 0x0000_0000; PROVEN: Hi3535 data sheet, PDF page 701, section 4.1.8.2).";
        field {
            name = "reserved";
            desc = "Reserved.";
            sw = r; hw = w;
            reset = 0x0;
        } reserved_31_5[31:5];
        field {
            name = "wdmbdl";
            desc = "WDQM delay select. This field specifies the delay value of the bit delay line of DQM.";
            sw = rw; hw = r;
            reset = 0x0;
        } wdmbdl[4:0];
    } PACK_DXNWDQBDL2_2 @ 0x318;
    reg {
        name = "PACK_DXNWDQBDL2";
        desc = "PACK_DXNWDQBDL2 is data block bit delay line control register 2. PACK_DXNWDQBDL2 (offset 0x218 + n x 0x80 (n = 0-3), total reset 0x0000_0000; PROVEN: Hi3535 data sheet, PDF page 701, section 4.1.8.2).";
        field {
            name = "reserved";
            desc = "Reserved.";
            sw = r; hw = w;
            reset = 0x0;
        } reserved_31_5[31:5];
        field {
            name = "wdmbdl";
            desc = "WDQM delay select. This field specifies the delay value of the bit delay line of DQM.";
            sw = rw; hw = r;
            reset = 0x0;
        } wdmbdl[4:0];
    } PACK_DXNWDQBDL2_3 @ 0x398;
    reg {
        name = "PACK_DXNRDQBDL0";
        desc = "PACK_DXNRDQBDL0 is data block bit delay line control register 3. PACK_DXNRDQBDL0 (offset 0x21C + n x 0x80 (n = 0-3), total reset 0x0000_0000; PROVEN: Hi3535 data sheet, PDF page 701, section 4.1.8.2).";
        field {
            name = "reserved";
            desc = "Reserved.";
            sw = r; hw = w;
            reset = 0x0;
        } reserved_31_29[31:29];
        field {
            name = "rdq3bdl";
            desc = "RDQ 3 delay selection. This field specifies the delay value of the bit delay line on the DQ 3 write path.";
            sw = rw; hw = r;
            reset = 0x0;
        } rdq3bdl[28:24];
        field {
            name = "reserved";
            desc = "Reserved.";
            sw = r; hw = w;
            reset = 0x0;
        } reserved_23_21[23:21];
        field {
            name = "rdq2bdl";
            desc = "RDQ 2 delay select. This field specifies the delay value of the bit delay line on the DQ 2 write path.";
            sw = rw; hw = r;
            reset = 0x0;
        } rdq2bdl[20:16];
        field {
            name = "reserved";
            desc = "Reserved.";
            sw = r; hw = w;
            reset = 0x0;
        } reserved_15_13[15:13];
        field {
            name = "rdq1bdl";
            desc = "RDQ 1 delay select. This field specifies the delay value of the bit delay line on the DQ 1 write path.";
            sw = rw; hw = r;
            reset = 0x0;
        } rdq1bdl[12:8];
        field {
            name = "reserved";
            desc = "Reserved.";
            sw = r; hw = w;
            reset = 0x0;
        } reserved_7_5[7:5];
        field {
            name = "rdq0bdl";
            desc = "RDQ 0 delay select. This field specifies the delay value of the bit delay line on the DQ 0 write path.";
            sw = rw; hw = r;
            reset = 0x0;
        } rdq0bdl[4:0];
    } PACK_DXNRDQBDL0_0 @ 0x21c;
    reg {
        name = "PACK_DXNRDQBDL0";
        desc = "PACK_DXNRDQBDL0 is data block bit delay line control register 3. PACK_DXNRDQBDL0 (offset 0x21C + n x 0x80 (n = 0-3), total reset 0x0000_0000; PROVEN: Hi3535 data sheet, PDF page 701, section 4.1.8.2).";
        field {
            name = "reserved";
            desc = "Reserved.";
            sw = r; hw = w;
            reset = 0x0;
        } reserved_31_29[31:29];
        field {
            name = "rdq3bdl";
            desc = "RDQ 3 delay selection. This field specifies the delay value of the bit delay line on the DQ 3 write path.";
            sw = rw; hw = r;
            reset = 0x0;
        } rdq3bdl[28:24];
        field {
            name = "reserved";
            desc = "Reserved.";
            sw = r; hw = w;
            reset = 0x0;
        } reserved_23_21[23:21];
        field {
            name = "rdq2bdl";
            desc = "RDQ 2 delay select. This field specifies the delay value of the bit delay line on the DQ 2 write path.";
            sw = rw; hw = r;
            reset = 0x0;
        } rdq2bdl[20:16];
        field {
            name = "reserved";
            desc = "Reserved.";
            sw = r; hw = w;
            reset = 0x0;
        } reserved_15_13[15:13];
        field {
            name = "rdq1bdl";
            desc = "RDQ 1 delay select. This field specifies the delay value of the bit delay line on the DQ 1 write path.";
            sw = rw; hw = r;
            reset = 0x0;
        } rdq1bdl[12:8];
        field {
            name = "reserved";
            desc = "Reserved.";
            sw = r; hw = w;
            reset = 0x0;
        } reserved_7_5[7:5];
        field {
            name = "rdq0bdl";
            desc = "RDQ 0 delay select. This field specifies the delay value of the bit delay line on the DQ 0 write path.";
            sw = rw; hw = r;
            reset = 0x0;
        } rdq0bdl[4:0];
    } PACK_DXNRDQBDL0_1 @ 0x29c;
    reg {
        name = "PACK_DXNRDQBDL0";
        desc = "PACK_DXNRDQBDL0 is data block bit delay line control register 3. PACK_DXNRDQBDL0 (offset 0x21C + n x 0x80 (n = 0-3), total reset 0x0000_0000; PROVEN: Hi3535 data sheet, PDF page 701, section 4.1.8.2).";
        field {
            name = "reserved";
            desc = "Reserved.";
            sw = r; hw = w;
            reset = 0x0;
        } reserved_31_29[31:29];
        field {
            name = "rdq3bdl";
            desc = "RDQ 3 delay selection. This field specifies the delay value of the bit delay line on the DQ 3 write path.";
            sw = rw; hw = r;
            reset = 0x0;
        } rdq3bdl[28:24];
        field {
            name = "reserved";
            desc = "Reserved.";
            sw = r; hw = w;
            reset = 0x0;
        } reserved_23_21[23:21];
        field {
            name = "rdq2bdl";
            desc = "RDQ 2 delay select. This field specifies the delay value of the bit delay line on the DQ 2 write path.";
            sw = rw; hw = r;
            reset = 0x0;
        } rdq2bdl[20:16];
        field {
            name = "reserved";
            desc = "Reserved.";
            sw = r; hw = w;
            reset = 0x0;
        } reserved_15_13[15:13];
        field {
            name = "rdq1bdl";
            desc = "RDQ 1 delay select. This field specifies the delay value of the bit delay line on the DQ 1 write path.";
            sw = rw; hw = r;
            reset = 0x0;
        } rdq1bdl[12:8];
        field {
            name = "reserved";
            desc = "Reserved.";
            sw = r; hw = w;
            reset = 0x0;
        } reserved_7_5[7:5];
        field {
            name = "rdq0bdl";
            desc = "RDQ 0 delay select. This field specifies the delay value of the bit delay line on the DQ 0 write path.";
            sw = rw; hw = r;
            reset = 0x0;
        } rdq0bdl[4:0];
    } PACK_DXNRDQBDL0_2 @ 0x31c;
    reg {
        name = "PACK_DXNRDQBDL0";
        desc = "PACK_DXNRDQBDL0 is data block bit delay line control register 3. PACK_DXNRDQBDL0 (offset 0x21C + n x 0x80 (n = 0-3), total reset 0x0000_0000; PROVEN: Hi3535 data sheet, PDF page 701, section 4.1.8.2).";
        field {
            name = "reserved";
            desc = "Reserved.";
            sw = r; hw = w;
            reset = 0x0;
        } reserved_31_29[31:29];
        field {
            name = "rdq3bdl";
            desc = "RDQ 3 delay selection. This field specifies the delay value of the bit delay line on the DQ 3 write path.";
            sw = rw; hw = r;
            reset = 0x0;
        } rdq3bdl[28:24];
        field {
            name = "reserved";
            desc = "Reserved.";
            sw = r; hw = w;
            reset = 0x0;
        } reserved_23_21[23:21];
        field {
            name = "rdq2bdl";
            desc = "RDQ 2 delay select. This field specifies the delay value of the bit delay line on the DQ 2 write path.";
            sw = rw; hw = r;
            reset = 0x0;
        } rdq2bdl[20:16];
        field {
            name = "reserved";
            desc = "Reserved.";
            sw = r; hw = w;
            reset = 0x0;
        } reserved_15_13[15:13];
        field {
            name = "rdq1bdl";
            desc = "RDQ 1 delay select. This field specifies the delay value of the bit delay line on the DQ 1 write path.";
            sw = rw; hw = r;
            reset = 0x0;
        } rdq1bdl[12:8];
        field {
            name = "reserved";
            desc = "Reserved.";
            sw = r; hw = w;
            reset = 0x0;
        } reserved_7_5[7:5];
        field {
            name = "rdq0bdl";
            desc = "RDQ 0 delay select. This field specifies the delay value of the bit delay line on the DQ 0 write path.";
            sw = rw; hw = r;
            reset = 0x0;
        } rdq0bdl[4:0];
    } PACK_DXNRDQBDL0_3 @ 0x39c;
    reg {
        name = "PACK_DXNRDQBDL1";
        desc = "PACK_DXNRDQBDL1 is data block bit delay line control register 4. PACK_DXNRDQBDL1 (offset 0x220 + n x 0x80 (n = 0-3), total reset 0x0000_0000; PROVEN: Hi3535 data sheet, PDF page 702, section 4.1.8.2).";
        field {
            name = "reserved";
            desc = "Reserved.";
            sw = r; hw = w;
            reset = 0x0;
        } reserved_31_29[31:29];
        field {
            name = "rdq7bdl";
            desc = "RDQ 7 delay selection. This field specifies the delay value of the bit delay line on the DQ 3 write path.";
            sw = rw; hw = r;
            reset = 0x0;
        } rdq7bdl[28:24];
        field {
            name = "reserved";
            desc = "Reserved.";
            sw = r; hw = w;
            reset = 0x0;
        } reserved_23_21[23:21];
        field {
            name = "rdq6bdl";
            desc = "RDQ 6 delay select. This field specifies the delay value of the bit delay line on the DQ 2 write path.";
            sw = rw; hw = r;
            reset = 0x0;
        } rdq6bdl[20:16];
        field {
            name = "reserved";
            desc = "Reserved.";
            sw = r; hw = w;
            reset = 0x0;
        } reserved_15_13[15:13];
        field {
            name = "rdq5bdl";
            desc = "RDQ 5 delay select. This field specifies the delay value of the bit delay line on the DQ 1 write path.";
            sw = rw; hw = r;
            reset = 0x0;
        } rdq5bdl[12:8];
        field {
            name = "reserved";
            desc = "Reserved.";
            sw = r; hw = w;
            reset = 0x0;
        } reserved_7_5[7:5];
        field {
            name = "rdq4bdl";
            desc = "RDQ 4 delay select. This field specifies the delay value of the bit delay line on the DQ 0 write path.";
            sw = rw; hw = r;
            reset = 0x0;
        } rdq4bdl[4:0];
    } PACK_DXNRDQBDL1_0 @ 0x220;
    reg {
        name = "PACK_DXNRDQBDL1";
        desc = "PACK_DXNRDQBDL1 is data block bit delay line control register 4. PACK_DXNRDQBDL1 (offset 0x220 + n x 0x80 (n = 0-3), total reset 0x0000_0000; PROVEN: Hi3535 data sheet, PDF page 702, section 4.1.8.2).";
        field {
            name = "reserved";
            desc = "Reserved.";
            sw = r; hw = w;
            reset = 0x0;
        } reserved_31_29[31:29];
        field {
            name = "rdq7bdl";
            desc = "RDQ 7 delay selection. This field specifies the delay value of the bit delay line on the DQ 3 write path.";
            sw = rw; hw = r;
            reset = 0x0;
        } rdq7bdl[28:24];
        field {
            name = "reserved";
            desc = "Reserved.";
            sw = r; hw = w;
            reset = 0x0;
        } reserved_23_21[23:21];
        field {
            name = "rdq6bdl";
            desc = "RDQ 6 delay select. This field specifies the delay value of the bit delay line on the DQ 2 write path.";
            sw = rw; hw = r;
            reset = 0x0;
        } rdq6bdl[20:16];
        field {
            name = "reserved";
            desc = "Reserved.";
            sw = r; hw = w;
            reset = 0x0;
        } reserved_15_13[15:13];
        field {
            name = "rdq5bdl";
            desc = "RDQ 5 delay select. This field specifies the delay value of the bit delay line on the DQ 1 write path.";
            sw = rw; hw = r;
            reset = 0x0;
        } rdq5bdl[12:8];
        field {
            name = "reserved";
            desc = "Reserved.";
            sw = r; hw = w;
            reset = 0x0;
        } reserved_7_5[7:5];
        field {
            name = "rdq4bdl";
            desc = "RDQ 4 delay select. This field specifies the delay value of the bit delay line on the DQ 0 write path.";
            sw = rw; hw = r;
            reset = 0x0;
        } rdq4bdl[4:0];
    } PACK_DXNRDQBDL1_1 @ 0x2a0;
    reg {
        name = "PACK_DXNRDQBDL1";
        desc = "PACK_DXNRDQBDL1 is data block bit delay line control register 4. PACK_DXNRDQBDL1 (offset 0x220 + n x 0x80 (n = 0-3), total reset 0x0000_0000; PROVEN: Hi3535 data sheet, PDF page 702, section 4.1.8.2).";
        field {
            name = "reserved";
            desc = "Reserved.";
            sw = r; hw = w;
            reset = 0x0;
        } reserved_31_29[31:29];
        field {
            name = "rdq7bdl";
            desc = "RDQ 7 delay selection. This field specifies the delay value of the bit delay line on the DQ 3 write path.";
            sw = rw; hw = r;
            reset = 0x0;
        } rdq7bdl[28:24];
        field {
            name = "reserved";
            desc = "Reserved.";
            sw = r; hw = w;
            reset = 0x0;
        } reserved_23_21[23:21];
        field {
            name = "rdq6bdl";
            desc = "RDQ 6 delay select. This field specifies the delay value of the bit delay line on the DQ 2 write path.";
            sw = rw; hw = r;
            reset = 0x0;
        } rdq6bdl[20:16];
        field {
            name = "reserved";
            desc = "Reserved.";
            sw = r; hw = w;
            reset = 0x0;
        } reserved_15_13[15:13];
        field {
            name = "rdq5bdl";
            desc = "RDQ 5 delay select. This field specifies the delay value of the bit delay line on the DQ 1 write path.";
            sw = rw; hw = r;
            reset = 0x0;
        } rdq5bdl[12:8];
        field {
            name = "reserved";
            desc = "Reserved.";
            sw = r; hw = w;
            reset = 0x0;
        } reserved_7_5[7:5];
        field {
            name = "rdq4bdl";
            desc = "RDQ 4 delay select. This field specifies the delay value of the bit delay line on the DQ 0 write path.";
            sw = rw; hw = r;
            reset = 0x0;
        } rdq4bdl[4:0];
    } PACK_DXNRDQBDL1_2 @ 0x320;
    reg {
        name = "PACK_DXNRDQBDL1";
        desc = "PACK_DXNRDQBDL1 is data block bit delay line control register 4. PACK_DXNRDQBDL1 (offset 0x220 + n x 0x80 (n = 0-3), total reset 0x0000_0000; PROVEN: Hi3535 data sheet, PDF page 702, section 4.1.8.2).";
        field {
            name = "reserved";
            desc = "Reserved.";
            sw = r; hw = w;
            reset = 0x0;
        } reserved_31_29[31:29];
        field {
            name = "rdq7bdl";
            desc = "RDQ 7 delay selection. This field specifies the delay value of the bit delay line on the DQ 3 write path.";
            sw = rw; hw = r;
            reset = 0x0;
        } rdq7bdl[28:24];
        field {
            name = "reserved";
            desc = "Reserved.";
            sw = r; hw = w;
            reset = 0x0;
        } reserved_23_21[23:21];
        field {
            name = "rdq6bdl";
            desc = "RDQ 6 delay select. This field specifies the delay value of the bit delay line on the DQ 2 write path.";
            sw = rw; hw = r;
            reset = 0x0;
        } rdq6bdl[20:16];
        field {
            name = "reserved";
            desc = "Reserved.";
            sw = r; hw = w;
            reset = 0x0;
        } reserved_15_13[15:13];
        field {
            name = "rdq5bdl";
            desc = "RDQ 5 delay select. This field specifies the delay value of the bit delay line on the DQ 1 write path.";
            sw = rw; hw = r;
            reset = 0x0;
        } rdq5bdl[12:8];
        field {
            name = "reserved";
            desc = "Reserved.";
            sw = r; hw = w;
            reset = 0x0;
        } reserved_7_5[7:5];
        field {
            name = "rdq4bdl";
            desc = "RDQ 4 delay select. This field specifies the delay value of the bit delay line on the DQ 0 write path.";
            sw = rw; hw = r;
            reset = 0x0;
        } rdq4bdl[4:0];
    } PACK_DXNRDQBDL1_3 @ 0x3a0;
    reg {
        name = "PACK_DXNRDQBDL2";
        desc = "PACK_DXNRDQBDL2 is data block bit delay line control register 5. PACK_DXNRDQBDL2 (offset 0x224 + n x 0x80 (n = 0-3), total reset 0x0000_0000; PROVEN: Hi3535 data sheet, PDF page 703, section 4.1.8.2).";
        field {
            name = "reserved";
            desc = "Reserved.";
            sw = r; hw = w;
            reset = 0x0;
        } reserved_31_5[31:5];
        field {
            name = "rdmbdl";
            desc = "RDQM delay select. This field specifies the delay value of the bit delay line on the DQM loopback read path.";
            sw = rw; hw = r;
            reset = 0x0;
        } rdmbdl[4:0];
    } PACK_DXNRDQBDL2_0 @ 0x224;
    reg {
        name = "PACK_DXNRDQBDL2";
        desc = "PACK_DXNRDQBDL2 is data block bit delay line control register 5. PACK_DXNRDQBDL2 (offset 0x224 + n x 0x80 (n = 0-3), total reset 0x0000_0000; PROVEN: Hi3535 data sheet, PDF page 703, section 4.1.8.2).";
        field {
            name = "reserved";
            desc = "Reserved.";
            sw = r; hw = w;
            reset = 0x0;
        } reserved_31_5[31:5];
        field {
            name = "rdmbdl";
            desc = "RDQM delay select. This field specifies the delay value of the bit delay line on the DQM loopback read path.";
            sw = rw; hw = r;
            reset = 0x0;
        } rdmbdl[4:0];
    } PACK_DXNRDQBDL2_1 @ 0x2a4;
    reg {
        name = "PACK_DXNRDQBDL2";
        desc = "PACK_DXNRDQBDL2 is data block bit delay line control register 5. PACK_DXNRDQBDL2 (offset 0x224 + n x 0x80 (n = 0-3), total reset 0x0000_0000; PROVEN: Hi3535 data sheet, PDF page 703, section 4.1.8.2).";
        field {
            name = "reserved";
            desc = "Reserved.";
            sw = r; hw = w;
            reset = 0x0;
        } reserved_31_5[31:5];
        field {
            name = "rdmbdl";
            desc = "RDQM delay select. This field specifies the delay value of the bit delay line on the DQM loopback read path.";
            sw = rw; hw = r;
            reset = 0x0;
        } rdmbdl[4:0];
    } PACK_DXNRDQBDL2_2 @ 0x324;
    reg {
        name = "PACK_DXNRDQBDL2";
        desc = "PACK_DXNRDQBDL2 is data block bit delay line control register 5. PACK_DXNRDQBDL2 (offset 0x224 + n x 0x80 (n = 0-3), total reset 0x0000_0000; PROVEN: Hi3535 data sheet, PDF page 703, section 4.1.8.2).";
        field {
            name = "reserved";
            desc = "Reserved.";
            sw = r; hw = w;
            reset = 0x0;
        } reserved_31_5[31:5];
        field {
            name = "rdmbdl";
            desc = "RDQM delay select. This field specifies the delay value of the bit delay line on the DQM loopback read path.";
            sw = rw; hw = r;
            reset = 0x0;
        } rdmbdl[4:0];
    } PACK_DXNRDQBDL2_3 @ 0x3a4;
    reg {
        name = "PACK_DXNRDQSDLY";
        desc = "PACK_DXNRDQSDLY is the local delay line control register. PACK_DXNRDQSDLY (offset 0x22C + n x 0x80 (n = 0-3), total reset 0x0000_0000; PROVEN: Hi3535 data sheet, PDF page 703, section 4.1.8.2).";
        field {
            name = "reserved";
            desc = "Reserved.";
            sw = r; hw = w;
            reset = 0x0;
        } reserved_31_23[31:23];
        field {
            name = "rdqs_cyc";
            desc = "Read DQS clock phase select. This field specifies the phase offset of the read DQS to obtain a 90-degree delay.";
            sw = rw; hw = r;
            reset = 0x0;
        } rdqs_cyc[22:16];
        field {
            name = "reserved";
            desc = "Reserved.";
            sw = r; hw = w;
            reset = 0x0;
        } reserved_15_7[15:7];
        field {
            name = "rdqs_bdl";
            desc = "Read DQS delay select. This field specifies the phase offset of the read DQS to obtain a 90-degree delay.";
            sw = rw; hw = r;
            reset = 0x0;
        } rdqs_bdl[6:0];
    } PACK_DXNRDQSDLY_0 @ 0x22c;
    reg {
        name = "PACK_DXNRDQSDLY";
        desc = "PACK_DXNRDQSDLY is the local delay line control register. PACK_DXNRDQSDLY (offset 0x22C + n x 0x80 (n = 0-3), total reset 0x0000_0000; PROVEN: Hi3535 data sheet, PDF page 703, section 4.1.8.2).";
        field {
            name = "reserved";
            desc = "Reserved.";
            sw = r; hw = w;
            reset = 0x0;
        } reserved_31_23[31:23];
        field {
            name = "rdqs_cyc";
            desc = "Read DQS clock phase select. This field specifies the phase offset of the read DQS to obtain a 90-degree delay.";
            sw = rw; hw = r;
            reset = 0x0;
        } rdqs_cyc[22:16];
        field {
            name = "reserved";
            desc = "Reserved.";
            sw = r; hw = w;
            reset = 0x0;
        } reserved_15_7[15:7];
        field {
            name = "rdqs_bdl";
            desc = "Read DQS delay select. This field specifies the phase offset of the read DQS to obtain a 90-degree delay.";
            sw = rw; hw = r;
            reset = 0x0;
        } rdqs_bdl[6:0];
    } PACK_DXNRDQSDLY_1 @ 0x2ac;
    reg {
        name = "PACK_DXNRDQSDLY";
        desc = "PACK_DXNRDQSDLY is the local delay line control register. PACK_DXNRDQSDLY (offset 0x22C + n x 0x80 (n = 0-3), total reset 0x0000_0000; PROVEN: Hi3535 data sheet, PDF page 703, section 4.1.8.2).";
        field {
            name = "reserved";
            desc = "Reserved.";
            sw = r; hw = w;
            reset = 0x0;
        } reserved_31_23[31:23];
        field {
            name = "rdqs_cyc";
            desc = "Read DQS clock phase select. This field specifies the phase offset of the read DQS to obtain a 90-degree delay.";
            sw = rw; hw = r;
            reset = 0x0;
        } rdqs_cyc[22:16];
        field {
            name = "reserved";
            desc = "Reserved.";
            sw = r; hw = w;
            reset = 0x0;
        } reserved_15_7[15:7];
        field {
            name = "rdqs_bdl";
            desc = "Read DQS delay select. This field specifies the phase offset of the read DQS to obtain a 90-degree delay.";
            sw = rw; hw = r;
            reset = 0x0;
        } rdqs_bdl[6:0];
    } PACK_DXNRDQSDLY_2 @ 0x32c;
    reg {
        name = "PACK_DXNRDQSDLY";
        desc = "PACK_DXNRDQSDLY is the local delay line control register. PACK_DXNRDQSDLY (offset 0x22C + n x 0x80 (n = 0-3), total reset 0x0000_0000; PROVEN: Hi3535 data sheet, PDF page 703, section 4.1.8.2).";
        field {
            name = "reserved";
            desc = "Reserved.";
            sw = r; hw = w;
            reset = 0x0;
        } reserved_31_23[31:23];
        field {
            name = "rdqs_cyc";
            desc = "Read DQS clock phase select. This field specifies the phase offset of the read DQS to obtain a 90-degree delay.";
            sw = rw; hw = r;
            reset = 0x0;
        } rdqs_cyc[22:16];
        field {
            name = "reserved";
            desc = "Reserved.";
            sw = r; hw = w;
            reset = 0x0;
        } reserved_15_7[15:7];
        field {
            name = "rdqs_bdl";
            desc = "Read DQS delay select. This field specifies the phase offset of the read DQS to obtain a 90-degree delay.";
            sw = rw; hw = r;
            reset = 0x0;
        } rdqs_bdl[6:0];
    } PACK_DXNRDQSDLY_3 @ 0x3ac;
    reg {
        name = "PACK_DXWDQSDLY";
        desc = "PACK_DXWDQSDLY is the write leveling DQS delay control register. PACK_DXWDQSDLY (offset 0x230 + n x 0x80 (n = 0-3), total reset 0x0000_0000; PROVEN: Hi3535 data sheet, PDF page 704, section 4.1.8.2).";
        field {
            name = "reserved";
            desc = "Reserved.";
            sw = r; hw = w;
            reset = 0x0;
        } reserved_31_12[31:12];
        field {
            name = "wdqs_phase";
            desc = "Write DQS clock phase selection.";
            sw = rw; hw = r;
            reset = 0x0;
        } wdqs_phase[11:8];
        field {
            name = "reserved";
            desc = "Reserved.";
            sw = r; hw = w;
            reset = 0x0;
        } reserved_7_5[7:5];
        field {
            name = "wdqs_bdl";
            desc = "Write leveling DQS delay select. This field specifies the delay value used for WDQS write leveling.";
            sw = rw; hw = r;
            reset = 0x0;
        } wdqs_bdl[4:0];
    } PACK_DXWDQSDLY_0 @ 0x230;
    reg {
        name = "PACK_DXWDQSDLY";
        desc = "PACK_DXWDQSDLY is the write leveling DQS delay control register. PACK_DXWDQSDLY (offset 0x230 + n x 0x80 (n = 0-3), total reset 0x0000_0000; PROVEN: Hi3535 data sheet, PDF page 704, section 4.1.8.2).";
        field {
            name = "reserved";
            desc = "Reserved.";
            sw = r; hw = w;
            reset = 0x0;
        } reserved_31_12[31:12];
        field {
            name = "wdqs_phase";
            desc = "Write DQS clock phase selection.";
            sw = rw; hw = r;
            reset = 0x0;
        } wdqs_phase[11:8];
        field {
            name = "reserved";
            desc = "Reserved.";
            sw = r; hw = w;
            reset = 0x0;
        } reserved_7_5[7:5];
        field {
            name = "wdqs_bdl";
            desc = "Write leveling DQS delay select. This field specifies the delay value used for WDQS write leveling.";
            sw = rw; hw = r;
            reset = 0x0;
        } wdqs_bdl[4:0];
    } PACK_DXWDQSDLY_1 @ 0x2b0;
    reg {
        name = "PACK_DXWDQSDLY";
        desc = "PACK_DXWDQSDLY is the write leveling DQS delay control register. PACK_DXWDQSDLY (offset 0x230 + n x 0x80 (n = 0-3), total reset 0x0000_0000; PROVEN: Hi3535 data sheet, PDF page 704, section 4.1.8.2).";
        field {
            name = "reserved";
            desc = "Reserved.";
            sw = r; hw = w;
            reset = 0x0;
        } reserved_31_12[31:12];
        field {
            name = "wdqs_phase";
            desc = "Write DQS clock phase selection.";
            sw = rw; hw = r;
            reset = 0x0;
        } wdqs_phase[11:8];
        field {
            name = "reserved";
            desc = "Reserved.";
            sw = r; hw = w;
            reset = 0x0;
        } reserved_7_5[7:5];
        field {
            name = "wdqs_bdl";
            desc = "Write leveling DQS delay select. This field specifies the delay value used for WDQS write leveling.";
            sw = rw; hw = r;
            reset = 0x0;
        } wdqs_bdl[4:0];
    } PACK_DXWDQSDLY_2 @ 0x330;
    reg {
        name = "PACK_DXWDQSDLY";
        desc = "PACK_DXWDQSDLY is the write leveling DQS delay control register. PACK_DXWDQSDLY (offset 0x230 + n x 0x80 (n = 0-3), total reset 0x0000_0000; PROVEN: Hi3535 data sheet, PDF page 704, section 4.1.8.2).";
        field {
            name = "reserved";
            desc = "Reserved.";
            sw = r; hw = w;
            reset = 0x0;
        } reserved_31_12[31:12];
        field {
            name = "wdqs_phase";
            desc = "Write DQS clock phase selection.";
            sw = rw; hw = r;
            reset = 0x0;
        } wdqs_phase[11:8];
        field {
            name = "reserved";
            desc = "Reserved.";
            sw = r; hw = w;
            reset = 0x0;
        } reserved_7_5[7:5];
        field {
            name = "wdqs_bdl";
            desc = "Write leveling DQS delay select. This field specifies the delay value used for WDQS write leveling.";
            sw = rw; hw = r;
            reset = 0x0;
        } wdqs_bdl[4:0];
    } PACK_DXWDQSDLY_3 @ 0x3b0;
    reg {
        name = "PACK_DXNWDQDLY";
        desc = "PACK_DXNWDQDLY is the write leveling delay control register. PACK_DXNWDQDLY (offset 0x234 + n x 0x80 (n = 0-3), total reset 0x0000_0C00; PROVEN: Hi3535 data sheet, PDF page 704, section 4.1.8.2).";
        field {
            name = "reserved";
            desc = "Reserved.";
            sw = r; hw = w;
            reset = 0x0;
        } reserved_31_13[31:13];
        field {
            name = "wdq_phase";
            desc = "Write data eye clock phase select.";
            sw = rw; hw = r;
            reset = 0xc;
        } wdq_phase[12:8];
        field {
            name = "reserved";
            desc = "Reserved.";
            sw = r; hw = w;
            reset = 0x0;
        } reserved_7_0[7:0];
    } PACK_DXNWDQDLY_0 @ 0x234;
    reg {
        name = "PACK_DXNWDQDLY";
        desc = "PACK_DXNWDQDLY is the write leveling delay control register. PACK_DXNWDQDLY (offset 0x234 + n x 0x80 (n = 0-3), total reset 0x0000_0C00; PROVEN: Hi3535 data sheet, PDF page 704, section 4.1.8.2).";
        field {
            name = "reserved";
            desc = "Reserved.";
            sw = r; hw = w;
            reset = 0x0;
        } reserved_31_13[31:13];
        field {
            name = "wdq_phase";
            desc = "Write data eye clock phase select.";
            sw = rw; hw = r;
            reset = 0xc;
        } wdq_phase[12:8];
        field {
            name = "reserved";
            desc = "Reserved.";
            sw = r; hw = w;
            reset = 0x0;
        } reserved_7_0[7:0];
    } PACK_DXNWDQDLY_1 @ 0x2b4;
    reg {
        name = "PACK_DXNWDQDLY";
        desc = "PACK_DXNWDQDLY is the write leveling delay control register. PACK_DXNWDQDLY (offset 0x234 + n x 0x80 (n = 0-3), total reset 0x0000_0C00; PROVEN: Hi3535 data sheet, PDF page 704, section 4.1.8.2).";
        field {
            name = "reserved";
            desc = "Reserved.";
            sw = r; hw = w;
            reset = 0x0;
        } reserved_31_13[31:13];
        field {
            name = "wdq_phase";
            desc = "Write data eye clock phase select.";
            sw = rw; hw = r;
            reset = 0xc;
        } wdq_phase[12:8];
        field {
            name = "reserved";
            desc = "Reserved.";
            sw = r; hw = w;
            reset = 0x0;
        } reserved_7_0[7:0];
    } PACK_DXNWDQDLY_2 @ 0x334;
    reg {
        name = "PACK_DXNWDQDLY";
        desc = "PACK_DXNWDQDLY is the write leveling delay control register. PACK_DXNWDQDLY (offset 0x234 + n x 0x80 (n = 0-3), total reset 0x0000_0C00; PROVEN: Hi3535 data sheet, PDF page 704, section 4.1.8.2).";
        field {
            name = "reserved";
            desc = "Reserved.";
            sw = r; hw = w;
            reset = 0x0;
        } reserved_31_13[31:13];
        field {
            name = "wdq_phase";
            desc = "Write data eye clock phase select.";
            sw = rw; hw = r;
            reset = 0xc;
        } wdq_phase[12:8];
        field {
            name = "reserved";
            desc = "Reserved.";
            sw = r; hw = w;
            reset = 0x0;
        } reserved_7_0[7:0];
    } PACK_DXNWDQDLY_3 @ 0x3b4;
    reg {
        name = "PACK_DXNDQSGDLY";
        desc = "PACK_DXNDQSGDLY is the local delay line control register. PACK_DXNDQSGDLY (offset 0x23C + n x 0x80 (n = 0-3), total reset 0x0000_0010; PROVEN: Hi3535 data sheet, PDF page 705, section 4.1.8.2).";
        field {
            name = "reserved";
            desc = "Reserved.";
            sw = r; hw = w;
            reset = 0x0;
        } reserved_31_21[31:21];
        field {
            name = "rdqsgtxbdl";
            desc = "Read DQS gate delay select. This field specifies the read gate delay value in front of the DQS dummy pad.";
            sw = rw; hw = r;
            reset = 0x0;
        } rdqsgtxbdl[20:16];
        field {
            name = "reserved";
            desc = "Reserved.";
            sw = r; hw = w;
            reset = 0x0;
        } reserved_15_14[15:14];
        field {
            name = "rdqsg_phase";
            desc = "Read DQS gating clock phase select.";
            sw = rw; hw = r;
            reset = 0x0;
        } rdqsg_phase[13:8];
        field {
            name = "reserved";
            desc = "Reserved.";
            sw = r; hw = w;
            reset = 0x0;
        } reserved_7_6[7:6];
        field {
            name = "rdqsg_bdl";
            desc = "Read DQS gating delay select. This field specifies the read gating delay value after the DQS dummy pad.";
            sw = rw; hw = r;
            reset = 0x10;
        } rdqsg_bdl[5:0];
    } PACK_DXNDQSGDLY_0 @ 0x23c;
    reg {
        name = "PACK_DXNDQSGDLY";
        desc = "PACK_DXNDQSGDLY is the local delay line control register. PACK_DXNDQSGDLY (offset 0x23C + n x 0x80 (n = 0-3), total reset 0x0000_0010; PROVEN: Hi3535 data sheet, PDF page 705, section 4.1.8.2).";
        field {
            name = "reserved";
            desc = "Reserved.";
            sw = r; hw = w;
            reset = 0x0;
        } reserved_31_21[31:21];
        field {
            name = "rdqsgtxbdl";
            desc = "Read DQS gate delay select. This field specifies the read gate delay value in front of the DQS dummy pad.";
            sw = rw; hw = r;
            reset = 0x0;
        } rdqsgtxbdl[20:16];
        field {
            name = "reserved";
            desc = "Reserved.";
            sw = r; hw = w;
            reset = 0x0;
        } reserved_15_14[15:14];
        field {
            name = "rdqsg_phase";
            desc = "Read DQS gating clock phase select.";
            sw = rw; hw = r;
            reset = 0x0;
        } rdqsg_phase[13:8];
        field {
            name = "reserved";
            desc = "Reserved.";
            sw = r; hw = w;
            reset = 0x0;
        } reserved_7_6[7:6];
        field {
            name = "rdqsg_bdl";
            desc = "Read DQS gating delay select. This field specifies the read gating delay value after the DQS dummy pad.";
            sw = rw; hw = r;
            reset = 0x10;
        } rdqsg_bdl[5:0];
    } PACK_DXNDQSGDLY_1 @ 0x2bc;
    reg {
        name = "PACK_DXNDQSGDLY";
        desc = "PACK_DXNDQSGDLY is the local delay line control register. PACK_DXNDQSGDLY (offset 0x23C + n x 0x80 (n = 0-3), total reset 0x0000_0010; PROVEN: Hi3535 data sheet, PDF page 705, section 4.1.8.2).";
        field {
            name = "reserved";
            desc = "Reserved.";
            sw = r; hw = w;
            reset = 0x0;
        } reserved_31_21[31:21];
        field {
            name = "rdqsgtxbdl";
            desc = "Read DQS gate delay select. This field specifies the read gate delay value in front of the DQS dummy pad.";
            sw = rw; hw = r;
            reset = 0x0;
        } rdqsgtxbdl[20:16];
        field {
            name = "reserved";
            desc = "Reserved.";
            sw = r; hw = w;
            reset = 0x0;
        } reserved_15_14[15:14];
        field {
            name = "rdqsg_phase";
            desc = "Read DQS gating clock phase select.";
            sw = rw; hw = r;
            reset = 0x0;
        } rdqsg_phase[13:8];
        field {
            name = "reserved";
            desc = "Reserved.";
            sw = r; hw = w;
            reset = 0x0;
        } reserved_7_6[7:6];
        field {
            name = "rdqsg_bdl";
            desc = "Read DQS gating delay select. This field specifies the read gating delay value after the DQS dummy pad.";
            sw = rw; hw = r;
            reset = 0x10;
        } rdqsg_bdl[5:0];
    } PACK_DXNDQSGDLY_2 @ 0x33c;
    reg {
        name = "PACK_DXNDQSGDLY";
        desc = "PACK_DXNDQSGDLY is the local delay line control register. PACK_DXNDQSGDLY (offset 0x23C + n x 0x80 (n = 0-3), total reset 0x0000_0010; PROVEN: Hi3535 data sheet, PDF page 705, section 4.1.8.2).";
        field {
            name = "reserved";
            desc = "Reserved.";
            sw = r; hw = w;
            reset = 0x0;
        } reserved_31_21[31:21];
        field {
            name = "rdqsgtxbdl";
            desc = "Read DQS gate delay select. This field specifies the read gate delay value in front of the DQS dummy pad.";
            sw = rw; hw = r;
            reset = 0x0;
        } rdqsgtxbdl[20:16];
        field {
            name = "reserved";
            desc = "Reserved.";
            sw = r; hw = w;
            reset = 0x0;
        } reserved_15_14[15:14];
        field {
            name = "rdqsg_phase";
            desc = "Read DQS gating clock phase select.";
            sw = rw; hw = r;
            reset = 0x0;
        } rdqsg_phase[13:8];
        field {
            name = "reserved";
            desc = "Reserved.";
            sw = r; hw = w;
            reset = 0x0;
        } reserved_7_6[7:6];
        field {
            name = "rdqsg_bdl";
            desc = "Read DQS gating delay select. This field specifies the read gating delay value after the DQS dummy pad.";
            sw = rw; hw = r;
            reset = 0x10;
        } rdqsg_bdl[5:0];
    } PACK_DXNDQSGDLY_3 @ 0x3bc;
    reg {
        name = "PACK_DXNWLSL";
        desc = "PACK_DXNWLSL is the extra system latency addition control register. PACK_DXNWLSL (offset 0x244 + n x 0x80 (n = 0-3), total reset 0x0001_0000; PROVEN: Hi3535 data sheet, PDF page 705, section 4.1.8.2).";
        field {
            name = "reserved";
            desc = "Reserved.";
            sw = r; hw = w;
            reset = 0x0;
        } reserved_31_18[31:18];
        field {
            name = "wl_sl";
            desc = "Write leveling system enable. This field adjusts the write latency after write leveling.";
            sw = rw; hw = r;
            reset = 0x1;
        } wl_sl[17:16];
        field {
            name = "reserved";
            desc = "Reserved.";
            sw = rw; hw = r;
            reset = 0x0;
        } reserved_15_0[15:0];
    } PACK_DXNWLSL_0 @ 0x244;
    reg {
        name = "PACK_DXNWLSL";
        desc = "PACK_DXNWLSL is the extra system latency addition control register. PACK_DXNWLSL (offset 0x244 + n x 0x80 (n = 0-3), total reset 0x0001_0000; PROVEN: Hi3535 data sheet, PDF page 705, section 4.1.8.2).";
        field {
            name = "reserved";
            desc = "Reserved.";
            sw = r; hw = w;
            reset = 0x0;
        } reserved_31_18[31:18];
        field {
            name = "wl_sl";
            desc = "Write leveling system enable. This field adjusts the write latency after write leveling.";
            sw = rw; hw = r;
            reset = 0x1;
        } wl_sl[17:16];
        field {
            name = "reserved";
            desc = "Reserved.";
            sw = rw; hw = r;
            reset = 0x0;
        } reserved_15_0[15:0];
    } PACK_DXNWLSL_1 @ 0x2c4;
    reg {
        name = "PACK_DXNWLSL";
        desc = "PACK_DXNWLSL is the extra system latency addition control register. PACK_DXNWLSL (offset 0x244 + n x 0x80 (n = 0-3), total reset 0x0001_0000; PROVEN: Hi3535 data sheet, PDF page 705, section 4.1.8.2).";
        field {
            name = "reserved";
            desc = "Reserved.";
            sw = r; hw = w;
            reset = 0x0;
        } reserved_31_18[31:18];
        field {
            name = "wl_sl";
            desc = "Write leveling system enable. This field adjusts the write latency after write leveling.";
            sw = rw; hw = r;
            reset = 0x1;
        } wl_sl[17:16];
        field {
            name = "reserved";
            desc = "Reserved.";
            sw = rw; hw = r;
            reset = 0x0;
        } reserved_15_0[15:0];
    } PACK_DXNWLSL_2 @ 0x344;
    reg {
        name = "PACK_DXNWLSL";
        desc = "PACK_DXNWLSL is the extra system latency addition control register. PACK_DXNWLSL (offset 0x244 + n x 0x80 (n = 0-3), total reset 0x0001_0000; PROVEN: Hi3535 data sheet, PDF page 705, section 4.1.8.2).";
        field {
            name = "reserved";
            desc = "Reserved.";
            sw = r; hw = w;
            reset = 0x0;
        } reserved_31_18[31:18];
        field {
            name = "wl_sl";
            desc = "Write leveling system enable. This field adjusts the write latency after write leveling.";
            sw = rw; hw = r;
            reset = 0x1;
        } wl_sl[17:16];
        field {
            name = "reserved";
            desc = "Reserved.";
            sw = rw; hw = r;
            reset = 0x0;
        } reserved_15_0[15:0];
    } PACK_DXNWLSL_3 @ 0x3c4;
    reg {
        name = "PACK_DXNGDS";
        desc = "PACK_DXNGDS is the PHY latch enable register (for obtaining stable data). PACK_DXNGDS (offset 0x248 + n x 0x80 (n = 0-3), total reset 0x0000_0000; PROVEN: Hi3535 data sheet, PDF page 706, section 4.1.8.2).";
        field {
            name = "reserved";
            desc = "Reserved.";
            sw = r; hw = w;
            reset = 0x0;
        } reserved_31_3[31:3];
        field {
            name = "gds";
            desc = "Rank 0 read data latch delay. This field is used as the reference stable region when the PHY latches the read data.";
            sw = rw; hw = r;
            reset = 0x0;
        } gds[2:0];
    } PACK_DXNGDS_0 @ 0x248;
    reg {
        name = "PACK_DXNGDS";
        desc = "PACK_DXNGDS is the PHY latch enable register (for obtaining stable data). PACK_DXNGDS (offset 0x248 + n x 0x80 (n = 0-3), total reset 0x0000_0000; PROVEN: Hi3535 data sheet, PDF page 706, section 4.1.8.2).";
        field {
            name = "reserved";
            desc = "Reserved.";
            sw = r; hw = w;
            reset = 0x0;
        } reserved_31_3[31:3];
        field {
            name = "gds";
            desc = "Rank 0 read data latch delay. This field is used as the reference stable region when the PHY latches the read data.";
            sw = rw; hw = r;
            reset = 0x0;
        } gds[2:0];
    } PACK_DXNGDS_1 @ 0x2c8;
    reg {
        name = "PACK_DXNGDS";
        desc = "PACK_DXNGDS is the PHY latch enable register (for obtaining stable data). PACK_DXNGDS (offset 0x248 + n x 0x80 (n = 0-3), total reset 0x0000_0000; PROVEN: Hi3535 data sheet, PDF page 706, section 4.1.8.2).";
        field {
            name = "reserved";
            desc = "Reserved.";
            sw = r; hw = w;
            reset = 0x0;
        } reserved_31_3[31:3];
        field {
            name = "gds";
            desc = "Rank 0 read data latch delay. This field is used as the reference stable region when the PHY latches the read data.";
            sw = rw; hw = r;
            reset = 0x0;
        } gds[2:0];
    } PACK_DXNGDS_2 @ 0x348;
    reg {
        name = "PACK_DXNGDS";
        desc = "PACK_DXNGDS is the PHY latch enable register (for obtaining stable data). PACK_DXNGDS (offset 0x248 + n x 0x80 (n = 0-3), total reset 0x0000_0000; PROVEN: Hi3535 data sheet, PDF page 706, section 4.1.8.2).";
        field {
            name = "reserved";
            desc = "Reserved.";
            sw = r; hw = w;
            reset = 0x0;
        } reserved_31_3[31:3];
        field {
            name = "gds";
            desc = "Rank 0 read data latch delay. This field is used as the reference stable region when the PHY latches the read data.";
            sw = rw; hw = r;
            reset = 0x0;
        } gds[2:0];
    } PACK_DXNGDS_3 @ 0x3c8;
    reg {
        name = "PACK_DXNCLKBDL";
        desc = "PACK_DXNCLKBDL is the data block clock bit delay line setting register. PACK_DXNCLKBDL (offset 0x24C + n x 0x80 (n = 0-3), total reset 0x0000_0000; PROVEN: Hi3535 data sheet, PDF page 706, section 4.1.8.2).";
        field {
            name = "reserved";
            desc = "Reserved.";
            sw = r; hw = w;
            reset = 0x0;
        } reserved_31_21[31:21];
        field {
            name = "dx_refclk_bdl";
            desc = "Bit delay line setting of REFCLK.";
            sw = rw; hw = r;
            reset = 0x0;
        } dx_refclk_bdl[20:16];
        field {
            name = "reserved";
            desc = "Reserved.";
            sw = r; hw = w;
            reset = 0x0;
        } reserved_15_5[15:5];
        field {
            name = "dx_fbclk_bdl";
            desc = "Bit delay line setting of FBCLK.";
            sw = rw; hw = r;
            reset = 0x0;
        } dx_fbclk_bdl[4:0];
    } PACK_DXNCLKBDL_0 @ 0x24c;
    reg {
        name = "PACK_DXNCLKBDL";
        desc = "PACK_DXNCLKBDL is the data block clock bit delay line setting register. PACK_DXNCLKBDL (offset 0x24C + n x 0x80 (n = 0-3), total reset 0x0000_0000; PROVEN: Hi3535 data sheet, PDF page 706, section 4.1.8.2).";
        field {
            name = "reserved";
            desc = "Reserved.";
            sw = r; hw = w;
            reset = 0x0;
        } reserved_31_21[31:21];
        field {
            name = "dx_refclk_bdl";
            desc = "Bit delay line setting of REFCLK.";
            sw = rw; hw = r;
            reset = 0x0;
        } dx_refclk_bdl[20:16];
        field {
            name = "reserved";
            desc = "Reserved.";
            sw = r; hw = w;
            reset = 0x0;
        } reserved_15_5[15:5];
        field {
            name = "dx_fbclk_bdl";
            desc = "Bit delay line setting of FBCLK.";
            sw = rw; hw = r;
            reset = 0x0;
        } dx_fbclk_bdl[4:0];
    } PACK_DXNCLKBDL_1 @ 0x2cc;
    reg {
        name = "PACK_DXNCLKBDL";
        desc = "PACK_DXNCLKBDL is the data block clock bit delay line setting register. PACK_DXNCLKBDL (offset 0x24C + n x 0x80 (n = 0-3), total reset 0x0000_0000; PROVEN: Hi3535 data sheet, PDF page 706, section 4.1.8.2).";
        field {
            name = "reserved";
            desc = "Reserved.";
            sw = r; hw = w;
            reset = 0x0;
        } reserved_31_21[31:21];
        field {
            name = "dx_refclk_bdl";
            desc = "Bit delay line setting of REFCLK.";
            sw = rw; hw = r;
            reset = 0x0;
        } dx_refclk_bdl[20:16];
        field {
            name = "reserved";
            desc = "Reserved.";
            sw = r; hw = w;
            reset = 0x0;
        } reserved_15_5[15:5];
        field {
            name = "dx_fbclk_bdl";
            desc = "Bit delay line setting of FBCLK.";
            sw = rw; hw = r;
            reset = 0x0;
        } dx_fbclk_bdl[4:0];
    } PACK_DXNCLKBDL_2 @ 0x34c;
    reg {
        name = "PACK_DXNCLKBDL";
        desc = "PACK_DXNCLKBDL is the data block clock bit delay line setting register. PACK_DXNCLKBDL (offset 0x24C + n x 0x80 (n = 0-3), total reset 0x0000_0000; PROVEN: Hi3535 data sheet, PDF page 706, section 4.1.8.2).";
        field {
            name = "reserved";
            desc = "Reserved.";
            sw = r; hw = w;
            reset = 0x0;
        } reserved_31_21[31:21];
        field {
            name = "dx_refclk_bdl";
            desc = "Bit delay line setting of REFCLK.";
            sw = rw; hw = r;
            reset = 0x0;
        } dx_refclk_bdl[20:16];
        field {
            name = "reserved";
            desc = "Reserved.";
            sw = r; hw = w;
            reset = 0x0;
        } reserved_15_5[15:5];
        field {
            name = "dx_fbclk_bdl";
            desc = "Bit delay line setting of FBCLK.";
            sw = rw; hw = r;
            reset = 0x0;
        } dx_fbclk_bdl[4:0];
    } PACK_DXNCLKBDL_3 @ 0x3cc;
    reg {
        name = "PACK_DXNRDBOUND";
        desc = "PACK_DXNRDBOUND is the read data eye boundary register. The boundary here refers to the left and right boundaries of RDQSQDL in the data eye. PACK_DXNRDBOUND (offset 0x250 + n x 0x80 (n = 0-3), total reset 0x0000_0000; PROVEN: Hi3535 data sheet, PDF page 707, section 4.1.8.2).";
        field {
            name = "reserved";
            desc = "Reserved.";
            sw = r; hw = w;
            reset = 0x0;
        } reserved_31_23[31:23];
        field {
            name = "rdqsqdl_left";
            desc = "Left boundary of the read data eye.";
            sw = r; hw = w;
            reset = 0x0;
        } rdqsqdl_left[22:16];
        field {
            name = "reserved";
            desc = "Reserved.";
            sw = r; hw = w;
            reset = 0x0;
        } reserved_15_7[15:7];
        field {
            name = "rdqsqdl_right";
            desc = "Right boundary of the read data eye.";
            sw = r; hw = w;
            reset = 0x0;
        } rdqsqdl_right[6:0];
    } PACK_DXNRDBOUND_0 @ 0x250;
    reg {
        name = "PACK_DXNRDBOUND";
        desc = "PACK_DXNRDBOUND is the read data eye boundary register. The boundary here refers to the left and right boundaries of RDQSQDL in the data eye. PACK_DXNRDBOUND (offset 0x250 + n x 0x80 (n = 0-3), total reset 0x0000_0000; PROVEN: Hi3535 data sheet, PDF page 707, section 4.1.8.2).";
        field {
            name = "reserved";
            desc = "Reserved.";
            sw = r; hw = w;
            reset = 0x0;
        } reserved_31_23[31:23];
        field {
            name = "rdqsqdl_left";
            desc = "Left boundary of the read data eye.";
            sw = r; hw = w;
            reset = 0x0;
        } rdqsqdl_left[22:16];
        field {
            name = "reserved";
            desc = "Reserved.";
            sw = r; hw = w;
            reset = 0x0;
        } reserved_15_7[15:7];
        field {
            name = "rdqsqdl_right";
            desc = "Right boundary of the read data eye.";
            sw = r; hw = w;
            reset = 0x0;
        } rdqsqdl_right[6:0];
    } PACK_DXNRDBOUND_1 @ 0x2d0;
    reg {
        name = "PACK_DXNRDBOUND";
        desc = "PACK_DXNRDBOUND is the read data eye boundary register. The boundary here refers to the left and right boundaries of RDQSQDL in the data eye. PACK_DXNRDBOUND (offset 0x250 + n x 0x80 (n = 0-3), total reset 0x0000_0000; PROVEN: Hi3535 data sheet, PDF page 707, section 4.1.8.2).";
        field {
            name = "reserved";
            desc = "Reserved.";
            sw = r; hw = w;
            reset = 0x0;
        } reserved_31_23[31:23];
        field {
            name = "rdqsqdl_left";
            desc = "Left boundary of the read data eye.";
            sw = r; hw = w;
            reset = 0x0;
        } rdqsqdl_left[22:16];
        field {
            name = "reserved";
            desc = "Reserved.";
            sw = r; hw = w;
            reset = 0x0;
        } reserved_15_7[15:7];
        field {
            name = "rdqsqdl_right";
            desc = "Right boundary of the read data eye.";
            sw = r; hw = w;
            reset = 0x0;
        } rdqsqdl_right[6:0];
    } PACK_DXNRDBOUND_2 @ 0x350;
    reg {
        name = "PACK_DXNRDBOUND";
        desc = "PACK_DXNRDBOUND is the read data eye boundary register. The boundary here refers to the left and right boundaries of RDQSQDL in the data eye. PACK_DXNRDBOUND (offset 0x250 + n x 0x80 (n = 0-3), total reset 0x0000_0000; PROVEN: Hi3535 data sheet, PDF page 707, section 4.1.8.2).";
        field {
            name = "reserved";
            desc = "Reserved.";
            sw = r; hw = w;
            reset = 0x0;
        } reserved_31_23[31:23];
        field {
            name = "rdqsqdl_left";
            desc = "Left boundary of the read data eye.";
            sw = r; hw = w;
            reset = 0x0;
        } rdqsqdl_left[22:16];
        field {
            name = "reserved";
            desc = "Reserved.";
            sw = r; hw = w;
            reset = 0x0;
        } reserved_15_7[15:7];
        field {
            name = "rdqsqdl_right";
            desc = "Right boundary of the read data eye.";
            sw = r; hw = w;
            reset = 0x0;
        } rdqsqdl_right[6:0];
    } PACK_DXNRDBOUND_3 @ 0x3d0;
    reg {
        name = "PACK_DXNWRBOUND";
        desc = "PACK_DXNWRBOUND is the write data eye boundary register. The boundary here refers to the left and right boundaries of WDQSQDL in the data eye. PACK_DXNWRBOUND (offset 0x254 + n x 0x80 (n = 0-3), total reset 0x0000_0000; PROVEN: Hi3535 data sheet, PDF page 707, section 4.1.8.2).";
        field {
            name = "reserved";
            desc = "Reserved.";
            sw = r; hw = w;
            reset = 0x0;
        } reserved_31_21[31:21];
        field {
            name = "wdqs_phase_left";
            desc = "Left boundary of the write data eye.";
            sw = r; hw = w;
            reset = 0x0;
        } wdqs_phase_left[20:16];
        field {
            name = "reserved";
            desc = "Reserved.";
            sw = r; hw = w;
            reset = 0x0;
        } reserved_15_5[15:5];
        field {
            name = "wdqs_phase_right";
            desc = "Right boundary of the write data eye.";
            sw = r; hw = w;
            reset = 0x0;
        } wdqs_phase_right[4:0];
    } PACK_DXNWRBOUND_0 @ 0x254;
    reg {
        name = "PACK_DXNWRBOUND";
        desc = "PACK_DXNWRBOUND is the write data eye boundary register. The boundary here refers to the left and right boundaries of WDQSQDL in the data eye. PACK_DXNWRBOUND (offset 0x254 + n x 0x80 (n = 0-3), total reset 0x0000_0000; PROVEN: Hi3535 data sheet, PDF page 707, section 4.1.8.2).";
        field {
            name = "reserved";
            desc = "Reserved.";
            sw = r; hw = w;
            reset = 0x0;
        } reserved_31_21[31:21];
        field {
            name = "wdqs_phase_left";
            desc = "Left boundary of the write data eye.";
            sw = r; hw = w;
            reset = 0x0;
        } wdqs_phase_left[20:16];
        field {
            name = "reserved";
            desc = "Reserved.";
            sw = r; hw = w;
            reset = 0x0;
        } reserved_15_5[15:5];
        field {
            name = "wdqs_phase_right";
            desc = "Right boundary of the write data eye.";
            sw = r; hw = w;
            reset = 0x0;
        } wdqs_phase_right[4:0];
    } PACK_DXNWRBOUND_1 @ 0x2d4;
    reg {
        name = "PACK_DXNWRBOUND";
        desc = "PACK_DXNWRBOUND is the write data eye boundary register. The boundary here refers to the left and right boundaries of WDQSQDL in the data eye. PACK_DXNWRBOUND (offset 0x254 + n x 0x80 (n = 0-3), total reset 0x0000_0000; PROVEN: Hi3535 data sheet, PDF page 707, section 4.1.8.2).";
        field {
            name = "reserved";
            desc = "Reserved.";
            sw = r; hw = w;
            reset = 0x0;
        } reserved_31_21[31:21];
        field {
            name = "wdqs_phase_left";
            desc = "Left boundary of the write data eye.";
            sw = r; hw = w;
            reset = 0x0;
        } wdqs_phase_left[20:16];
        field {
            name = "reserved";
            desc = "Reserved.";
            sw = r; hw = w;
            reset = 0x0;
        } reserved_15_5[15:5];
        field {
            name = "wdqs_phase_right";
            desc = "Right boundary of the write data eye.";
            sw = r; hw = w;
            reset = 0x0;
        } wdqs_phase_right[4:0];
    } PACK_DXNWRBOUND_2 @ 0x354;
    reg {
        name = "PACK_DXNWRBOUND";
        desc = "PACK_DXNWRBOUND is the write data eye boundary register. The boundary here refers to the left and right boundaries of WDQSQDL in the data eye. PACK_DXNWRBOUND (offset 0x254 + n x 0x80 (n = 0-3), total reset 0x0000_0000; PROVEN: Hi3535 data sheet, PDF page 707, section 4.1.8.2).";
        field {
            name = "reserved";
            desc = "Reserved.";
            sw = r; hw = w;
            reset = 0x0;
        } reserved_31_21[31:21];
        field {
            name = "wdqs_phase_left";
            desc = "Left boundary of the write data eye.";
            sw = r; hw = w;
            reset = 0x0;
        } wdqs_phase_left[20:16];
        field {
            name = "reserved";
            desc = "Reserved.";
            sw = r; hw = w;
            reset = 0x0;
        } reserved_15_5[15:5];
        field {
            name = "wdqs_phase_right";
            desc = "Right boundary of the write data eye.";
            sw = r; hw = w;
            reset = 0x0;
        } wdqs_phase_right[4:0];
    } PACK_DXNWRBOUND_3 @ 0x3d4;
};

`endif
