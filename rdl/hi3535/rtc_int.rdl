`ifndef EHI3535_RTC_INT_RDL
`define EHI3535_RTC_INT_RDL
regfile eHI3535_RTC_INT {
    name = "Internal RTC register file (device addresses reached through the RTC SPI interface, NOT memory mapped; the instance base 0x20060100 in the SoC map is a placeholder)";
    desc = "Internal RTC register file (device addresses reached through the RTC SPI interface, NOT memory mapped; the instance base 0x20060100 in the SoC map is a placeholder) of the Hi3535 at base 0x20060000. 89 registers extracted programmatically from the Hi3535 H.264 codec processor (Hi3535 user guide) data sheet (Issue 00B08, 2014-02-25); chapter 3.8.7, table 3-34. Field names, bit ranges, access types and reset values are taken from the register tables; reset values are the data sheet total reset values split onto the fields (per-field values where the table has them). Label: PROVEN. Hardware not verified here (no board).";
    default regwidth = 8;
    default accesswidth = 8;
    reg {
        name = "RTC_10MS_COUNT";
        desc = "RTC_10MS_COUNT 为RTC 10ms 计数值寄存器。 RTC_10MS_COUNT (offset 0x00, total reset 0x00; PROVEN: Hi3535 data sheet, PDF page 542, section 3.8.7).";
        field {
            name = "reserved";
            desc = "Reserved";
            sw = r; hw = na;
            reset = 0x0;
        } reserved_7_7[7:7];
        field {
            name = "rtc_10ms_count";
            desc = "RTC 10ms 计数器值，表示当前计时的10ms 时间 个数。 取值范围值为0～99。";
            sw = r; hw = w;
            reset = 0x0;
        } rtc_10ms_count[6:0];
    } RTC_10MS_COUNT @ 0x0;
    reg {
        name = "RTC_S_COUNT";
        desc = "RTC_S_COUNT 为RTC 秒计数值寄存器。 RTC_S_COUNT (offset 0x01, total reset 0x00; PROVEN: Hi3535 data sheet, PDF page 542, section 3.8.7).";
        field {
            name = "reserved";
            desc = "Reserved.";
            sw = r; hw = na;
            reset = 0x0;
        } reserved_7_6[7:6];
        field {
            name = "rtc_s_count";
            desc = "RTC 秒计数器值，表示当前计时的秒时间个数。 取值范围为0～59。";
            sw = r; hw = w;
            reset = 0x0;
        } rtc_s_count[5:0];
    } RTC_S_COUNT @ 0x1;
    reg {
        name = "RTC_M_COUNT";
        desc = "RTC_M_COUNT 为RTC 分计数值寄存器 RTC_M_COUNT (offset 0x02, total reset 0x00; PROVEN: Hi3535 data sheet, PDF page 543, section 3.8.7).";
        field {
            name = "reserved";
            desc = "Reserved.";
            sw = r; hw = na;
            reset = 0x0;
        } reserved_7_6[7:6];
        field {
            name = "rtc_m_count";
            desc = "RTC 分计数器值，表示当前计时的分时间个数。 取之范围为0～59。";
            sw = r; hw = w;
            reset = 0x0;
        } rtc_m_count[5:0];
    } RTC_M_COUNT @ 0x2;
    reg {
        name = "RTC_H_COUNT";
        desc = "RTC_H_COUNT 为RTC 时 计数值寄存器。 RTC_H_COUNT (offset 0x03, total reset 0x00; PROVEN: Hi3535 data sheet, PDF page 543, section 3.8.7).";
        field {
            name = "reserved";
            desc = "Reserved";
            sw = r; hw = na;
            reset = 0x0;
        } reserved_7_5[7:5];
        field {
            name = "rtc_h_count";
            desc = "RTC 时计数器值，表示当前计时的小时时间个 数。 取之范围为0～23。";
            sw = r; hw = w;
            reset = 0x0;
        } rtc_h_count[4:0];
    } RTC_H_COUNT @ 0x3;
    reg {
        name = "RTC_D_COUNT_L";
        desc = "RTC_D_COUNT_L 为RTC 天计数值低8 位寄存器。 RTC_D_COUNT_L (offset 0x04, total reset 0x00; PROVEN: Hi3535 data sheet, PDF page 544, section 3.8.7).";
        field {
            name = "rtc_d_count_l";
            desc = "RTC 天计数器值的低8 位，与RTC_D_COUNT_H 配合，表示当前计时的天时间个数，取值范围为 0～65535。";
            sw = r; hw = w;
            reset = 0x0;
        } rtc_d_count_l[7:0];
    } RTC_D_COUNT_L @ 0x4;
    reg {
        name = "RTC_D_COUNT_H";
        desc = "RTC_D_COUNT_H 为RTC 天计数值高8 位寄存器。 RTC_D_COUNT_H (offset 0x05, total reset 0x00; PROVEN: Hi3535 data sheet, PDF page 544, section 3.8.7).";
        field {
            name = "rtc_d_count_h";
            desc = "RTC 天计数器值的高8 位，与RTC_D_COUNT_L 配合，表示当前计时的天时间个数，取值范围为 0～65535。";
            sw = r; hw = w;
            reset = 0x0;
        } rtc_d_count_h[7:0];
    } RTC_D_COUNT_H @ 0x5;
    reg {
        name = "RTC_MR_10MS";
        desc = "RTC_MR_10MS 为RTC 10ms 定时值寄存器。 RTC_MR_10MS (offset 0x06, total reset 0x7F; PROVEN: Hi3535 data sheet, PDF page 545, section 3.8.7).";
        field {
            name = "reserved";
            desc = "Reserved.";
            sw = rw; hw = r;
            reset = 0x0;
        } reserved_7_7[7:7];
        field {
            name = "rtc_mr_10ms";
            desc = "RTC 10ms 定时值，表示定时的10ms 时间值。 取值范围值为0～99。";
            sw = rw; hw = r;
            reset = 0x7f;
        } rtc_mr_10ms[6:0];
    } RTC_MR_10MS @ 0x6;
    reg {
        name = "RTC_MR_S";
        desc = "RTC_MR_S 为RTC 秒定时值寄存器。 RTC_MR_S (offset 0x07, total reset 0x3F; PROVEN: Hi3535 data sheet, PDF page 545, section 3.8.7).";
        field {
            name = "reserved";
            desc = "Reserved.";
            sw = rw; hw = r;
            reset = 0x0;
        } reserved_7_6[7:6];
        field {
            name = "rtc_mr_s";
            desc = "RTC 秒定时值，表示定时的秒时间值。 取值范围值为0～59。";
            sw = rw; hw = r;
            reset = 0x3f;
        } rtc_mr_s[5:0];
    } RTC_MR_S @ 0x7;
    reg {
        name = "RTC_MR_M";
        desc = "RTC_MR_M 为RTC 分定时值寄存器。 RTC_MR_M (offset 0x08, total reset 0x3F; PROVEN: Hi3535 data sheet, PDF page 546, section 3.8.7).";
        field {
            name = "reserved";
            desc = "Reserved";
            sw = rw; hw = r;
            reset = 0x0;
        } reserved_7_6[7:6];
        field {
            name = "rtc_mr_m";
            desc = "RTC 分定时值，表示定时的分时间值。 取值范围值为0～59。";
            sw = rw; hw = r;
            reset = 0x3f;
        } rtc_mr_m[5:0];
    } RTC_MR_M @ 0x8;
    reg {
        name = "RTC_MR_H";
        desc = "RTC_MR_H 为RTC 时定时值寄存器。 RTC_MR_H (offset 0x09, total reset 0x1F; PROVEN: Hi3535 data sheet, PDF page 546, section 3.8.7).";
        field {
            name = "reserved";
            desc = "Reserved";
            sw = rw; hw = r;
            reset = 0x0;
        } reserved_7_5[7:5];
        field {
            name = "rtc_mr_h";
            desc = "RTC 时定时值，表示定时的小时时间值。 取值范围值为0～23。";
            sw = rw; hw = r;
            reset = 0x1f;
        } rtc_mr_h[4:0];
    } RTC_MR_H @ 0x9;
    reg {
        name = "RTC_MR_D_L";
        desc = "RTC_MR_D_L 为RTC 天定时值的低8 位寄存器。 RTC_MR_D_L (offset 0x0A, total reset 0xFF; PROVEN: Hi3535 data sheet, PDF page 547, section 3.8.7).";
        field {
            name = "rtc_mr_d_l";
            desc = "RTC 天定时值低8 位，与RTC_MR_D_H 配合， 表示定时的天时间值，取值范围为0～65535。";
            sw = rw; hw = r;
            reset = 0xff;
        } rtc_mr_d_l[7:0];
    } RTC_MR_D_L @ 0xa;
    reg {
        name = "RTC_MR_D_H";
        desc = "RTC_MR_D_H 为RTC 天定时值的高8 位寄存器。 RTC_MR_D_H (offset 0x0B, total reset 0xFF; PROVEN: Hi3535 data sheet, PDF page 547, section 3.8.7).";
        field {
            name = "rtc_mr_d_h";
            desc = "RTC 天定时值高8 位，与RTC_MR_D_L 配合， 表示定时的天时间值，取值范围为0～65535。";
            sw = rw; hw = r;
            reset = 0xff;
        } rtc_mr_d_h[7:0];
    } RTC_MR_D_H @ 0xb;
    reg {
        name = "RTC_LR_10MS";
        desc = "RTC_LR_10MS 为RTC 10ms 设置值寄存器。 RTC_LR_10MS (offset 0x0C, total reset 0x00; PROVEN: Hi3535 data sheet, PDF page 547, section 3.8.7).";
        field {
            name = "reserved";
            desc = "Reserved.";
            sw = rw; hw = r;
            reset = 0x0;
        } reserved_7_7[7:7];
        field {
            name = "rtc_lr_10ms";
            desc = "RTC 10ms 设置值，表示设置的10ms 时间值。 取值范围为0～99。";
            sw = rw; hw = r;
            reset = 0x0;
        } rtc_lr_10ms[6:0];
    } RTC_LR_10MS @ 0xc;
    reg {
        name = "RTC_LR_S";
        desc = "RTC_LR_S 为RTC 秒设置值寄存器。 RTC_LR_S (offset 0x0D, total reset 0x00; PROVEN: Hi3535 data sheet, PDF page 548, section 3.8.7).";
        field {
            name = "reserved";
            desc = "Reserved";
            sw = rw; hw = r;
            reset = 0x0;
        } reserved_7_6[7:6];
        field {
            name = "rtc_lr_s";
            desc = "RTC 秒设置值，表示设置的秒时间值。 取值范围为0～59。";
            sw = rw; hw = r;
            reset = 0x0;
        } rtc_lr_s[5:0];
    } RTC_LR_S @ 0xd;
    reg {
        name = "RTC_LR_M";
        desc = "RTC_LR_M 为RTC 分设置值寄存器。 RTC_LR_M (offset 0x0E, total reset 0x00; PROVEN: Hi3535 data sheet, PDF page 548, section 3.8.7).";
        field {
            name = "reserved";
            desc = "Reserved.";
            sw = rw; hw = r;
            reset = 0x0;
        } reserved_7_6[7:6];
        field {
            name = "rtc_lr_m";
            desc = "RTC 分设置值，表示设置的分时间值。 取值范围为0～59。";
            sw = rw; hw = r;
            reset = 0x0;
        } rtc_lr_m[5:0];
    } RTC_LR_M @ 0xe;
    reg {
        name = "RTC_LR_H";
        desc = "RTC_LR_H 为RTC 时设置值寄存器。 RTC_LR_H (offset 0x0F, total reset 0x00; PROVEN: Hi3535 data sheet, PDF page 549, section 3.8.7).";
        field {
            name = "reserved";
            desc = "Reserved.";
            sw = rw; hw = r;
            reset = 0x0;
        } reserved_7_5[7:5];
        field {
            name = "rtc_lr_h";
            desc = "RTC 时设置值，表示设置的小时时间值。 取值范围为0～23。";
            sw = rw; hw = r;
            reset = 0x0;
        } rtc_lr_h[4:0];
    } RTC_LR_H @ 0xf;
    reg {
        name = "RTC_LR_D_L";
        desc = "RTC_LR_D_L 为RTC 天设置值的低8 位寄存器。 RTC_LR_D_L (offset 0x10, total reset 0x00; PROVEN: Hi3535 data sheet, PDF page 549, section 3.8.7).";
        field {
            name = "rtc_lr_d_l";
            desc = "RTC 天设置值低8 位，与RTC_LR_D_H 配合表示 设置的天时间，取值范围为0～65535。";
            sw = rw; hw = r;
            reset = 0x0;
        } rtc_lr_d_l[7:0];
    } RTC_LR_D_L @ 0x10;
    reg {
        name = "RTC_LR_D_H";
        desc = "RTC_LR_D_H 为RTC 天设置值的高8 位寄存器。 RTC_LR_D_H (offset 0x11, total reset 0x00; PROVEN: Hi3535 data sheet, PDF page 550, section 3.8.7).";
        field {
            name = "rtc_lr_d_h";
            desc = "RTC 天设置值高8 位，与RTC_LR_D_L 配合表示 设置的天时间，取值范围为0～65535。";
            sw = rw; hw = r;
            reset = 0x0;
        } rtc_lr_d_h[7:0];
    } RTC_LR_D_H @ 0x11;
    reg {
        name = "RTC_LORD";
        desc = "RTC_LORD 为RTC 设置值使能加载寄存器。 RTC_LORD (offset 0x12, total reset 0x00; PROVEN: Hi3535 data sheet, PDF page 550, section 3.8.7).";
        field {
            name = "reserved";
            desc = "Reserved";
            sw = r; hw = na;
            reset = 0x0;
        } reserved_7_1[7:1];
        field {
            name = "rtc_load";
            desc = "把RTC 的时间配置值写入RTC 累加器中的使能信 号。软件写入1 后，硬件会在加载成功后自动清 零。";
            sw = rw; hw = r;
            reset = 0x0;
        } rtc_load[0:0];
    } RTC_LORD @ 0x12;
    reg {
        name = "RTC_IMSC";
        desc = "RTC_IMSC 为RTC 中断使能寄存器。 RTC_IMSC (offset 0x13, total reset 0x00; PROVEN: Hi3535 data sheet, PDF page 551, section 3.8.7).";
        field {
            name = "reserved";
            desc = "Reserved.";
            sw = r; hw = na;
            reset = 0x0;
        } reserved_7_1[7:1];
        field {
            name = "rtc_imsc";
            desc = "RTC 定时中断输出使能位。
- 0：不输出中断；
- 1：输出中断。";
            sw = rw; hw = r;
            reset = 0x0;
        } rtc_imsc[0:0];
    } RTC_IMSC @ 0x13;
    reg {
        name = "RTC_INT_CLR";
        desc = "RTC_INT_CLR 为RTC 中断清除寄存器。 RTC_INT_CLR (offset 0x14, total reset 0x00; PROVEN: Hi3535 data sheet, PDF page 551, section 3.8.7).";
        field {
            name = "reserved";
            desc = "Reserved.";
            sw = r; hw = na;
            reset = 0x0;
        } reserved_7_1[7:1];
        field {
            name = "rtc_int_clr";
            desc = "RTC 定时中断清除寄存器，软件写入1 后，硬件 会在中断清除成功后自动清零。";
            sw = rw; hw = r;
            reset = 0x0;
        } rtc_int_clr[0:0];
    } RTC_INT_CLR @ 0x14;
    reg {
        name = "RTC_MSC_INT";
        desc = "RTC_MSC_INT 为RTC mask 中断状态寄存器。 RTC_MSC_INT (offset 0x15, total reset 0x00; PROVEN: Hi3535 data sheet, PDF page 552, section 3.8.7).";
        field {
            name = "reserved";
            desc = "Reserved.";
            sw = r; hw = na;
            reset = 0x0;
        } reserved_7_1[7:1];
        field {
            name = "mask_int";
            desc = "mask int 状态寄存器。";
            sw = r; hw = w;
            reset = 0x0;
        } mask_int[0:0];
    } RTC_MSC_INT @ 0x15;
    reg {
        name = "RTC_RAW_INT";
        desc = "RTC_RAW_INT 为RTC 原始中断状态寄存器。 RTC_RAW_INT (offset 0x16, total reset 0x00; PROVEN: Hi3535 data sheet, PDF page 552, section 3.8.7).";
        field {
            name = "reserved";
            desc = "Reserved.";
            sw = r; hw = na;
            reset = 0x0;
        } reserved_7_1[7:1];
        field {
            name = "raw_int";
            desc = "raw int 状态寄存器。";
            sw = r; hw = w;
            reset = 0x0;
        } raw_int[0:0];
    } RTC_RAW_INT @ 0x16;
    reg {
        name = "RTC_CLK";
        desc = "RTC_CLK 为RTC 输出时钟选择寄存器。 RTC_CLK (offset 0x17, total reset 0x00; PROVEN: Hi3535 data sheet, PDF page 553, section 3.8.7).";
        field {
            name = "reserved";
            desc = "Reserved.";
            sw = r; hw = na;
            reset = 0x0;
        } reserved_7_2[7:2];
        field {
            name = "clk_out_sel";
            desc = "RTC 输出的测试时钟选择。
- 00：输出晶体的震荡时钟；
- 01：输出校正后的100Hz 时钟； 1X：输出1Hz 时钟。";
            sw = rw; hw = r;
            reset = 0x0;
        } clk_out_sel[1:0];
    } RTC_CLK @ 0x17;
    reg {
        name = "RTC_POR_N";
        desc = "RTC_POR_N 为RTC 复位控制寄存器。 RTC_POR_N (offset 0x18, total reset 0x01; PROVEN: Hi3535 data sheet, PDF page 553, section 3.8.7).";
        field {
            name = "reserved";
            desc = "Reserved.";
            sw = r; hw = na;
            reset = 0x0;
        } reserved_7_1[7:1];
        field {
            name = "rtc_por_n";
            desc = "RTC 模块的复位信号。复位成功后自动置1。
- 0：复位。";
            sw = rw; hw = r;
            reset = 0x1;
        } rtc_por_n[0:0];
    } RTC_POR_N @ 0x18;
    reg {
        name = "RTC_SAR_CTRL";
        desc = "RTC_SAR_CTRL 为RTC 内部t_sensor 控制寄存器。 RTC_SAR_CTRL (offset 0x1A, total reset 0x00; PROVEN: Hi3535 data sheet, PDF page 554, section 3.8.7).";
        field {
            name = "reserved";
            desc = "Reserved.";
            sw = rw; hw = r;
            reset = 0x0;
        } reserved_7_4[7:4];
        field {
            name = "reserved";
            desc = "Reserved.";
            sw = rw; hw = r;
            reset = 0x0;
        } reserved_3_3[3:3];
        field {
            name = "reserved";
            desc = "Reserved.";
            sw = rw; hw = r;
            reset = 0x0;
        } reserved_2_2[2:2];
        field {
            name = "sample_time";
            desc = "温度的更新时间。
- 00：1 分钟；
- 01：4 分钟；
- 10：8 分钟；
- 11：16 分钟。";
            sw = rw; hw = r;
            reset = 0x0;
        } sample_time[1:0];
    } RTC_SAR_CTRL @ 0x1a;
    reg {
        name = "TOT_OFFSET_L";
        desc = "TOT_OFFSET_L 为校正算法中tot_offset 的修正值的低8 位寄存器。 TOT_OFFSET_L (offset 0x1C, total reset 0x00; PROVEN: Hi3535 data sheet, PDF page 554, section 3.8.7).";
        field {
            name = "tot_offset_l";
            desc = "校正算法中tot_offset 的修正值，为补码，表示- 256~255，也就是说校正算法中tot_offset 的值为 1990+(-256~255)。寄存器值为低7 位。";
            sw = rw; hw = r;
            reset = 0x0;
        } tot_offset_l[7:0];
    } TOT_OFFSET_L @ 0x1c;
    reg {
        name = "TOT_OFFSET_H";
        desc = "TOT_OFFSET_H 为校正算法中tot_offset 的修正值的高1 位寄存器。 TOT_OFFSET_H (offset 0x1D, total reset 0x00; PROVEN: Hi3535 data sheet, PDF page 555, section 3.8.7).";
        field {
            name = "reserved";
            desc = "Reserved";
            sw = r; hw = na;
            reset = 0x0;
        } reserved_7_1[7:1];
        field {
            name = "tot_offset_h";
            desc = "校正算法中tot_offset 的修正值，为补码，表示- 256~255，也就是说校正算法中tot_offset 的值为 1990+(-256~255)。寄存器值为高1 位。";
            sw = rw; hw = r;
            reset = 0x0;
        } tot_offset_h[0:0];
    } TOT_OFFSET_H @ 0x1d;
    reg {
        name = "TEMP_OFFSET";
        desc = "TEMP_OFFSET 为对输入校正LUT 的温度码字的offset 值寄存器。 TEMP_OFFSET (offset 0x1E, total reset 0x00; PROVEN: Hi3535 data sheet, PDF page 555, section 3.8.7).";
        field {
            name = "reserved";
            desc = "Reserved";
            sw = r; hw = na;
            reset = 0x0;
        } reserved_7_6[7:6];
        field {
            name = "temp_offset";
            desc = "对输入校正LUT 的温度码字的offset 值，为补 码，表示-32～31。";
            sw = rw; hw = r;
            reset = 0x0;
        } temp_offset[5:0];
    } TEMP_OFFSET @ 0x1e;
    reg {
        name = "OUTSIDE_TEMP";
        desc = "OUTSIDE_TEMP 为外部环境温度值寄存器。 OUTSIDE_TEMP (offset 0x1F, total reset 0x00; PROVEN: Hi3535 data sheet, PDF page 556, section 3.8.7).";
        field {
            name = "outside_temp";
            desc = "外部环境温度值，码字表示-40°C～140°C。";
            sw = rw; hw = r;
            reset = 0x0;
        } outside_temp[7:0];
    } OUTSIDE_TEMP @ 0x1f;
    reg {
        name = "DIE_TEMP";
        desc = "DIE_TEMP 为RTC 内部t_sensor 提供的温度值寄存器 DIE_TEMP (offset 0x20, total reset 0x00; PROVEN: Hi3535 data sheet, PDF page 556, section 3.8.7).";
        field {
            name = "die_temp";
            desc = "RTC 内部t_sensor 提供的温度值，即芯片内部温 度，码字表示-40°C～140°C。";
            sw = r; hw = w;
            reset = 0x0;
        } die_temp[7:0];
    } DIE_TEMP @ 0x20;
    reg {
        name = "TEMP_SEL";
        desc = "TEMP_SEL 为校正输入温度选择寄存器。 TEMP_SEL (offset 0x21, total reset 0x00; PROVEN: Hi3535 data sheet, PDF page 556, section 3.8.7).";
        field {
            name = "reserved";
            desc = "Reserved.";
            sw = rw; hw = r;
            reset = 0x0;
        } reserved_7_3[7:3];
        field {
            name = "sdm_sel";
            desc = "与fix_model 和temp_sel 配合，表示是否进行温度 补偿。 芯片上电及下电时： { temp_sel,fix_mode,temp_sel } 0xx：打开温度补偿，模式由{fix_mode,temp_sel} 决定；
- 110：不进行温度补偿，RTC 时钟直接采用小数分 频后的时钟，分频系数寄存器见0x51 和0x52； 其他：保留。";
            sw = rw; hw = r;
            reset = 0x0;
        } sdm_sel[2:2];
        field {
            name = "fix_mode";
            desc = "与temp_sel 配合，表示校正算法输入温度来源。 详细描述请参见temp_sel。";
            sw = rw; hw = r;
            reset = 0x0;
        } fix_mode[1:1];
        field {
            name = "temp_sel";
            desc = "与fix_mode 配合，表示校正算法输入温度来源。 芯片上电时： {fix_mode,temp_sel}
- 00：选择DIE_TEMP 为温度来源；
- 01：选择OUTSIDE_TEMP 为温度来源； 1X：选择OUTSIDE_TEMP 为温度来源。 芯片下电时： {fix_mode,temp_sel} 0X：选择DIE_TEMP 为温度来源； 1X：选择OUTSIDE_TEMP 为温度来源。";
            sw = rw; hw = r;
            reset = 0x0;
        } temp_sel[0:0];
    } TEMP_SEL @ 0x21;
    reg {
        name = "LUT1";
        desc = "LUT1 为校正LUT1 寄存器。 LUT1 (offset 0x22, total reset 0xAC; PROVEN: Hi3535 data sheet, PDF page 557, section 3.8.7).";
        field {
            name = "lut1";
            desc = "温度校正算法的LUT1。";
            sw = rw; hw = r;
            reset = 0xac;
        } lut1[7:0];
    } LUT1 @ 0x22;
    reg {
        name = "LUT2";
        desc = "LUT2 为校正LUT2 寄存器。 LUT2 (offset 0x23, total reset 0xB4; PROVEN: Hi3535 data sheet, PDF page 558, section 3.8.7).";
        field {
            name = "lut2";
            desc = "温度校正算法的LUT2。";
            sw = rw; hw = r;
            reset = 0xb4;
        } lut2[7:0];
    } LUT2 @ 0x23;
    reg {
        name = "LUT3";
        desc = "LUT3 为校正LUT3 寄存器。 LUT3 (offset 0x24, total reset 0xBB; PROVEN: Hi3535 data sheet, PDF page 558, section 3.8.7).";
        field {
            name = "lut3";
            desc = "温度校正算法的LUT3。";
            sw = rw; hw = r;
            reset = 0xbb;
        } lut3[7:0];
    } LUT3 @ 0x24;
    reg {
        name = "LUT4";
        desc = "LUT4 为校正LUT4 寄存器。 LUT4 (offset 0x25, total reset 0xC2; PROVEN: Hi3535 data sheet, PDF page 558, section 3.8.7).";
        field {
            name = "lut4";
            desc = "温度校正算法的LUT4。";
            sw = rw; hw = r;
            reset = 0xc2;
        } lut4[7:0];
    } LUT4 @ 0x25;
    reg {
        name = "LUT5";
        desc = "LUT5 为校正LUT5 寄存器。 LUT5 (offset 0x26, total reset 0xC8; PROVEN: Hi3535 data sheet, PDF page 559, section 3.8.7).";
        field {
            name = "lut5";
            desc = "温度校正算法的LUT5。";
            sw = rw; hw = r;
            reset = 0xc8;
        } lut5[7:0];
    } LUT5 @ 0x26;
    reg {
        name = "LUT6";
        desc = "LUT6 为校正LUT6 寄存器。 LUT6 (offset 0x27, total reset 0xCF; PROVEN: Hi3535 data sheet, PDF page 559, section 3.8.7).";
        field {
            name = "lut6";
            desc = "温度校正算法的LUT6。";
            sw = rw; hw = r;
            reset = 0xcf;
        } lut6[7:0];
    } LUT6 @ 0x27;
    reg {
        name = "LUT7";
        desc = "LUT7 为校正LUT7 寄存器。 LUT7 (offset 0x28, total reset 0xD5; PROVEN: Hi3535 data sheet, PDF page 559, section 3.8.7).";
        field {
            name = "lut7";
            desc = "温度校正算法的LUT7。";
            sw = rw; hw = r;
            reset = 0xd5;
        } lut7[7:0];
    } LUT7 @ 0x28;
    reg {
        name = "LUT8";
        desc = "LUT8 为校正LUT8 寄存器。 LUT8 (offset 0x29, total reset 0xDC; PROVEN: Hi3535 data sheet, PDF page 560, section 3.8.7).";
        field {
            name = "lut8";
            desc = "温度校正算法的LUT8。";
            sw = rw; hw = r;
            reset = 0xdc;
        } lut8[7:0];
    } LUT8 @ 0x29;
    reg {
        name = "LUT9";
        desc = "LUT9 为校正LUT9 寄存器。 LUT9 (offset 0x2A, total reset 0xE2; PROVEN: Hi3535 data sheet, PDF page 560, section 3.8.7).";
        field {
            name = "lut9";
            desc = "温度校正算法的LUT9。";
            sw = rw; hw = r;
            reset = 0xe2;
        } lut9[7:0];
    } LUT9 @ 0x2a;
    reg {
        name = "LUT10";
        desc = "LUT10 为校正LUT10 寄存器。 LUT10 (offset 0x2B, total reset 0xE8; PROVEN: Hi3535 data sheet, PDF page 560, section 3.8.7).";
        field {
            name = "lut10";
            desc = "温度校正算法的LUT10。";
            sw = rw; hw = r;
            reset = 0xe8;
        } lut10[7:0];
    } LUT10 @ 0x2b;
    reg {
        name = "LUT11";
        desc = "LUT11 为校正LUT11 寄存器。 LUT11 (offset 0x2C, total reset 0xEE; PROVEN: Hi3535 data sheet, PDF page 561, section 3.8.7).";
        field {
            name = "lut11";
            desc = "温度校正算法的LUT11。";
            sw = rw; hw = r;
            reset = 0xee;
        } lut11[7:0];
    } LUT11 @ 0x2c;
    reg {
        name = "LUT12";
        desc = "LUT12 为校正LUT12 寄存器。 LUT12 (offset 0x2D, total reset 0xF3; PROVEN: Hi3535 data sheet, PDF page 561, section 3.8.7).";
        field {
            name = "lut12";
            desc = "温度校正算法的LUT12。";
            sw = rw; hw = r;
            reset = 0xf3;
        } lut12[7:0];
    } LUT12 @ 0x2d;
    reg {
        name = "LUT13";
        desc = "LUT13 为校正LUT13 寄存器。 LUT13 (offset 0x2E, total reset 0xF9; PROVEN: Hi3535 data sheet, PDF page 561, section 3.8.7).";
        field {
            name = "lut13";
            desc = "温度校正算法的LUT13。";
            sw = rw; hw = r;
            reset = 0xf9;
        } lut13[7:0];
    } LUT13 @ 0x2e;
    reg {
        name = "LUT14";
        desc = "LUT14 为校正LUT14 寄存器。 LUT14 (offset 0x2F, total reset 0xFE; PROVEN: Hi3535 data sheet, PDF page 562, section 3.8.7).";
        field {
            name = "lut14";
            desc = "温度校正算法的LUT14。";
            sw = rw; hw = r;
            reset = 0xfe;
        } lut14[7:0];
    } LUT14 @ 0x2f;
    reg {
        name = "LUT15";
        desc = "LUT15 为校正LUT15 寄存器。 LUT15 (offset 0x30, total reset 0x03; PROVEN: Hi3535 data sheet, PDF page 562, section 3.8.7).";
        field {
            name = "lut15";
            desc = "温度校正算法的LUT15。";
            sw = rw; hw = r;
            reset = 0x3;
        } lut15[7:0];
    } LUT15 @ 0x30;
    reg {
        name = "LUT16";
        desc = "LUT16 为校正LUT16 寄存器。 LUT16 (offset 0x31, total reset 0x08; PROVEN: Hi3535 data sheet, PDF page 562, section 3.8.7).";
        field {
            name = "lut16";
            desc = "温度校正算法的LUT16。";
            sw = rw; hw = r;
            reset = 0x8;
        } lut16[7:0];
    } LUT16 @ 0x31;
    reg {
        name = "LUT17";
        desc = "LUT17 为校正LUT17 寄存器。 LUT17 (offset 0x32, total reset 0x0D; PROVEN: Hi3535 data sheet, PDF page 563, section 3.8.7).";
        field {
            name = "lut17";
            desc = "温度校正算法的LUT17。";
            sw = rw; hw = r;
            reset = 0xd;
        } lut17[7:0];
    } LUT17 @ 0x32;
    reg {
        name = "LUT18";
        desc = "LUT18 为校正LUT18 寄存器。 LUT18 (offset 0x33, total reset 0x12; PROVEN: Hi3535 data sheet, PDF page 563, section 3.8.7).";
        field {
            name = "lut18";
            desc = "温度校正算法的LUT18。";
            sw = rw; hw = r;
            reset = 0x12;
        } lut18[7:0];
    } LUT18 @ 0x33;
    reg {
        name = "LUT19";
        desc = "LUT19 为校正LUT19 寄存器。 LUT19 (offset 0x34, total reset 0x17; PROVEN: Hi3535 data sheet, PDF page 563, section 3.8.7).";
        field {
            name = "lut19";
            desc = "温度校正算法的LUT19。";
            sw = rw; hw = r;
            reset = 0x17;
        } lut19[7:0];
    } LUT19 @ 0x34;
    reg {
        name = "LUT20";
        desc = "LUT20 为校正LUT20 寄存器。 LUT20 (offset 0x35, total reset 0x1B; PROVEN: Hi3535 data sheet, PDF page 564, section 3.8.7).";
        field {
            name = "lut20";
            desc = "温度校正算法的LUT20。";
            sw = rw; hw = r;
            reset = 0x1b;
        } lut20[7:0];
    } LUT20 @ 0x35;
    reg {
        name = "LUT21";
        desc = "LUT21 为校正LUT21 寄存器。 LUT21 (offset 0x36, total reset 0x1F; PROVEN: Hi3535 data sheet, PDF page 564, section 3.8.7).";
        field {
            name = "lut21";
            desc = "温度校正算法的LUT21。";
            sw = rw; hw = r;
            reset = 0x1f;
        } lut21[7:0];
    } LUT21 @ 0x36;
    reg {
        name = "LUT22";
        desc = "LUT22 为校正LUT22 寄存器。 LUT22 (offset 0x37, total reset 0x23; PROVEN: Hi3535 data sheet, PDF page 564, section 3.8.7).";
        field {
            name = "lut22";
            desc = "温度校正算法的LUT22。";
            sw = rw; hw = r;
            reset = 0x23;
        } lut22[7:0];
    } LUT22 @ 0x37;
    reg {
        name = "LUT23";
        desc = "LUT23 为校正LUT23 寄存器。 LUT23 (offset 0x38, total reset 0x27; PROVEN: Hi3535 data sheet, PDF page 565, section 3.8.7).";
        field {
            name = "lut23";
            desc = "温度校正算法的LUT23。";
            sw = rw; hw = r;
            reset = 0x27;
        } lut23[7:0];
    } LUT23 @ 0x38;
    reg {
        name = "LUT24";
        desc = "LUT24 为校正LUT24 寄存器。 LUT24 (offset 0x39, total reset 0x2B; PROVEN: Hi3535 data sheet, PDF page 565, section 3.8.7).";
        field {
            name = "lut24";
            desc = "温度校正算法的LUT24。";
            sw = rw; hw = r;
            reset = 0x2b;
        } lut24[7:0];
    } LUT24 @ 0x39;
    reg {
        name = "LUT25";
        desc = "LUT25 为校正LUT25 寄存器。 LUT25 (offset 0x3A, total reset 0x2E; PROVEN: Hi3535 data sheet, PDF page 565, section 3.8.7).";
        field {
            name = "lut25";
            desc = "温度校正算法的LUT25。";
            sw = rw; hw = r;
            reset = 0x2e;
        } lut25[7:0];
    } LUT25 @ 0x3a;
    reg {
        name = "LUT26";
        desc = "LUT26 为校正LUT26 寄存器。 LUT26 (offset 0x3B, total reset 0x32; PROVEN: Hi3535 data sheet, PDF page 566, section 3.8.7).";
        field {
            name = "lut26";
            desc = "温度校正算法的LUT26。";
            sw = rw; hw = r;
            reset = 0x32;
        } lut26[7:0];
    } LUT26 @ 0x3b;
    reg {
        name = "LUT27";
        desc = "LUT27 为校正LUT27 寄存器。 LUT27 (offset 0x3C, total reset 0x35; PROVEN: Hi3535 data sheet, PDF page 566, section 3.8.7).";
        field {
            name = "lut27";
            desc = "温度校正算法的LUT27。";
            sw = rw; hw = r;
            reset = 0x35;
        } lut27[7:0];
    } LUT27 @ 0x3c;
    reg {
        name = "LUT28";
        desc = "LUT28 为校正LUT28 寄存器。 LUT28 (offset 0x3D, total reset 0x38; PROVEN: Hi3535 data sheet, PDF page 566, section 3.8.7).";
        field {
            name = "lut28";
            desc = "温度校正算法的LUT28。";
            sw = rw; hw = r;
            reset = 0x38;
        } lut28[7:0];
    } LUT28 @ 0x3d;
    reg {
        name = "LUT29";
        desc = "LUT29 为校正LUT29 寄存器。 LUT29 (offset 0x3E, total reset 0x3B; PROVEN: Hi3535 data sheet, PDF page 567, section 3.8.7).";
        field {
            name = "lut29";
            desc = "温度校正算法的LUT29。";
            sw = rw; hw = r;
            reset = 0x3b;
        } lut29[7:0];
    } LUT29 @ 0x3e;
    reg {
        name = "LUT30";
        desc = "LUT30 为校正LUT30 寄存器。 LUT30 (offset 0x3F, total reset 0x3E; PROVEN: Hi3535 data sheet, PDF page 567, section 3.8.7).";
        field {
            name = "lut30";
            desc = "温度校正算法的LUT30。";
            sw = rw; hw = r;
            reset = 0x3e;
        } lut30[7:0];
    } LUT30 @ 0x3f;
    reg {
        name = "LUT31";
        desc = "LUT31 为校正LUT31 寄存器。 LUT31 (offset 0x40, total reset 0x41; PROVEN: Hi3535 data sheet, PDF page 567, section 3.8.7).";
        field {
            name = "lut31";
            desc = "温度校正算法的LUT31。";
            sw = rw; hw = r;
            reset = 0x41;
        } lut31[7:0];
    } LUT31 @ 0x40;
    reg {
        name = "LUT32";
        desc = "LUT32 为校正LUT32 寄存器。 LUT32 (offset 0x41, total reset 0x43; PROVEN: Hi3535 data sheet, PDF page 568, section 3.8.7).";
        field {
            name = "lut32";
            desc = "温度校正算法的LUT32。";
            sw = rw; hw = r;
            reset = 0x43;
        } lut32[7:0];
    } LUT32 @ 0x41;
    reg {
        name = "LUT33";
        desc = "LUT33 为校正LUT33 寄存器。 LUT33 (offset 0x42, total reset 0x45; PROVEN: Hi3535 data sheet, PDF page 568, section 3.8.7).";
        field {
            name = "lut33";
            desc = "温度校正算法的LUT33。";
            sw = rw; hw = r;
            reset = 0x45;
        } lut33[7:0];
    } LUT33 @ 0x42;
    reg {
        name = "LUT34";
        desc = "LUT34 为校正LUT34 寄存器。 LUT34 (offset 0x43, total reset 0x48; PROVEN: Hi3535 data sheet, PDF page 568, section 3.8.7).";
        field {
            name = "lut34";
            desc = "温度校正算法的LUT34。";
            sw = rw; hw = r;
            reset = 0x48;
        } lut34[7:0];
    } LUT34 @ 0x43;
    reg {
        name = "LUT35";
        desc = "LUT35 为校正LUT35 寄存器。 LUT35 (offset 0x44, total reset 0x4A; PROVEN: Hi3535 data sheet, PDF page 569, section 3.8.7).";
        field {
            name = "lut35";
            desc = "温度校正算法的LUT35。";
            sw = rw; hw = r;
            reset = 0x4a;
        } lut35[7:0];
    } LUT35 @ 0x44;
    reg {
        name = "LUT36";
        desc = "LUT36 为校正LUT36 寄存器。 LUT36 (offset 0x45, total reset 0x4B; PROVEN: Hi3535 data sheet, PDF page 569, section 3.8.7).";
        field {
            name = "lut36";
            desc = "温度校正算法的LUT36。";
            sw = rw; hw = r;
            reset = 0x4b;
        } lut36[7:0];
    } LUT36 @ 0x45;
    reg {
        name = "LUT37";
        desc = "LUT37 为校正LUT37 寄存器。 LUT37 (offset 0x46, total reset 0x4D; PROVEN: Hi3535 data sheet, PDF page 569, section 3.8.7).";
        field {
            name = "lut37";
            desc = "温度校正算法的LUT37。";
            sw = rw; hw = r;
            reset = 0x4d;
        } lut37[7:0];
    } LUT37 @ 0x46;
    reg {
        name = "LUT38";
        desc = "LUT38 为校正LUT38 寄存器。 LUT38 (offset 0x47, total reset 0x4F; PROVEN: Hi3535 data sheet, PDF page 570, section 3.8.7).";
        field {
            name = "lut38";
            desc = "温度校正算法的LUT38。";
            sw = rw; hw = r;
            reset = 0x4f;
        } lut38[7:0];
    } LUT38 @ 0x47;
    reg {
        name = "LUT39";
        desc = "LUT39 为校正LUT39 寄存器。 LUT39 (offset 0x48, total reset 0x50; PROVEN: Hi3535 data sheet, PDF page 570, section 3.8.7).";
        field {
            name = "lut39";
            desc = "温度校正算法的LUT39。";
            sw = rw; hw = r;
            reset = 0x50;
        } lut39[7:0];
    } LUT39 @ 0x48;
    reg {
        name = "LUT40";
        desc = "LUT40 为校正LUT40 寄存器。 LUT40 (offset 0x49, total reset 0x51; PROVEN: Hi3535 data sheet, PDF page 570, section 3.8.7).";
        field {
            name = "lut40";
            desc = "温度校正算法的LUT40。";
            sw = rw; hw = r;
            reset = 0x51;
        } lut40[7:0];
    } LUT40 @ 0x49;
    reg {
        name = "LUT41";
        desc = "LUT41 为校正LUT41 寄存器。 LUT41 (offset 0x4A, total reset 0x52; PROVEN: Hi3535 data sheet, PDF page 571, section 3.8.7).";
        field {
            name = "lut41";
            desc = "温度校正算法的LUT41。";
            sw = rw; hw = r;
            reset = 0x52;
        } lut41[7:0];
    } LUT41 @ 0x4a;
    reg {
        name = "LUT42";
        desc = "LUT42 为校正LUT42 寄存器。 LUT42 (offset 0x4B, total reset 0x53; PROVEN: Hi3535 data sheet, PDF page 571, section 3.8.7).";
        field {
            name = "lut42";
            desc = "温度校正算法的LUT42。";
            sw = rw; hw = r;
            reset = 0x53;
        } lut42[7:0];
    } LUT42 @ 0x4b;
    reg {
        name = "LUT43";
        desc = "LUT43 为校正LUT43 寄存器。 LUT43 (offset 0x4C, total reset 0x54; PROVEN: Hi3535 data sheet, PDF page 571, section 3.8.7).";
        field {
            name = "lut43";
            desc = "温度校正算法的LUT43。";
            sw = rw; hw = r;
            reset = 0x54;
        } lut43[7:0];
    } LUT43 @ 0x4c;
    reg {
        name = "LUT44";
        desc = "LUT44 为校正LUT44 寄存器。 LUT44 (offset 0x4D, total reset 0x54; PROVEN: Hi3535 data sheet, PDF page 572, section 3.8.7).";
        field {
            name = "lut44";
            desc = "温度校正算法的LUT44。";
            sw = rw; hw = r;
            reset = 0x54;
        } lut44[7:0];
    } LUT44 @ 0x4d;
    reg {
        name = "LUT45";
        desc = "LUT45 为校正LUT45 寄存器。 LUT45 (offset 0x4E, total reset 0x55; PROVEN: Hi3535 data sheet, PDF page 572, section 3.8.7).";
        field {
            name = "lut45";
            desc = "温度校正算法的LUT45。";
            sw = rw; hw = r;
            reset = 0x55;
        } lut45[7:0];
    } LUT45 @ 0x4e;
    reg {
        name = "LUT46";
        desc = "LUT46 为校正LUT46 寄存器。 LUT46 (offset 0x4F, total reset 0x55; PROVEN: Hi3535 data sheet, PDF page 572, section 3.8.7).";
        field {
            name = "lut46";
            desc = "温度校正算法的LUT46。";
            sw = rw; hw = r;
            reset = 0x55;
        } lut46[7:0];
    } LUT46 @ 0x4f;
    reg {
        name = "LUT47";
        desc = "LUT47 为校正LUT47 寄存器。 LUT47 (offset 0x50, total reset 0x55; PROVEN: Hi3535 data sheet, PDF page 573, section 3.8.7).";
        field {
            name = "lut47";
            desc = "温度校正算法的LUT47。";
            sw = rw; hw = r;
            reset = 0x55;
        } lut47[7:0];
    } LUT47 @ 0x50;
    reg {
        name = "SDM_COEF_OUSIDE_H";
        desc = "SDM_COEF_OUSIDE_H 为外部分频系数高4 位寄存器。 SDM_COEF_OUSIDE_H (offset 0x51, total reset 0x8; PROVEN: Hi3535 data sheet, PDF page 573, section 3.8.7).";
        field {
            name = "reserved";
            desc = "Reserved.";
            sw = r; hw = w;
            reset = 0x0;
        } reserved_7_4[7:4];
        field {
            name = "sdm_coef_ouside_h";
            desc = "固定分频模式时的分频系数高4 位。";
            sw = rw; hw = r;
            reset = 0x8;
        } sdm_coef_ouside_h[3:0];
    } SDM_COEF_OUSIDE_H @ 0x51;
    reg {
        name = "SDM_COEF_OUSIDE_L";
        desc = "SDM_COEF_OUSIDE_L 为外部分频系数低8 位寄存器。 SDM_COEF_OUSIDE_L (offset 0x52, total reset 0x1B; PROVEN: Hi3535 data sheet, PDF page 573, section 3.8.7).";
        field {
            name = "Sdm_coef_ouside_l";
            desc = "固定分频模式时的分频系数低8 位。 注意：对分频系数寄存器（0x51、0x52）进行读/ 写时，应该先读/写高4 位，再读/写低8 位，并且 需要高位到低位连续操作才能完成读/写操作。";
            sw = rw; hw = r;
            reset = 0x1b;
        } Sdm_coef_ouside_l[7:0];
    } SDM_COEF_OUSIDE_L @ 0x52;
    reg {
        name = "USER_REGISTER1";
        desc = "USER_REGISTER1 为64bit 用户使用寄存器1。 USER_REGISTER1 (offset 0x53, total reset 0x0; PROVEN: Hi3535 data sheet, PDF page 574, section 3.8.7).";
        field {
            name = "user_register1";
            desc = "64bit 用户使用寄存器1，对应bit[7:0]。";
            sw = rw; hw = r;
            reset = 0x0;
        } user_register1[7:0];
    } USER_REGISTER1 @ 0x53;
    reg {
        name = "USER_REGISTER2";
        desc = "USER_REGISTER2 为64bit 用户使用寄存器2。 USER_REGISTER2 (offset 0x54, total reset 0x0; PROVEN: Hi3535 data sheet, PDF page 574, section 3.8.7).";
        field {
            name = "user_register2";
            desc = "64bit 用户使用寄存器2，对应bit[15:8]。";
            sw = rw; hw = r;
            reset = 0x0;
        } user_register2[7:0];
    } USER_REGISTER2 @ 0x54;
    reg {
        name = "USER_REGISTER3";
        desc = "USER_REGISTER3 为64bit 用户使用寄存器3。 USER_REGISTER3 (offset 0x55, total reset 0x0; PROVEN: Hi3535 data sheet, PDF page 574, section 3.8.7).";
        field {
            name = "user_register3";
            desc = "64bit 用户使用寄存器3，对应bit[23:16]。";
            sw = rw; hw = r;
            reset = 0x0;
        } user_register3[7:0];
    } USER_REGISTER3 @ 0x55;
    reg {
        name = "USER_REGISTER4";
        desc = "USER_REGISTER4 为64bit 用户使用寄存器4。 USER_REGISTER4 (offset 0x56, total reset 0x0; PROVEN: Hi3535 data sheet, PDF page 575, section 3.8.7).";
        field {
            name = "user_register4";
            desc = "64bit 用户使用寄存器4，对应bit[31:24]。";
            sw = rw; hw = r;
            reset = 0x0;
        } user_register4[7:0];
    } USER_REGISTER4 @ 0x56;
    reg {
        name = "USER_REGISTER5";
        desc = "USER_REGISTER5 为64bit 用户使用寄存器5。 USER_REGISTER5 (offset 0x57, total reset 0x0; PROVEN: Hi3535 data sheet, PDF page 575, section 3.8.7).";
        field {
            name = "user_register5";
            desc = "64bit 用户使用寄存器5，对应bit[39:32]。";
            sw = rw; hw = r;
            reset = 0x0;
        } user_register5[7:0];
    } USER_REGISTER5 @ 0x57;
    reg {
        name = "USER_REGISTER6";
        desc = "USER_REGISTER6 为64bit 用户使用寄存器6。 USER_REGISTER6 (offset 0x58, total reset 0x0; PROVEN: Hi3535 data sheet, PDF page 575, section 3.8.7).";
        field {
            name = "user_register6";
            desc = "64bit 用户使用寄存器6，对应bit[47:40]。";
            sw = rw; hw = r;
            reset = 0x0;
        } user_register6[7:0];
    } USER_REGISTER6 @ 0x58;
    reg {
        name = "USER_REGISTER7";
        desc = "USER_REGISTER7 为64bit 用户使用寄存器7。 USER_REGISTER7 (offset 0x59, total reset 0x0; PROVEN: Hi3535 data sheet, PDF page 576, section 3.8.7).";
        field {
            name = "user_register7";
            desc = "64bit 用户使用寄存器7，对应bit[55:48]。";
            sw = rw; hw = r;
            reset = 0x0;
        } user_register7[7:0];
    } USER_REGISTER7 @ 0x59;
    reg {
        name = "USER_REGISTER8";
        desc = "USER_REGISTER8 为64bit 用户使用寄存器8。 USER_REGISTER8 (offset 0x5A, total reset 0x0; PROVEN: Hi3535 data sheet, PDF page 576, section 3.8.7).";
        field {
            name = "user_register8";
            desc = "64bit 用户使用寄存器8，对应bit[63:56]。";
            sw = rw; hw = r;
            reset = 0x0;
        } user_register8[7:0];
    } USER_REGISTER8 @ 0x5a;
};

`endif
