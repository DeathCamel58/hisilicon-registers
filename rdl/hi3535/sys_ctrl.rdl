`ifndef EHI3535_SYS_CTRL_RDL
`define EHI3535_SYS_CTRL_RDL
regfile eHI3535_SYS_CTRL {
    name = "System controller (SC)";
    desc = "System controller (SC). 34 registers extracted programmatically from the Hi3535 H.264 codec processor (Hi3535 user guide) data sheet (Issue 00B08, 2014-02-25); chapter 3.4.4, table 3-26. Field names, bit ranges, access types and reset values are taken from the register tables; reset values are the data sheet total reset values split onto the fields (per-field values where the table has them). Label: PROVEN. Hardware not verified here (no board).";
    reg {
        name = "SC_CTRL";
        desc = "SC_CTRL is the system control register. It specifies the operations the system needs to perform. This register can be write-protected by the SC_PERLOCK register; writes to this register are effective only when write protection is not in use. SC_CTRL (offset 0x000, total reset 0x0000_0212; PROVEN: Hi3535 data sheet, PDF page 396, section 3.4.4.2).";
        field {
            name = "timeren7ov";
            desc = "Timer7 count clock select.
- 0: Count with the 3MHz clock.
- 1: Count with the bus clock.";
            sw = rw; hw = r;
            reset = 0x0;
        } timeren7ov[31:31];
        field {
            name = "reserved";
            desc = "Reserved.";
            sw = rw; hw = r;
            reset = 0x0;
        } reserved_30_30[30:30];
        field {
            name = "timeren6ov";
            desc = "Timer6 count clock select.
- 0: Count using the 3MHz clock;
- 1: Count using the bus clock.";
            sw = rw; hw = r;
            reset = 0x0;
        } timeren6ov[29:29];
        field {
            name = "reserved";
            desc = "Reserved.";
            sw = rw; hw = r;
            reset = 0x0;
        } reserved_28_28[28:28];
        field {
            name = "timeren5ov";
            desc = "Timer5 count clock select.
- 0: Count with the 3MHz clock;
- 1: Count with the bus clock.";
            sw = rw; hw = r;
            reset = 0x0;
        } timeren5ov[27:27];
        field {
            name = "reserved";
            desc = "Reserved.";
            sw = rw; hw = r;
            reset = 0x0;
        } reserved_26_26[26:26];
        field {
            name = "timeren4ov";
            desc = "Timer4 counting clock select.
- 0: Count with the 3 MHz clock.
- 1: Count with the bus clock.";
            sw = rw; hw = r;
            reset = 0x0;
        } timeren4ov[25:25];
        field {
            name = "reserved";
            desc = "Reserved.";
            sw = rw; hw = r;
            reset = 0x0;
        } reserved_24_24[24:24];
        field {
            name = "wdogenov";
            desc = "WDG count clock selection.
- 0: WDG counts with the 3MHz clock;
- 1: WDG counts with the bus clock.";
            sw = rw; hw = r;
            reset = 0x0;
        } wdogenov[23:23];
        field {
            name = "timeren3ov";
            desc = "Timer3 count clock selection.
- 0: Count with the 3MHz clock;
- 1: Count with the bus clock.";
            sw = rw; hw = r;
            reset = 0x0;
        } timeren3ov[22:22];
        field {
            name = "reserved";
            desc = "Reserved.";
            sw = r; hw = w;
            reset = 0x0;
        } reserved_21_21[21:21];
        field {
            name = "timeren2ov";
            desc = "Timer2 count clock select.
- 0: Count using the 3MHz clock;
- 1: Count using the bus clock.";
            sw = rw; hw = r;
            reset = 0x0;
        } timeren2ov[20:20];
        field {
            name = "reserved";
            desc = "Reserved.";
            sw = rw; hw = r;
            reset = 0x0;
        } reserved_19_19[19:19];
        field {
            name = "timeren1ov";
            desc = "Timer1 count clock select.
- 0: Count using the 3MHz clock;
- 1: Count using the bus clock.";
            sw = rw; hw = r;
            reset = 0x0;
        } timeren1ov[18:18];
        field {
            name = "reserved";
            desc = "Reserved.";
            sw = rw; hw = r;
            reset = 0x0;
        } reserved_17_17[17:17];
        field {
            name = "timeren0ov";
            desc = "Timer0 count clock select.
- 0: Count with the 3MHz clock;
- 1: Count with the bus clock.";
            sw = rw; hw = r;
            reset = 0x0;
        } timeren0ov[16:16];
        field {
            name = "reserved";
            desc = "Reserved.";
            sw = rw; hw = r;
            reset = 0x0;
        } reserved_15_15[15:15];
        field {
            name = "reserved";
            desc = "Reserved. Reads return 0; writes have no effect.";
            sw = r; hw = w;
            reset = 0x0;
        } reserved_14_10[14:10];
        field {
            name = "remapstat";
            desc = "Address remap status.
- 0: Address remap not performed;
- 1: Address remap performed. The Bootrom, NANDC CS0, or SFC CS1 is remapped to address 0.";
            sw = r; hw = w;
            reset = 0x1;
        } remapstat[9:9];
        field {
            name = "remapclear";
            desc = "Address remap clear select.
- 0: Keep the Remap state.
- 1: Clear Remap.

For the address mapping before and after Clear Remap, see the address allocation (1 Product Overview / 1.3 Boot Modes / 1.3.4 Address Space Mapping).";
            sw = rw; hw = r;
            reset = 0x0;
        } remapclear[8:8];
        field {
            name = "reserved";
            desc = "Reserved. Reads return 0; writes have no effect.";
            sw = r; hw = w;
            reset = 0x0;
        } reserved_7_7[7:7];
        field {
            name = "modestatus";
            desc = "Mode status bits. Returns the current operating mode of the system.
- 0x0: Reserved.
- 0x1: DOZE.
- 0x2: SLOW.
- 0x3: XTAL CTL.
- 0x4: NORMAL.
- 0x6: PLL CTL.
- 0x9: SW from XTAL.
- 0xA: SW from PLL.
- 0xB: SW to XTAL.
- 0xE: SW to PLL. Others: Reserved, unused.";
            sw = rw; hw = r;
            reset = 0x2;
        } modestatus[6:3];
        field {
            name = "modectrl";
            desc = "Mode control bits. Define the operating mode that the system controller is required to enter.
- 001: DOZE;
- 010: SLOW;
- 100: NORMAL; Others: Reserved.";
            sw = rw; hw = r;
            reset = 0x2;
        } modectrl[2:0];
    } SC_CTRL @ 0x0;
    reg {
        name = "SC_SYSRES";
        desc = "SC_SYSRES is the system soft reset register. Writing any value to this register makes the system controller issue a system soft reset request to the reset module, which performs a system soft reset. This register can be write-protected by the SC_PERLOCK register; writes to this register are valid only when write protection is disabled. SC_SYSRES (offset 0x004, total reset 0x0000_0002; PROVEN: Hi3535 data sheet, PDF page 398, section 3.4.4.2).";
        field {
            name = "softresreq";
            desc = "Any write to this register causes a system soft reset.";
            sw = w; hw = r;
            reset = 0x2;
        } softresreq[31:0];
    } SC_SYSRES @ 0x4;
    reg {
        name = "SC_IMCTRL";
        desc = "SC_IMCTRL is the interrupt mode control register. It controls the system mode when an interrupt occurs. SC_IMCTRL (offset 0x008, total reset 0x0000_0000; PROVEN: Hi3535 data sheet, PDF page 399, section 3.4.4.2).";
        field {
            name = "reserved";
            desc = "Reserved. Reads return 0x000000; writes have no effect.";
            sw = r; hw = w;
            reset = 0x0;
        } reserved_31_8[31:8];
        field {
            name = "inmdtype";
            desc = "Interrupt type that triggers the system to enter interrupt mode.
- 0: Only an FIQ interrupt can make the system enter interrupt mode.
- 1: Both FIQ and IRQ interrupts can make the system enter interrupt mode.";
            sw = rw; hw = r;
            reset = 0x0;
        } inmdtype[7:7];
        field {
            name = "reserved";
            desc = "Reserved.";
            sw = r; hw = w;
            reset = 0x0;
        } reserved_6_4[6:4];
        field {
            name = "itmdctrl";
            desc = "Lowest operating mode of the system in interrupt mode. The value of this register is ORed with the value of SC_CTRL[modectrl] to give the operating mode of the system after an interrupt occurs. Defined as follows:
- 000: SLEEP;
- 001: DOZE; 01X: SLOW; 1XX: NORMAL.";
            sw = rw; hw = r;
            reset = 0x0;
        } itmdctrl[3:1];
        field {
            name = "itmden";
            desc = "Interrupt mode enable.
- 0: Disable;
- 1: Enable (enter interrupt mode when an interrupt occurs).";
            sw = rw; hw = r;
            reset = 0x0;
        } itmden[0:0];
    } SC_IMCTRL @ 0x8;
    reg {
        name = "SC_IMSTAT";
        desc = "SC_IMSTAT is the interrupt mode status register. It monitors whether the system is in interrupt mode, and the system can also be forced into interrupt mode by configuring this register. The interrupt mode must be cleared manually when the interrupt service routine ends. SC_IMSTAT (offset 0x00C, total reset 0x0000_0000; PROVEN: Hi3535 data sheet, PDF page 400, section 3.4.4.2).";
        field {
            name = "reserved";
            desc = "Reserved. Reads return 0x00000000; writes have no effect.";
            sw = r; hw = w;
            reset = 0x0;
        } reserved_31_1[31:1];
        field {
            name = "itmdstat";
            desc = "Interrupt mode status. Can be used by software to enter interrupt mode directly. When reading this register:
- 0: Not currently in interrupt mode.
- 1: Currently in interrupt mode. When writing this register:
- 0: Software does not control entering interrupt mode.
- 1: Software controls entering interrupt mode.";
            sw = rw; hw = r;
            reset = 0x0;
        } itmdstat[0:0];
    } SC_IMSTAT @ 0xc;
    reg {
        name = "SC_XTALCTRL";
        desc = "SC_XTALCTRL is the crystal control register. It controls the stabilization wait time of the clock module during initialization, that is, the wait time for the transition from the XTAL CTL intermediate state to the SW to XTAL intermediate state. SC_XTALCTRL (offset 0x010, total reset 0x0000_0000; PROVEN: Hi3535 data sheet, PDF page 400, section 3.4.4.2).";
        field {
            name = "reserved";
            desc = "Reserved; returns 0x0000 on read, writes have no effect.";
            sw = r; hw = w;
            reset = 0x0;
        } reserved_31_19[31:19];
        field {
            name = "xtaltime";
            desc = "Crystal oscillator switching wait time. The value of this field specifies the wait time for the transition from the XTAL CTL state to the SW to XTAL state during system mode switching. The number of wait cycles can be calculated (T46.8K is the period of the 46.8KHz low-frequency clock): (65536 - xtaltime) x T46.8K.";
            sw = rw; hw = r;
            reset = 0x0;
        } xtaltime[18:3];
        field {
            name = "reserved";
            desc = "Reserved. Reads return 0x0; writes have no effect.";
            sw = r; hw = w;
            reset = 0x0;
        } reserved_2_2[2:2];
        field {
            name = "reserved";
            desc = "Reserved. Reads return the written value; writes have no effect.";
            sw = r; hw = w;
            reset = 0x0;
        } reserved_1_0[1:0];
    } SC_XTALCTRL @ 0x10;
    reg {
        name = "SC_PLLCTRL";
        desc = "SC_PLLCTRL is the PLL control register. It controls enabling of the on-chip ARM PLL (ARMPLL), either enabled by software or controlled by system mode switching. It also sets the ARMPLL stabilization wait time. This register can be write-protected by the SC_PERLOCK register; writes to this register take effect only when write protection is disabled. When in \"ARMPLL enable controlled by system mode switching\" (controlled by SC_PLLCTRL[pllover]), the ARMPLL is turned off automatically when the system is not in NORMAL mode. When in \"ARMPLL enable controlled by software\", the ARMPLL enable is controlled by software (by SC_PLLCTRL[pllen]) and is not affected by mode switching. The ARMPLL clock frequency is controlled by the CRG registers PERI_CRG0 and PERI_CRG1. The system requires the PLL to wait 0.5 ms after a frequency configuration change before it outputs a stable clock. Therefore the plltime configuration of this register must meet this requirement. SC_PLLCTRL (offset 0x014, total reset 0x0000_0000; PROVEN: Hi3535 data sheet, PDF page 401, section 3.4.4.2).";
        field {
            name = "reserved";
            desc = "Reserved. Reads return 0x0; writes have no effect.";
            sw = r; hw = w;
            reset = 0x0;
        } reserved_31_28[31:28];
        field {
            name = "plltime";
            desc = "ARMPLL lock stabilization wait time. This time is used to wait from PLL startup until the PLL output reaches a stable state, that is, the wait time for the transition from the PLL CTL state to the SW to PLL state when switching the system mode. The timeout value is calculated as follows (TXIN is the clock period of the crystal connected to the chip): (33554432 - plltime) x TXIN.";
            sw = rw; hw = r;
            reset = 0x0;
        } plltime[27:3];
        field {
            name = "reserved";
            desc = "Reserved. Reads return 0x0; writes have no effect.";
            sw = r; hw = w;
            reset = 0x0;
        } reserved_2_2[2:2];
        field {
            name = "reserved";
            desc = "Reserved.";
            sw = r; hw = w;
            reset = 0x0;
        } reserved_1_1[1:1];
        field {
            name = "pllover";
            desc = "Allows the ARMPLL to be enabled directly under software control rather than by system mode state changes. Must be configured as 0.
- 0: The ARMPLL is enabled by system mode switching.
- 1: Reserved.";
            sw = rw; hw = r;
            reset = 0x0;
        } pllover[0:0];
    } SC_PLLCTRL @ 0x14;
    reg {
        name = "SOLFINT";
        desc = "SOLFINT is the software interrupt register. SOLFINT (offset 0x001C, total reset 0x0000_0000; PROVEN: Hi3535 data sheet, PDF page 402, section 3.4.4.2).";
        field {
            name = "reserved";
            desc = "Reserved";
            sw = r; hw = w;
            reset = 0x0;
        } reserved_31_1[31:1];
        field {
            name = "software_int";
            desc = "Software interrupt.
- 0: No interrupt generated;
- 1: Interrupt generated.";
            sw = rw; hw = r;
            reset = 0x0;
        } software_int[0:0];
    } SOLFINT @ 0x1c;
    reg {
        name = "SOLFTYPE";
        desc = "SOLFTYPE is the software interrupt vector register. SOLFTYPE (offset 0x0020, total reset 0x0000_0000; PROVEN: Hi3535 data sheet, PDF page 402, section 3.4.4.2).";
        field {
            name = "field_31_0";
            desc = " (field name not recoverable from the data sheet text layer: see the data sheet page)";
            sw = r; hw = w;
            reset = 0x0;
        } field_31_0[31:0];
    } SOLFTYPE @ 0x20;
    reg {
        name = "SC_LOCKEN";
        desc = "SC_LOCKEN is the lock register for the key system control registers. SC_LOCKEN (offset 0x0044, total reset 0x0000_0000; PROVEN: Hi3535 data sheet, PDF page 403, section 3.4.4.2).";
        field {
            name = "scper_lockl";
            desc = "Lock register for the key system control registers. The registers involved include SC_CTRL, SC_SYSSTAT, SC_PLLCTRL and SC_PLLFCTRL. Writing 0x1ACC_E551 to this register opens write access to all of them; writing any other value closes write access. Reading this register returns the lock status rather than the value written. 0x0000_0000: The above write accesses are allowed (unlocked). 0x0000_0001: The above write accesses are prohibited (locked).";
            sw = rw; hw = r;
            reset = 0x0;
        } scper_lockl[31:0];
    } SC_LOCKEN @ 0x44;
    reg {
        name = "SYSSTAT";
        desc = "SYSSTAT is the system status register. SYSSTAT (offset 0x008C, total reset 0x0000_0000; PROVEN: Hi3535 data sheet, PDF page 403, section 3.4.4.2).";
        field {
            name = "bootrom_sel_in";
            desc = "Indicates whether booting from the bootrom.
- 0: Not booting from the bootrom;
- 1: Booting from the bootrom.";
            sw = r; hw = w;
            reset = 0x0;
        } bootrom_sel_in[31:31];
        field {
            name = "reserved";
            desc = "Reserved.";
            sw = r; hw = w;
            reset = 0x0;
        } reserved_30_30[30:30];
        field {
            name = "a9_standbywfe";
            desc = "Indicates whether the A9 processor is in the WFE state.
- 0: Not in the WFE state;
- 1: In the WFE state. a9_standbywfe[1] represents core1 and a9_standbywfe[0] represents core0.";
            sw = r; hw = w;
            reset = 0x0;
        } a9_standbywfe[29:28];
        field {
            name = "a9_standbywfi";
            desc = "Indicates whether the A9 processor is in the WFI state.
- 0: Not in the WFI state;
- 1: In the WFI state.
a9_standbywfi[1] represents core1 and a9_standbywfi[0] represents core0.";
            sw = r; hw = w;
            reset = 0x0;
        } a9_standbywfi[27:26];
        field {
            name = "a9_pmupri";
            desc = "Indicates the A9 processor status.
- 0: In user mode;
- 1: In privileged mode.
a9_pmupri[1] is for core1, a9_pmupri[0] is for core0.";
            sw = r; hw = w;
            reset = 0x0;
        } a9_pmupri[25:24];
        field {
            name = "a9_pmusecure";
            desc = "Indicates the security state of the A9 processor.
- 0: Non-secure state.
- 1: Secure state. a9_pmusecure[1] indicates core1 and a9_pmusecure[0] indicates core0.";
            sw = r; hw = w;
            reset = 0x0;
        } a9_pmusecure[23:22];
        field {
            name = "a9_smpnamp";
            desc = "Indicates whether the A9 processor is in symmetric or asymmetric mode.
- 0: Asymmetric.
- 1: Symmetric. a9_smpnamp[1] indicates core1 and a9_smpnamp[0] indicates core0.";
            sw = r; hw = w;
            reset = 0x0;
        } a9_smpnamp[21:20];
        field {
            name = "jtag_sel";
            desc = "JTAG test select.
- 000: USB 3.0.
- 001: SATA PHY0.
- 010: SATA PHY1.
- 011: COMB PHY. 1XX: A9. Others: Reserved.";
            sw = r; hw = w;
            reset = 0x0;
        } jtag_sel[19:17];
        field {
            name = "nf_addr_num";
            desc = "Number of address cycles sent to the NAND Flash device. Note: valid only at the moment of power-on.
- 0: 4;
- 1: 5.";
            sw = r; hw = w;
            reset = 0x0;
        } nf_addr_num[16:16];
        field {
            name = "nf_block_size";
            desc = "Block size of the Nand Flash device at boot.
- 00: 64 pages;
- 01: 128 pages;
- 10: 256 pages;
- 11: Reserved;";
            sw = r; hw = w;
            reset = 0x0;
        } nf_block_size[15:14];
        field {
            name = "nf_ecc_type";
            desc = "Nand Flash ECC mode selected at boot.
- 000: No ECC.
- 010: 4bit mode.
- 011: 8bit mode.
- 100: 24bit mode. Others: Reserved.";
            sw = r; hw = w;
            reset = 0x0;
        } nf_ecc_type[13:11];
        field {
            name = "nf_page";
            desc = "Page size of the Nand Flash device at boot.
- 001: 2KB;
- 010: 4KB;
- 011: 8KB;
Others: Reserved.";
            sw = r; hw = w;
            reset = 0x0;
        } nf_page[10:8];
        field {
            name = "sfc_addr_mode";
            desc = "SPI FLASH default operating address mode.
- 0: 3-byte address mode;
- 1: 4-byte address mode.";
            sw = r; hw = w;
            reset = 0x0;
        } sfc_addr_mode[7:7];
        field {
            name = "reserved";
            desc = "Reserved.";
            sw = r; hw = w;
            reset = 0x0;
        } reserved_6_6[6:6];
        field {
            name = "boot_mode";
            desc = "Boot mode selected by the chip.
- 00: Boot from SPI Flash.
- 01: Load into DDR through PCIE and boot from DDR.
- 10: Boot from NANDFlash.
- 11: Reserved.";
            sw = r; hw = w;
            reset = 0x0;
        } boot_mode[5:4];
        field {
            name = "reserved";
            desc = "Reserved.";
            sw = rw; hw = r;
            reset = 0x0;
        } reserved_3_0[3:0];
    } SYSSTAT @ 0x8c;
    reg {
        name = "DDRT0";
        desc = "DDRT0 is DDR Training dedicated register 0. This register is not reset by a system soft reset. DDRT0 (offset 0x0090, total reset 0x0000_0000; PROVEN: Hi3535 data sheet, PDF page 406, section 3.4.4.2).";
        field {
            name = "ddrt0";
            desc = "DDR Training dedicated register 0.";
            sw = rw; hw = r;
            reset = 0x0;
        } ddrt0[31:0];
    } DDRT0 @ 0x90;
    reg {
        name = "DDRT1";
        desc = "DDRT1 is DDR Training dedicated register 1. This register is not reset by a system soft reset. DDRT1 (offset 0x0094, total reset 0x0000_0000; PROVEN: Hi3535 data sheet, PDF page 406, section 3.4.4.2).";
        field {
            name = "ddrt1";
            desc = "DDR Training dedicated register 1.";
            sw = rw; hw = r;
            reset = 0x0;
        } ddrt1[31:0];
    } DDRT1 @ 0x94;
    reg {
        name = "DDRT2";
        desc = "DDRT2 is DDR Training dedicated register 2. This register is not reset by a system soft reset. DDRT2 (offset 0x0098, total reset 0x0000_0000; PROVEN: Hi3535 data sheet, PDF page 407, section 3.4.4.2).";
        field {
            name = "ddrt2";
            desc = "DDR Training dedicated register 2.";
            sw = rw; hw = r;
            reset = 0x0;
        } ddrt2[31:0];
    } DDRT2 @ 0x98;
    reg {
        name = "DDRT3";
        desc = "DDRT3 is DDR Training dedicated register 3. This register is not reset by a system soft reset. DDRT3 (offset 0x009C, total reset 0x0000_0000; PROVEN: Hi3535 data sheet, PDF page 407, section 3.4.4.2).";
        field {
            name = "ddrt3";
            desc = "DDR Training dedicated register 3.";
            sw = rw; hw = r;
            reset = 0x0;
        } ddrt3[31:0];
    } DDRT3 @ 0x9c;
    reg {
        name = "DDRT4";
        desc = "DDRT4 is DDR Training dedicated register 4. This register is not reset by a system soft reset. DDRT4 (offset 0x00A0, total reset 0x0000_0000; PROVEN: Hi3535 data sheet, PDF page 408, section 3.4.4.2).";
        field {
            name = "ddrt4";
            desc = "DDR Training dedicated register 4.";
            sw = rw; hw = r;
            reset = 0x0;
        } ddrt4[31:0];
    } DDRT4 @ 0xa0;
    reg {
        name = "DDRT5";
        desc = "DDRT5 is DDR Training dedicated register 5. This register is not reset by a system soft reset. DDRT5 (offset 0x00A4, total reset 0x0000_0000; PROVEN: Hi3535 data sheet, PDF page 408, section 3.4.4.2).";
        field {
            name = "ddrt5";
            desc = "DDR Training dedicated register 5.";
            sw = rw; hw = r;
            reset = 0x0;
        } ddrt5[31:0];
    } DDRT5 @ 0xa4;
    reg {
        name = "DDRT6";
        desc = "DDRT6 is DDR Training dedicated register 6. This register is not reset by a system soft reset. DDRT6 (offset 0x00A8, total reset 0x0000_0000; PROVEN: Hi3535 data sheet, PDF page 409, section 3.4.4.2).";
        field {
            name = "ddrt6";
            desc = "DDR Training dedicated register 6.";
            sw = rw; hw = r;
            reset = 0x0;
        } ddrt6[31:0];
    } DDRT6 @ 0xa8;
    reg {
        name = "DDRT7";
        desc = "DDRT7 is DDR Training dedicated register 7. This register is not reset by a system soft reset. DDRT7 (offset 0x00AC, total reset 0x0000_0000; PROVEN: Hi3535 data sheet, PDF page 409, section 3.4.4.2).";
        field {
            name = "ddrt7";
            desc = "DDR Training dedicated register 7.";
            sw = rw; hw = r;
            reset = 0x0;
        } ddrt7[31:0];
    } DDRT7 @ 0xac;
    reg {
        name = "SYSBOOT0";
        desc = "SYSBOOT0 is system boot dedicated register 0. SYSBOOT0 (offset 0x0130, total reset 0x0000_0000; PROVEN: Hi3535 data sheet, PDF page 409, section 3.4.4.2).";
        field {
            name = "sysboot0";
            desc = "System boot dedicated register 0.";
            sw = rw; hw = r;
            reset = 0x0;
        } sysboot0[31:0];
    } SYSBOOT0 @ 0x130;
    reg {
        name = "SYSBOOT1";
        desc = "SYSBOOT1 is system boot dedicated register 1. SYSBOOT1 (offset 0x0134, total reset 0x0000_0000; PROVEN: Hi3535 data sheet, PDF page 410, section 3.4.4.2).";
        field {
            name = "sysboot1";
            desc = "System boot dedicated register 1.";
            sw = rw; hw = r;
            reset = 0x0;
        } sysboot1[31:0];
    } SYSBOOT1 @ 0x134;
    reg {
        name = "SYSBOOT2";
        desc = "SYSBOOT2 is system boot dedicated register 2. SYSBOOT2 (offset 0x0138, total reset 0x0000_0000; PROVEN: Hi3535 data sheet, PDF page 410, section 3.4.4.2).";
        field {
            name = "sysboot2";
            desc = "System boot dedicated register 2.";
            sw = rw; hw = r;
            reset = 0x0;
        } sysboot2[31:0];
    } SYSBOOT2 @ 0x138;
    reg {
        name = "SYSBOOT3";
        desc = "SYSBOOT3 is system boot dedicated register 3. SYSBOOT3 (offset 0x013C, total reset 0x0000_0000; PROVEN: Hi3535 data sheet, PDF page 410, section 3.4.4.2).";
        field {
            name = "sysboot3";
            desc = "System boot dedicated register 3.";
            sw = rw; hw = r;
            reset = 0x0;
        } sysboot3[31:0];
    } SYSBOOT3 @ 0x13c;
    reg {
        name = "SYSBOOT4";
        desc = "SYSBOOT4 is system boot dedicated register 4. SYSBOOT4 (offset 0x0140, total reset 0x0000_0000; PROVEN: Hi3535 data sheet, PDF page 411, section 3.4.4.2).";
        field {
            name = "sysboot4";
            desc = "System boot dedicated register 4.";
            sw = rw; hw = r;
            reset = 0x0;
        } sysboot4[31:0];
    } SYSBOOT4 @ 0x140;
    reg {
        name = "SYSBOOT5";
        desc = "SYSBOOT5 is system boot dedicated register 5. SYSBOOT5 (offset 0x0144, total reset 0x0000_0000; PROVEN: Hi3535 data sheet, PDF page 411, section 3.4.4.2).";
        field {
            name = "sysboot5";
            desc = "System boot dedicated register 5.";
            sw = rw; hw = r;
            reset = 0x0;
        } sysboot5[31:0];
    } SYSBOOT5 @ 0x144;
    reg {
        name = "SYSBOOT6";
        desc = "SYSBOOT6 is system boot dedicated register 6. SYSBOOT6 (offset 0x0148, total reset 0x0000_0000; PROVEN: Hi3535 data sheet, PDF page 411, section 3.4.4.2).";
        field {
            name = "sysboot6";
            desc = "System boot dedicated register 6.";
            sw = rw; hw = r;
            reset = 0x0;
        } sysboot6[31:0];
    } SYSBOOT6 @ 0x148;
    reg {
        name = "SYSBOOT7";
        desc = "SYSBOOT7 is system boot dedicated register 7. SYSBOOT7 (offset 0x014C, total reset 0x0000_0000; PROVEN: Hi3535 data sheet, PDF page 412, section 3.4.4.2).";
        field {
            name = "sysboot7";
            desc = "System boot dedicated register 7.";
            sw = rw; hw = r;
            reset = 0x0;
        } sysboot7[31:0];
    } SYSBOOT7 @ 0x14c;
    reg {
        name = "SYSBOOT8";
        desc = "SYSBOOT8 is system boot dedicated register 8. SYSBOOT8 (offset 0x0150, total reset 0x0000_0000; PROVEN: Hi3535 data sheet, PDF page 412, section 3.4.4.2).";
        field {
            name = "sysboot8";
            desc = "System boot dedicated register 8.";
            sw = rw; hw = r;
            reset = 0x0;
        } sysboot8[31:0];
    } SYSBOOT8 @ 0x150;
    reg {
        name = "SYSBOOT9";
        desc = "SYSBOOT9 is system boot dedicated register 9. SYSBOOT9 (offset 0x0154, total reset 0x0000_0000; PROVEN: Hi3535 data sheet, PDF page 412, section 3.4.4.2).";
        field {
            name = "sysboot9";
            desc = "System boot dedicated register 9 (dedicated to PCIe).";
            sw = rw; hw = r;
            reset = 0x0;
        } sysboot9[31:0];
    } SYSBOOT9 @ 0x154;
    reg {
        name = "SYSBOOT10";
        desc = "SYSBOOT10 is system boot dedicated register 10. SYSBOOT10 (offset 0x0158, total reset 0x0000_0000; PROVEN: Hi3535 data sheet, PDF page 413, section 3.4.4.2).";
        field {
            name = "sysboot10";
            desc = "System boot dedicated register 10 (dedicated to PCIe).";
            sw = rw; hw = r;
            reset = 0x0;
        } sysboot10[31:0];
    } SYSBOOT10 @ 0x158;
    reg {
        name = "SYSBOOT11";
        desc = "SYSBOOT11 is system boot dedicated register 11. SYSBOOT11 (offset 0x015C, total reset 0x0000_0000; PROVEN: Hi3535 data sheet, PDF page 413, section 3.4.4.2).";
        field {
            name = "sysboot11";
            desc = "System boot dedicated register 11 (dedicated to PCIe).";
            sw = rw; hw = r;
            reset = 0x0;
        } sysboot11[31:0];
    } SYSBOOT11 @ 0x15c;
    reg {
        name = "SCSYSID0";
        desc = "SCSYSID0 is chip ID register 0. SCSYSID0 (offset 0xEE0, total reset 0x0000_0000; PROVEN: Hi3535 data sheet, PDF page 413, section 3.4.4.2).";
        field {
            name = "chipid";
            desc = "Chip version information.";
            sw = r; hw = w;
            reset = 0x0;
        } chipid[31:24];
        field {
            name = "reserved";
            desc = "Reserved.";
            sw = r; hw = w;
            reset = 0x0;
        } reserved_23_8[23:8];
        field {
            name = "sysid0";
            desc = "Reading this register returns 0x00.";
            sw = r; hw = w;
            reset = 0x0;
        } sysid0[7:0];
    } SCSYSID0 @ 0xee0;
    reg {
        name = "SCSYSID1";
        desc = "SCSYSID1 is chip ID register 1. SCSYSID1 (offset 0xEE4, total reset 0x01; PROVEN: Hi3535 data sheet, PDF page 414, section 3.4.4.2).";
        field {
            name = "sysid1";
            desc = "Reading this register returns 0x01.";
            sw = r; hw = w;
            reset = 0x1;
        } sysid1[7:0];
    } SCSYSID1 @ 0xee4;
    reg {
        name = "SCSYSID2";
        desc = "SCSYSID2 is chip ID register 2. SCSYSID2 (offset 0xEE8, total reset 0x35; PROVEN: Hi3535 data sheet, PDF page 414, section 3.4.4.2).";
        field {
            name = "sysid2";
            desc = "Reading this register returns 0x35.";
            sw = r; hw = w;
            reset = 0x35;
        } sysid2[7:0];
    } SCSYSID2 @ 0xee8;
    reg {
        name = "SCSYSID3";
        desc = "SCSYSID3 is chip ID register 3. SCSYSID3 (offset 0xEEC, total reset 0x35; PROVEN: Hi3535 data sheet, PDF page 415, section 3.4.4.2).";
        field {
            name = "sysid3";
            desc = "Reading this register returns 0x35.";
            sw = r; hw = w;
            reset = 0x35;
        } sysid3[7:0];
    } SCSYSID3 @ 0xeec;
};

`endif
