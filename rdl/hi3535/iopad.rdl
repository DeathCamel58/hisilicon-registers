`ifndef EHI3535_IOPAD_RDL
`define EHI3535_IOPAD_RDL
regfile eHI3535_IOPAD {
    name = "Pin drive-strength / pad control registers (padctrl_reg)";
    desc = "Pin drive-strength / pad control registers (padctrl_reg). 133 registers extracted programmatically from the Hi3535 H.264 codec processor (Hi3535 user guide) data sheet (Issue 00B08, 2014-02-25); chapter 2.4.2, table 2-34. Field names, bit ranges, access types and reset values are taken from the register tables; reset values are the data sheet total reset values split onto the fields (per-field values where the table has them). Label: PROVEN. Hardware not verified here (no board).";
    reg {
        name = "PADCTRL_REG0";
        desc = "PADCTRL_REG0 is the VGA_HS pin drive capability register. PADCTRL_REG0 (offset 0x0000, total reset 0x0000_0058; PROVEN: Hi3535 data sheet, PDF page 143, section 2.4.2).";
        field {
            name = "reserved";
            desc = "Reserved.";
            sw = r; hw = w;
            reset = 0x0;
        } reserved_31_7[31:7];
        field {
            name = "vga_hs_ds";
            desc = "VGA_HS pin drive current control.
- 000: 4.7mA;
- 001: 7.0mA;
- 010: 9.3mA;
- 011: 11.6mA;
- 100: 14.0mA;
- 101: 16.3mA;
- 110: 18.6mA;
- 111: 20.9mA.";
            sw = rw; hw = r;
            reset = 0x5;
        } vga_hs_ds[6:4];
        field {
            name = "vga_hs_sl";
            desc = "VGA_HS pin slew rate control.
- 0: Slow edge.
- 1: Fast edge.";
            sw = rw; hw = r;
            reset = 0x1;
        } vga_hs_sl[3:3];
        field {
            name = "reserved";
            desc = "Reserved.";
            sw = r; hw = w;
            reset = 0x0;
        } reserved_2_0[2:0];
    } PADCTRL_REG0 @ 0x0;
    reg {
        name = "PADCTRL_REG1";
        desc = "PADCTRL_REG1 is the VGA_VS pin drive strength register. PADCTRL_REG1 (offset 0x0004, total reset 0x0000_0058; PROVEN: Hi3535 data sheet, PDF page 144, section 2.4.2).";
        field {
            name = "reserved";
            desc = "Reserved.";
            sw = r; hw = w;
            reset = 0x0;
        } reserved_31_7[31:7];
        field {
            name = "vga_vs_ds";
            desc = "VGA_VS pin drive current control.
- 000: 4.7 mA.
- 001: 7.0 mA.
- 010: 9.3 mA.
- 011: 11.6 mA.
- 100: 14.0 mA.
- 101: 16.3 mA.
- 110: 18.6 mA.
- 111: 20.9 mA.";
            sw = rw; hw = r;
            reset = 0x5;
        } vga_vs_ds[6:4];
        field {
            name = "vga_vs_sl";
            desc = "VGA_VS pin slew rate control.
- 0: Slow edge;
- 1: Fast edge.";
            sw = rw; hw = r;
            reset = 0x1;
        } vga_vs_sl[3:3];
        field {
            name = "reserved";
            desc = "Reserved.";
            sw = r; hw = w;
            reset = 0x0;
        } reserved_2_0[2:0];
    } PADCTRL_REG1 @ 0x4;
    reg {
        name = "PADCTRL_REG2";
        desc = "PADCTRL_REG2 is the RGMII0_RXDV pin drive strength register. PADCTRL_REG2 (offset 0x0008, total reset 0x0000_0010; PROVEN: Hi3535 data sheet, PDF page 145, section 2.4.2).";
        field {
            name = "reserved";
            desc = "Reserved.";
            sw = r; hw = w;
            reset = 0x0;
        } reserved_31_6[31:6];
        field {
            name = "rgmii0_rxdv_ds";
            desc = "RGMII0_RXDV pin drive current control.
- 00: 2.3mA;
- 01: 4.7mA;
- 10: 7.0mA;
- 11: 9.3mA.";
            sw = rw; hw = r;
            reset = 0x1;
        } rgmii0_rxdv_ds[5:4];
        field {
            name = "rgmii0_rxdv_sl";
            desc = "RGMII0_RXDV pin slew rate control.
- 0: Slow slew.
- 1: Fast slew.";
            sw = rw; hw = r;
            reset = 0x0;
        } rgmii0_rxdv_sl[3:3];
        field {
            name = "reserved";
            desc = "Reserved.";
            sw = r; hw = w;
            reset = 0x0;
        } reserved_2_0[2:0];
    } PADCTRL_REG2 @ 0x8;
    reg {
        name = "PADCTRL_REG3";
        desc = "PADCTRL_REG3 is the RGMII0_RXD0 pin drive capability register. PADCTRL_REG3 (offset 0x000C, total reset 0x0000_0010; PROVEN: Hi3535 data sheet, PDF page 146, section 2.4.2).";
        field {
            name = "reserved";
            desc = "Reserved.";
            sw = r; hw = w;
            reset = 0x0;
        } reserved_31_6[31:6];
        field {
            name = "rgmii0_rxd0_ds";
            desc = "RGMII0_RXD0 pin drive current control.
- 00: 2.3mA;
- 01: 4.7mA;
- 10: 7.0mA;
- 11: 9.3mA.";
            sw = rw; hw = r;
            reset = 0x1;
        } rgmii0_rxd0_ds[5:4];
        field {
            name = "rgmii0_rxd0_sl";
            desc = "RGMII0_RXD0 pin slew rate control.
- 0: Slow edge;
- 1: Fast edge.";
            sw = rw; hw = r;
            reset = 0x0;
        } rgmii0_rxd0_sl[3:3];
        field {
            name = "reserved";
            desc = "Reserved.";
            sw = r; hw = w;
            reset = 0x0;
        } reserved_2_0[2:0];
    } PADCTRL_REG3 @ 0xc;
    reg {
        name = "PADCTRL_REG4";
        desc = "PADCTRL_REG4 is the RGMII0_RXD1 pin drive capability register. PADCTRL_REG4 (offset 0x0010, total reset 0x0000_0010; PROVEN: Hi3535 data sheet, PDF page 147, section 2.4.2).";
        field {
            name = "reserved";
            desc = "Reserved.";
            sw = r; hw = w;
            reset = 0x0;
        } reserved_31_6[31:6];
        field {
            name = "rgmii0_rxd1_ds";
            desc = "RGMII0_RXD1 pin drive current control.
- 00: 2.3mA;
- 01: 4.7mA;
- 10: 7.0mA;
- 11: 9.3mA.";
            sw = rw; hw = r;
            reset = 0x1;
        } rgmii0_rxd1_ds[5:4];
        field {
            name = "rgmii0_rxd1_sl";
            desc = "RGMII0_RXD1 pin slew rate control.
- 0: Slow slew.
- 1: Fast slew.";
            sw = rw; hw = r;
            reset = 0x0;
        } rgmii0_rxd1_sl[3:3];
        field {
            name = "reserved";
            desc = "Reserved.";
            sw = r; hw = w;
            reset = 0x0;
        } reserved_2_0[2:0];
    } PADCTRL_REG4 @ 0x10;
    reg {
        name = "PADCTRL_REG5";
        desc = "PADCTRL_REG5 is the RGMII0_RXD2 pin drive capability register. PADCTRL_REG5 (offset 0x0014, total reset 0x0000_0010; PROVEN: Hi3535 data sheet, PDF page 148, section 2.4.2).";
        field {
            name = "reserved";
            desc = "Reserved.";
            sw = r; hw = w;
            reset = 0x0;
        } reserved_31_6[31:6];
        field {
            name = "rgmii0_rxd2_ds";
            desc = "RGMII0_RXD2 pin drive current control.
- 00: 2.3 mA.
- 01: 4.7 mA.
- 10: 7.0 mA.
- 11: 9.3 mA.";
            sw = rw; hw = r;
            reset = 0x1;
        } rgmii0_rxd2_ds[5:4];
        field {
            name = "rgmii0_rxd2_sl";
            desc = "RGMII0_RXD2 pin slew rate control.
- 0: Slow edge;
- 1: Fast edge.";
            sw = rw; hw = r;
            reset = 0x0;
        } rgmii0_rxd2_sl[3:3];
        field {
            name = "reserved";
            desc = "Reserved.";
            sw = r; hw = w;
            reset = 0x0;
        } reserved_2_0[2:0];
    } PADCTRL_REG5 @ 0x14;
    reg {
        name = "PADCTRL_REG6";
        desc = "PADCTRL_REG6 is the RGMII0_RXD3 pin drive strength register. PADCTRL_REG6 (offset 0x0018, total reset 0x0000_0010; PROVEN: Hi3535 data sheet, PDF page 149, section 2.4.2).";
        field {
            name = "reserved";
            desc = "Reserved.";
            sw = r; hw = w;
            reset = 0x0;
        } reserved_31_6[31:6];
        field {
            name = "rgmii0_rxd3_ds";
            desc = "RGMII0_RXD3 pin drive current control.
- 00: 2.3mA;
- 01: 4.7mA;
- 10: 7.0mA;
- 11: 9.3mA.";
            sw = rw; hw = r;
            reset = 0x1;
        } rgmii0_rxd3_ds[5:4];
        field {
            name = "rgmii0_rxd3_sl";
            desc = "RGMII0_RXD3 pin slew rate control.
- 0: Slow edge;
- 1: Fast edge.";
            sw = rw; hw = r;
            reset = 0x0;
        } rgmii0_rxd3_sl[3:3];
        field {
            name = "reserved";
            desc = "Reserved.";
            sw = r; hw = w;
            reset = 0x0;
        } reserved_2_0[2:0];
    } PADCTRL_REG6 @ 0x18;
    reg {
        name = "PADCTRL_REG7";
        desc = "PADCTRL_REG7 is the RGMII0_TXD0 pin drive capability register. PADCTRL_REG7 (offset 0x001C, total reset 0x0000_0058; PROVEN: Hi3535 data sheet, PDF page 150, section 2.4.2).";
        field {
            name = "reserved";
            desc = "Reserved.";
            sw = r; hw = w;
            reset = 0x0;
        } reserved_31_7[31:7];
        field {
            name = "rgmii0_txd0_ds";
            desc = "RGMII0_TXD0 pin drive current control.
- 000: 4.7mA;
- 001: 7.0mA;
- 010: 9.3mA;
- 011: 11.6mA;
- 100: 14.0mA;
- 101: 16.3mA;
- 110: 18.6mA;
- 111: 20.9mA.";
            sw = rw; hw = r;
            reset = 0x5;
        } rgmii0_txd0_ds[6:4];
        field {
            name = "rgmii0_txd0_sl";
            desc = "RGMII0_TXD0 pin slew rate control.
- 0: Slow edge;
- 1: Fast edge.";
            sw = rw; hw = r;
            reset = 0x1;
        } rgmii0_txd0_sl[3:3];
        field {
            name = "reserved";
            desc = "Reserved.";
            sw = r; hw = w;
            reset = 0x0;
        } reserved_2_0[2:0];
    } PADCTRL_REG7 @ 0x1c;
    reg {
        name = "PADCTRL_REG8";
        desc = "PADCTRL_REG8 is the RGMII0_TXD1 pin drive strength register. PADCTRL_REG8 (offset 0x0020, total reset 0x0000_0058; PROVEN: Hi3535 data sheet, PDF page 151, section 2.4.2).";
        field {
            name = "reserved";
            desc = "Reserved.";
            sw = r; hw = w;
            reset = 0x0;
        } reserved_31_7[31:7];
        field {
            name = "rgmii0_txd1_ds";
            desc = "RGMII0_TXD1 pin drive current control.
- 000: 4.7mA;
- 001: 7.0mA;
- 010: 9.3mA;
- 011: 11.6mA;
- 100: 14.0mA;
- 101: 16.3mA;
- 110: 18.6mA;
- 111: 20.9mA.";
            sw = rw; hw = r;
            reset = 0x5;
        } rgmii0_txd1_ds[6:4];
        field {
            name = "rgmii0_txd1_sl";
            desc = "RGMII0_TXD1 pin slew rate control.
- 0: Slow edge;
- 1: Fast edge.";
            sw = rw; hw = r;
            reset = 0x1;
        } rgmii0_txd1_sl[3:3];
        field {
            name = "reserved";
            desc = "Reserved.";
            sw = r; hw = w;
            reset = 0x0;
        } reserved_2_0[2:0];
    } PADCTRL_REG8 @ 0x20;
    reg {
        name = "PADCTRL_REG9";
        desc = "PADCTRL_REG9 is the RGMII0_TXD2 pin drive capability register. PADCTRL_REG9 (offset 0x0024, total reset 0x0000_0058; PROVEN: Hi3535 data sheet, PDF page 152, section 2.4.2).";
        field {
            name = "reserved";
            desc = "Reserved.";
            sw = r; hw = w;
            reset = 0x0;
        } reserved_31_7[31:7];
        field {
            name = "rgmii0_txd2_ds";
            desc = "RGMII0_TXD2 pin drive current control.
- 000: 4.7mA;
- 001: 7.0mA;
- 010: 9.3mA;
- 011: 11.6mA;
- 100: 14.0mA;
- 101: 16.3mA;
- 110: 18.6mA;
- 111: 20.9mA.";
            sw = rw; hw = r;
            reset = 0x5;
        } rgmii0_txd2_ds[6:4];
        field {
            name = "rgmii0_txd2_sl";
            desc = "RGMII0_TXD2 pin slew rate control.
- 0: Slow edge;
- 1: Fast edge.";
            sw = rw; hw = r;
            reset = 0x1;
        } rgmii0_txd2_sl[3:3];
        field {
            name = "reserved";
            desc = "Reserved.";
            sw = r; hw = w;
            reset = 0x0;
        } reserved_2_0[2:0];
    } PADCTRL_REG9 @ 0x24;
    reg {
        name = "PADCTRL_REG10";
        desc = "PADCTRL_REG10 is the RGMII0_TXD3 pin drive capability register. PADCTRL_REG10 (offset 0x0028, total reset 0x0000_0058; PROVEN: Hi3535 data sheet, PDF page 153, section 2.4.2).";
        field {
            name = "reserved";
            desc = "Reserved.";
            sw = r; hw = w;
            reset = 0x0;
        } reserved_31_7[31:7];
        field {
            name = "rgmii0_txd3_ds";
            desc = "RGMII0_TXD3 pin drive current control.
- 000: 4.7 mA.
- 001: 7.0 mA.
- 010: 9.3 mA.
- 011: 11.6 mA.
- 100: 14.0 mA.
- 101: 16.3 mA.
- 110: 18.6 mA.
- 111: 20.9 mA.";
            sw = rw; hw = r;
            reset = 0x5;
        } rgmii0_txd3_ds[6:4];
        field {
            name = "rgmii0_txd3_sl";
            desc = "RGMII0_TXD3 pin slew rate control.
- 0: Slow edge;
- 1: Fast edge.";
            sw = rw; hw = r;
            reset = 0x1;
        } rgmii0_txd3_sl[3:3];
        field {
            name = "reserved";
            desc = "Reserved.";
            sw = r; hw = w;
            reset = 0x0;
        } reserved_2_0[2:0];
    } PADCTRL_REG10 @ 0x28;
    reg {
        name = "PADCTRL_REG11";
        desc = "PADCTRL_REG11 is the RGMII0_RXCK pin drive capability register. PADCTRL_REG11 (offset 0x002C, total reset 0x0000_0010; PROVEN: Hi3535 data sheet, PDF page 154, section 2.4.2).";
        field {
            name = "reserved";
            desc = "Reserved.";
            sw = r; hw = w;
            reset = 0x0;
        } reserved_31_6[31:6];
        field {
            name = "rgmii0_rxck_ds";
            desc = "RGMII0_RXCK pin drive current control.
- 00: 2.3 mA.
- 01: 4.7 mA.
- 10: 7.0 mA.
- 11: 9.3 mA.";
            sw = rw; hw = r;
            reset = 0x1;
        } rgmii0_rxck_ds[5:4];
        field {
            name = "rgmii0_rxck_sl";
            desc = "RGMII0_RXCK pin slew rate control.
- 0: Slow edge;
- 1: Fast edge.";
            sw = rw; hw = r;
            reset = 0x0;
        } rgmii0_rxck_sl[3:3];
        field {
            name = "reserved";
            desc = "Reserved.";
            sw = r; hw = w;
            reset = 0x0;
        } reserved_2_0[2:0];
    } PADCTRL_REG11 @ 0x2c;
    reg {
        name = "PADCTRL_REG12";
        desc = "PADCTRL_REG12 is the RGMII0_TXEN pin drive strength register. PADCTRL_REG12 (offset 0x0030, total reset 0x0000_0058; PROVEN: Hi3535 data sheet, PDF page 155, section 2.4.2).";
        field {
            name = "reserved";
            desc = "Reserved.";
            sw = r; hw = w;
            reset = 0x0;
        } reserved_31_7[31:7];
        field {
            name = "rgmii0_txen_ds";
            desc = "RGMII0_TXEN pin drive current control.
- 000: 4.7mA.
- 001: 7.0mA.
- 010: 9.3mA.
- 011: 11.6mA.
- 100: 14.0mA.
- 101: 16.3mA.
- 110: 18.6mA.
- 111: 20.9mA.";
            sw = rw; hw = r;
            reset = 0x5;
        } rgmii0_txen_ds[6:4];
        field {
            name = "rgmii0_txen_sl";
            desc = "RGMII0_TXEN pin slew rate control.
- 0: Slow edge;
- 1: Fast edge.";
            sw = rw; hw = r;
            reset = 0x1;
        } rgmii0_txen_sl[3:3];
        field {
            name = "reserved";
            desc = "Reserved.";
            sw = r; hw = w;
            reset = 0x0;
        } reserved_2_0[2:0];
    } PADCTRL_REG12 @ 0x30;
    reg {
        name = "PADCTRL_REG13";
        desc = "PADCTRL_REG13 is the RGMII0_TXCK pin drive strength register. PADCTRL_REG13 (offset 0x0034, total reset 0x0000_0010; PROVEN: Hi3535 data sheet, PDF page 156, section 2.4.2).";
        field {
            name = "reserved";
            desc = "Reserved.";
            sw = r; hw = w;
            reset = 0x0;
        } reserved_31_6[31:6];
        field {
            name = "rgmii0_txck_ds";
            desc = "RGMII0_TXCK pin drive current control.
- 00: 2.3mA;
- 01: 4.7mA;
- 10: 7.0mA;
- 11: 9.3mA.";
            sw = rw; hw = r;
            reset = 0x1;
        } rgmii0_txck_ds[5:4];
        field {
            name = "rgmii0_txck_sl";
            desc = "RGMII0_TXCK pin slew rate control.
- 0: Slow edge;
- 1: Fast edge.";
            sw = rw; hw = r;
            reset = 0x0;
        } rgmii0_txck_sl[3:3];
        field {
            name = "reserved";
            desc = "Reserved.";
            sw = r; hw = w;
            reset = 0x0;
        } reserved_2_0[2:0];
    } PADCTRL_REG13 @ 0x34;
    reg {
        name = "PADCTRL_REG14";
        desc = "PADCTRL_REG14 is the RGMII0_TXCKOUT pin drive strength register. PADCTRL_REG14 (offset 0x0038, total reset 0x0000_0058; PROVEN: Hi3535 data sheet, PDF page 157, section 2.4.2).";
        field {
            name = "reserved";
            desc = "Reserved.";
            sw = r; hw = w;
            reset = 0x0;
        } reserved_31_7[31:7];
        field {
            name = "rgmii0_txckout_ds";
            desc = "RGMII0_TXCKOUT pin drive current control.
- 000: 4.7 mA.
- 001: 7.0 mA.
- 010: 9.3 mA.
- 011: 11.6 mA.
- 100: 14.0 mA.
- 101: 16.3 mA.
- 110: 18.6 mA.
- 111: 20.9 mA.";
            sw = rw; hw = r;
            reset = 0x5;
        } rgmii0_txckout_ds[6:4];
        field {
            name = "rgmii0_txckout_sl";
            desc = "RGMII0_TXCKOUT pin slew rate control.
- 0: Slow slew.
- 1: Fast slew.";
            sw = rw; hw = r;
            reset = 0x1;
        } rgmii0_txckout_sl[3:3];
        field {
            name = "reserved";
            desc = "Reserved.";
            sw = r; hw = w;
            reset = 0x0;
        } reserved_2_0[2:0];
    } PADCTRL_REG14 @ 0x38;
    reg {
        name = "PADCTRL_REG15";
        desc = "PADCTRL_REG15 is the RGMII0_CRS pin drive capability register. PADCTRL_REG15 (offset 0x003C, total reset 0x0000_0010; PROVEN: Hi3535 data sheet, PDF page 158, section 2.4.2).";
        field {
            name = "reserved";
            desc = "Reserved.";
            sw = r; hw = w;
            reset = 0x0;
        } reserved_31_6[31:6];
        field {
            name = "rgmii0_crs_ds";
            desc = "RGMII0_CRS pin drive current control.
- 00: 2.3mA;
- 01: 4.7mA;
- 10: 7.0mA;
- 11: 9.3mA.";
            sw = rw; hw = r;
            reset = 0x1;
        } rgmii0_crs_ds[5:4];
        field {
            name = "rgmii0_crs_sl";
            desc = "RGMII0_CRS pin slew rate control.
- 0: Slow slew.
- 1: Fast slew.";
            sw = rw; hw = r;
            reset = 0x0;
        } rgmii0_crs_sl[3:3];
        field {
            name = "reserved";
            desc = "Reserved.";
            sw = r; hw = w;
            reset = 0x0;
        } reserved_2_0[2:0];
    } PADCTRL_REG15 @ 0x3c;
    reg {
        name = "PADCTRL_REG16";
        desc = "PADCTRL_REG16 is the RGMII0_COL pin drive strength register. PADCTRL_REG16 (offset 0x0040, total reset 0x0000_0010; PROVEN: Hi3535 data sheet, PDF page 159, section 2.4.2).";
        field {
            name = "reserved";
            desc = "Reserved.";
            sw = r; hw = w;
            reset = 0x0;
        } reserved_31_6[31:6];
        field {
            name = "rgmii0_col_ds";
            desc = "RGMII0_COL pin drive current control.
- 00: 2.3 mA.
- 01: 4.7 mA.
- 10: 7.0 mA.
- 11: 9.3 mA.";
            sw = rw; hw = r;
            reset = 0x1;
        } rgmii0_col_ds[5:4];
        field {
            name = "rgmii0_col_sl";
            desc = "RGMII0_COL pin slew rate control.
- 0: Slow edge.
- 1: Fast edge.";
            sw = rw; hw = r;
            reset = 0x0;
        } rgmii0_col_sl[3:3];
        field {
            name = "reserved";
            desc = "Reserved.";
            sw = r; hw = w;
            reset = 0x0;
        } reserved_2_0[2:0];
    } PADCTRL_REG16 @ 0x40;
    reg {
        name = "PADCTRL_REG17";
        desc = "PADCTRL_REG17 is the RGMII0_RXER pin drive capability register. PADCTRL_REG17 (offset 0x0044, total reset 0x0000_0000; PROVEN: Hi3535 data sheet, PDF page 160, section 2.4.2).";
        field {
            name = "reserved";
            desc = "Reserved.";
            sw = r; hw = w;
            reset = 0x0;
        } reserved_31_6[31:6];
        field {
            name = "rgmii0_rxer_ds";
            desc = "RGMII0_RXER pin drive current control.
- 00: 2.3 mA.
- 01: 4.7 mA.
- 10: 7.0 mA.
- 11: 9.3 mA.";
            sw = rw; hw = r;
            reset = 0x0;
        } rgmii0_rxer_ds[5:4];
        field {
            name = "rgmii0_rxer_sl";
            desc = "RGMII0_RXER pin slew rate control.
- 0: Slow edge;
- 1: Fast edge.";
            sw = rw; hw = r;
            reset = 0x0;
        } rgmii0_rxer_sl[3:3];
        field {
            name = "reserved";
            desc = "Reserved.";
            sw = r; hw = w;
            reset = 0x0;
        } reserved_2_0[2:0];
    } PADCTRL_REG17 @ 0x44;
    reg {
        name = "PADCTRL_REG18";
        desc = "PADCTRL_REG18 is the RGMII0_TXER pin drive capability register. PADCTRL_REG18 (offset 0x0048, total reset 0x0000_0058; PROVEN: Hi3535 data sheet, PDF page 161, section 2.4.2).";
        field {
            name = "reserved";
            desc = "Reserved.";
            sw = r; hw = w;
            reset = 0x0;
        } reserved_31_7[31:7];
        field {
            name = "rgmii0_txer_ds";
            desc = "RGMII0_TXER pin drive current control.
- 000: 4.7mA;
- 001: 7.0mA;
- 010: 9.3mA;
- 011: 11.6mA;
- 100: 14.0mA;
- 101: 16.3mA;
- 110: 18.6mA;
- 111: 20.9mA.";
            sw = rw; hw = r;
            reset = 0x5;
        } rgmii0_txer_ds[6:4];
        field {
            name = "rgmii0_txer_sl";
            desc = "RGMII0_TXER pin slew rate control.
- 0: Slow edge;
- 1: Fast edge.";
            sw = rw; hw = r;
            reset = 0x1;
        } rgmii0_txer_sl[3:3];
        field {
            name = "reserved";
            desc = "Reserved.";
            sw = r; hw = w;
            reset = 0x0;
        } reserved_2_0[2:0];
    } PADCTRL_REG18 @ 0x48;
    reg {
        name = "PADCTRL_REG19";
        desc = "PADCTRL_REG19 is the RGMII1_RXDV pin drive capability register. PADCTRL_REG19 (offset 0x004C, total reset 0x0000_0010; PROVEN: Hi3535 data sheet, PDF page 162, section 2.4.2).";
        field {
            name = "reserved";
            desc = "Reserved.";
            sw = r; hw = w;
            reset = 0x0;
        } reserved_31_6[31:6];
        field {
            name = "rgmii1_rxdv_ds";
            desc = "RGMII1_RXDV pin drive current control.
- 00: 2.3mA;
- 01: 4.7mA;
- 10: 7.0mA;
- 11: 9.3mA.";
            sw = rw; hw = r;
            reset = 0x1;
        } rgmii1_rxdv_ds[5:4];
        field {
            name = "rgmii1_rxdv_sl";
            desc = "RGMII1_RXDV pin slew rate control.
- 0: Slow edge;
- 1: Fast edge.";
            sw = rw; hw = r;
            reset = 0x0;
        } rgmii1_rxdv_sl[3:3];
        field {
            name = "reserved";
            desc = "Reserved.";
            sw = r; hw = w;
            reset = 0x0;
        } reserved_2_0[2:0];
    } PADCTRL_REG19 @ 0x4c;
    reg {
        name = "PADCTRL_REG20";
        desc = "PADCTRL_REG20 is the RGMII1_RXD0 pin drive capability register. PADCTRL_REG20 (offset 0x0050, total reset 0x0000_0010; PROVEN: Hi3535 data sheet, PDF page 163, section 2.4.2).";
        field {
            name = "reserved";
            desc = "Reserved.";
            sw = r; hw = w;
            reset = 0x0;
        } reserved_31_6[31:6];
        field {
            name = "rgmii1_rxd0_ds";
            desc = "RGMII1_RXD0 pin drive current control.
- 00: 2.3mA;
- 01: 4.7mA;
- 10: 7.0mA;
- 11: 9.3mA.";
            sw = rw; hw = r;
            reset = 0x1;
        } rgmii1_rxd0_ds[5:4];
        field {
            name = "rgmii1_rxd0_sl";
            desc = "RGMII1_RXD0 pin slew rate control.
- 0: Slow edge;
- 1: Fast edge.";
            sw = rw; hw = r;
            reset = 0x0;
        } rgmii1_rxd0_sl[3:3];
        field {
            name = "reserved";
            desc = "Reserved.";
            sw = r; hw = w;
            reset = 0x0;
        } reserved_2_0[2:0];
    } PADCTRL_REG20 @ 0x50;
    reg {
        name = "PADCTRL_REG21";
        desc = "PADCTRL_REG21 is the RGMII1_RXD1 pin drive strength register. PADCTRL_REG21 (offset 0x0054, total reset 0x0000_0010; PROVEN: Hi3535 data sheet, PDF page 164, section 2.4.2).";
        field {
            name = "reserved";
            desc = "Reserved.";
            sw = r; hw = w;
            reset = 0x0;
        } reserved_31_6[31:6];
        field {
            name = "rgmii1_rxd1_ds";
            desc = "RGMII1_RXD1 pin drive current control.
- 00: 2.3mA.
- 01: 4.7mA.
- 10: 7.0mA.
- 11: 9.3mA.";
            sw = rw; hw = r;
            reset = 0x1;
        } rgmii1_rxd1_ds[5:4];
        field {
            name = "rgmii1_rxd1_sl";
            desc = "RGMII1_RXD1 pin slew rate control.
- 0: Slow edge;
- 1: Fast edge.";
            sw = rw; hw = r;
            reset = 0x0;
        } rgmii1_rxd1_sl[3:3];
        field {
            name = "reserved";
            desc = "Reserved.";
            sw = r; hw = w;
            reset = 0x0;
        } reserved_2_0[2:0];
    } PADCTRL_REG21 @ 0x54;
    reg {
        name = "PADCTRL_REG22";
        desc = "PADCTRL_REG22 is the RGMII1_RXD2 pin drive capability register. PADCTRL_REG22 (offset 0x0058, total reset 0x0000_0010; PROVEN: Hi3535 data sheet, PDF page 165, section 2.4.2).";
        field {
            name = "reserved";
            desc = "Reserved.";
            sw = r; hw = w;
            reset = 0x0;
        } reserved_31_6[31:6];
        field {
            name = "rgmii1_rxd2_ds";
            desc = "RGMII1_RXD2 pin drive current control.
- 00: 2.3mA;
- 01: 4.7mA;
- 10: 7.0mA;
- 11: 9.3mA.";
            sw = rw; hw = r;
            reset = 0x1;
        } rgmii1_rxd2_ds[5:4];
        field {
            name = "rgmii1_rxd2_sl";
            desc = "RGMII1_RXD2 pin slew rate control.
- 0: Slow edge;
- 1: Fast edge.";
            sw = rw; hw = r;
            reset = 0x0;
        } rgmii1_rxd2_sl[3:3];
        field {
            name = "reserved";
            desc = "Reserved.";
            sw = r; hw = w;
            reset = 0x0;
        } reserved_2_0[2:0];
    } PADCTRL_REG22 @ 0x58;
    reg {
        name = "PADCTRL_REG23";
        desc = "PADCTRL_REG23 is the RGMII1_RXD3 pin drive capability register. PADCTRL_REG23 (offset 0x005C, total reset 0x0000_0010; PROVEN: Hi3535 data sheet, PDF page 166, section 2.4.2).";
        field {
            name = "reserved";
            desc = "Reserved.";
            sw = r; hw = w;
            reset = 0x0;
        } reserved_31_6[31:6];
        field {
            name = "rgmii1_rxd3_ds";
            desc = "RGMII1_RXD3 pin drive current control.
- 00: 2.3mA;
- 01: 4.7mA;
- 10: 7.0mA;
- 11: 9.3mA.";
            sw = rw; hw = r;
            reset = 0x1;
        } rgmii1_rxd3_ds[5:4];
        field {
            name = "rgmii1_rxd3_sl";
            desc = "RGMII1_RXD3 pin slew rate control.
- 0: Slow edge;
- 1: Fast edge.";
            sw = rw; hw = r;
            reset = 0x0;
        } rgmii1_rxd3_sl[3:3];
        field {
            name = "reserved";
            desc = "Reserved.";
            sw = r; hw = w;
            reset = 0x0;
        } reserved_2_0[2:0];
    } PADCTRL_REG23 @ 0x5c;
    reg {
        name = "PADCTRL_REG24";
        desc = "PADCTRL_REG24 is the RGMII1_TXD0 pin drive capability register. PADCTRL_REG24 (offset 0x0060, total reset 0x0000_0058; PROVEN: Hi3535 data sheet, PDF page 167, section 2.4.2).";
        field {
            name = "reserved";
            desc = "Reserved.";
            sw = r; hw = w;
            reset = 0x0;
        } reserved_31_7[31:7];
        field {
            name = "rgmii1_txd0_ds";
            desc = "RGMII1_TXD0 pin drive current control.
- 000: 4.7mA;
- 001: 7.0mA;
- 010: 9.3mA;
- 011: 11.6mA;
- 100: 14.0mA;
- 101: 16.3mA;
- 110: 18.6mA;
- 111: 20.9mA.";
            sw = rw; hw = r;
            reset = 0x5;
        } rgmii1_txd0_ds[6:4];
        field {
            name = "rgmii1_txd0_sl";
            desc = "RGMII1_TXD0 pin slew rate control.
- 0: Slow edge;
- 1: Fast edge.";
            sw = rw; hw = r;
            reset = 0x1;
        } rgmii1_txd0_sl[3:3];
        field {
            name = "reserved";
            desc = "Reserved.";
            sw = r; hw = w;
            reset = 0x0;
        } reserved_2_0[2:0];
    } PADCTRL_REG24 @ 0x60;
    reg {
        name = "PADCTRL_REG25";
        desc = "PADCTRL_REG25 is the RGMII1_TXD1 pin drive strength register. PADCTRL_REG25 (offset 0x0064, total reset 0x0000_0058; PROVEN: Hi3535 data sheet, PDF page 168, section 2.4.2).";
        field {
            name = "reserved";
            desc = "Reserved.";
            sw = r; hw = w;
            reset = 0x0;
        } reserved_31_7[31:7];
        field {
            name = "rgmii1_txd1_ds";
            desc = "RGMII1_TXD1 pin drive current control.
- 000: 4.7 mA.
- 001: 7.0 mA.
- 010: 9.3 mA.
- 011: 11.6 mA.
- 100: 14.0 mA.
- 101: 16.3 mA.
- 110: 18.6 mA.
- 111: 20.9 mA.";
            sw = rw; hw = r;
            reset = 0x5;
        } rgmii1_txd1_ds[6:4];
        field {
            name = "rgmii1_txd1_sl";
            desc = "RGMII1_TXD1 pin slew rate control.
- 0: Slow slew.
- 1: Fast slew.";
            sw = rw; hw = r;
            reset = 0x1;
        } rgmii1_txd1_sl[3:3];
        field {
            name = "reserved";
            desc = "Reserved.";
            sw = r; hw = w;
            reset = 0x0;
        } reserved_2_0[2:0];
    } PADCTRL_REG25 @ 0x64;
    reg {
        name = "PADCTRL_REG26";
        desc = "PADCTRL_REG26 is the RGMII1_TXD2 pin drive capability register. PADCTRL_REG26 (offset 0x0068, total reset 0x0000_0058; PROVEN: Hi3535 data sheet, PDF page 169, section 2.4.2).";
        field {
            name = "reserved";
            desc = "Reserved.";
            sw = r; hw = w;
            reset = 0x0;
        } reserved_31_7[31:7];
        field {
            name = "rgmii1_txd2_ds";
            desc = "RGMII1_TXD2 pin drive current control.
- 000: 4.7mA;
- 001: 7.0mA;
- 010: 9.3mA;
- 011: 11.6mA;
- 100: 14.0mA;
- 101: 16.3mA;
- 110: 18.6mA;
- 111: 20.9mA.";
            sw = rw; hw = r;
            reset = 0x5;
        } rgmii1_txd2_ds[6:4];
        field {
            name = "rgmii1_txd2_sl";
            desc = "RGMII1_TXD2 pin slew rate control.
- 0: Slow edge;
- 1: Fast edge.";
            sw = rw; hw = r;
            reset = 0x1;
        } rgmii1_txd2_sl[3:3];
        field {
            name = "reserved";
            desc = "Reserved.";
            sw = r; hw = w;
            reset = 0x0;
        } reserved_2_0[2:0];
    } PADCTRL_REG26 @ 0x68;
    reg {
        name = "PADCTRL_REG27";
        desc = "PADCTRL_REG27 is the RGMII1_TXD3 pin drive strength register. PADCTRL_REG27 (offset 0x006C, total reset 0x0000_0058; PROVEN: Hi3535 data sheet, PDF page 170, section 2.4.2).";
        field {
            name = "reserved";
            desc = "Reserved.";
            sw = r; hw = w;
            reset = 0x0;
        } reserved_31_7[31:7];
        field {
            name = "rgmii1_txd3_ds";
            desc = "RGMII1_TXD3 pin drive current control.
- 000: 4.7mA;
- 001: 7.0mA;
- 010: 9.3mA;
- 011: 11.6mA;
- 100: 14.0mA;
- 101: 16.3mA;
- 110: 18.6mA;
- 111: 20.9mA.";
            sw = rw; hw = r;
            reset = 0x5;
        } rgmii1_txd3_ds[6:4];
        field {
            name = "rgmii1_txd3_sl";
            desc = "RGMII1_TXD3 pin slew rate control.
- 0: Slow edge;
- 1: Fast edge.";
            sw = rw; hw = r;
            reset = 0x1;
        } rgmii1_txd3_sl[3:3];
        field {
            name = "reserved";
            desc = "Reserved.";
            sw = r; hw = w;
            reset = 0x0;
        } reserved_2_0[2:0];
    } PADCTRL_REG27 @ 0x6c;
    reg {
        name = "PADCTRL_REG28";
        desc = "PADCTRL_REG28 is the RGMII1_RXCK pin drive capability register. PADCTRL_REG28 (offset 0x0070, total reset 0x0000_0010; PROVEN: Hi3535 data sheet, PDF page 171, section 2.4.2).";
        field {
            name = "reserved";
            desc = "Reserved.";
            sw = r; hw = w;
            reset = 0x0;
        } reserved_31_6[31:6];
        field {
            name = "rgmii1_rxck_ds";
            desc = "RGMII1_RXCK pin drive current control.
- 00: 2.3mA.
- 01: 4.7mA.
- 10: 7.0mA.
- 11: 9.3mA.";
            sw = rw; hw = r;
            reset = 0x1;
        } rgmii1_rxck_ds[5:4];
        field {
            name = "rgmii1_rxck_sl";
            desc = "RGMII1_RXCK pin slew rate control.
- 0: Slow edge;
- 1: Fast edge.";
            sw = rw; hw = r;
            reset = 0x0;
        } rgmii1_rxck_sl[3:3];
        field {
            name = "reserved";
            desc = "Reserved.";
            sw = r; hw = w;
            reset = 0x0;
        } reserved_2_0[2:0];
    } PADCTRL_REG28 @ 0x70;
    reg {
        name = "PADCTRL_REG29";
        desc = "PADCTRL_REG29 is the RGMII1_TXEN pin drive capability register. PADCTRL_REG29 (offset 0x0074, total reset 0x0000_0058; PROVEN: Hi3535 data sheet, PDF page 172, section 2.4.2).";
        field {
            name = "reserved";
            desc = "Reserved.";
            sw = r; hw = w;
            reset = 0x0;
        } reserved_31_7[31:7];
        field {
            name = "rgmii1_txen_ds";
            desc = "RGMII1_TXEN pin drive current control.
- 000: 4.7 mA.
- 001: 7.0 mA.
- 010: 9.3 mA.
- 011: 11.6 mA.
- 100: 14.0 mA.
- 101: 16.3 mA.
- 110: 18.6 mA.
- 111: 20.9 mA.";
            sw = rw; hw = r;
            reset = 0x5;
        } rgmii1_txen_ds[6:4];
        field {
            name = "rgmii1_txen_sl";
            desc = "RGMII1_TXEN pin slew rate control.
- 0: Slow slew.
- 1: Fast slew.";
            sw = rw; hw = r;
            reset = 0x1;
        } rgmii1_txen_sl[3:3];
        field {
            name = "reserved";
            desc = "Reserved.";
            sw = r; hw = w;
            reset = 0x0;
        } reserved_2_0[2:0];
    } PADCTRL_REG29 @ 0x74;
    reg {
        name = "PADCTRL_REG30";
        desc = "PADCTRL_REG30 is the RGMII1_TXCK pin drive strength register. PADCTRL_REG30 (offset 0x0078, total reset 0x0000_0010; PROVEN: Hi3535 data sheet, PDF page 173, section 2.4.2).";
        field {
            name = "reserved";
            desc = "Reserved.";
            sw = r; hw = w;
            reset = 0x0;
        } reserved_31_6[31:6];
        field {
            name = "rgmii1_txck_ds";
            desc = "RGMII1_TXCK pin drive current control.
- 00: 2.3mA;
- 01: 4.7mA;
- 10: 7.0mA;
- 11: 9.3mA.";
            sw = rw; hw = r;
            reset = 0x1;
        } rgmii1_txck_ds[5:4];
        field {
            name = "rgmii1_txck_sl";
            desc = "RGMII1_TXCK pin slew rate control.
- 0: Slow edge.
- 1: Fast edge.";
            sw = rw; hw = r;
            reset = 0x0;
        } rgmii1_txck_sl[3:3];
        field {
            name = "reserved";
            desc = "Reserved.";
            sw = r; hw = w;
            reset = 0x0;
        } reserved_2_0[2:0];
    } PADCTRL_REG30 @ 0x78;
    reg {
        name = "PADCTRL_REG31";
        desc = "PADCTRL_REG31 is the RGMII1_TXCKOUT pin drive capability register. PADCTRL_REG31 (offset 0x007C, total reset 0x0000_0058; PROVEN: Hi3535 data sheet, PDF page 174, section 2.4.2).";
        field {
            name = "reserved";
            desc = "Reserved.";
            sw = r; hw = w;
            reset = 0x0;
        } reserved_31_7[31:7];
        field {
            name = "rgmii1_txckout_ds";
            desc = "RGMII1_TXCKOUT pin drive current control.
- 000: 4.7mA;
- 001: 7.0mA;
- 010: 9.3mA;
- 011: 11.6mA;
- 100: 14.0mA;
- 101: 16.3mA;
- 110: 18.6mA;
- 111: 20.9mA.";
            sw = rw; hw = r;
            reset = 0x5;
        } rgmii1_txckout_ds[6:4];
        field {
            name = "rgmii1_txckout_sl";
            desc = "RGMII1_TXCKOUT pin slew rate control.
- 0: Slow edge;
- 1: Fast edge.";
            sw = rw; hw = r;
            reset = 0x1;
        } rgmii1_txckout_sl[3:3];
        field {
            name = "reserved";
            desc = "Reserved.";
            sw = r; hw = w;
            reset = 0x0;
        } reserved_2_0[2:0];
    } PADCTRL_REG31 @ 0x7c;
    reg {
        name = "PADCTRL_REG32";
        desc = "PADCTRL_REG32 is the RGMII1_CRS pin drive strength register. PADCTRL_REG32 (offset 0x0080, total reset 0x0000_0010; PROVEN: Hi3535 data sheet, PDF page 175, section 2.4.2).";
        field {
            name = "reserved";
            desc = "Reserved.";
            sw = r; hw = w;
            reset = 0x0;
        } reserved_31_6[31:6];
        field {
            name = "rgmii1_crs_ds";
            desc = "RGMII1_CRS pin drive current control.
- 00: 2.3 mA.
- 01: 4.7 mA.
- 10: 7.0 mA.
- 11: 9.3 mA.";
            sw = rw; hw = r;
            reset = 0x1;
        } rgmii1_crs_ds[5:4];
        field {
            name = "rgmii1_crs_sl";
            desc = "RGMII1_CRS pin slew rate control.
- 0: Slow edge;
- 1: Fast edge.";
            sw = rw; hw = r;
            reset = 0x0;
        } rgmii1_crs_sl[3:3];
        field {
            name = "reserved";
            desc = "Reserved.";
            sw = r; hw = w;
            reset = 0x0;
        } reserved_2_0[2:0];
    } PADCTRL_REG32 @ 0x80;
    reg {
        name = "PADCTRL_REG33";
        desc = "PADCTRL_REG33 is the RGMII1_COL pin drive capability register. PADCTRL_REG33 (offset 0x0084, total reset 0x0000_0010; PROVEN: Hi3535 data sheet, PDF page 176, section 2.4.2).";
        field {
            name = "reserved";
            desc = "Reserved.";
            sw = r; hw = w;
            reset = 0x0;
        } reserved_31_6[31:6];
        field {
            name = "rgmii1_col_ds";
            desc = "RGMII1_COL pin drive current control.
- 00: 2.3mA;
- 01: 4.7mA;
- 10: 7.0mA;
- 11: 9.3mA.";
            sw = rw; hw = r;
            reset = 0x1;
        } rgmii1_col_ds[5:4];
        field {
            name = "rgmii1_col_sl";
            desc = "RGMII1_COL pin slew rate control.
- 0: Slow edge;
- 1: Fast edge.";
            sw = rw; hw = r;
            reset = 0x0;
        } rgmii1_col_sl[3:3];
        field {
            name = "reserved";
            desc = "Reserved.";
            sw = r; hw = w;
            reset = 0x0;
        } reserved_2_0[2:0];
    } PADCTRL_REG33 @ 0x84;
    reg {
        name = "PADCTRL_REG34";
        desc = "PADCTRL_REG34 is the RGMII1_RXER pin drive capability register. PADCTRL_REG34 (offset 0x0088, total reset 0x0000_0010; PROVEN: Hi3535 data sheet, PDF page 177, section 2.4.2).";
        field {
            name = "reserved";
            desc = "Reserved.";
            sw = r; hw = w;
            reset = 0x0;
        } reserved_31_6[31:6];
        field {
            name = "rgmii1_rxer_ds";
            desc = "RGMII1_RXER pin drive current control.
- 00: 2.3mA;
- 01: 4.7mA;
- 10: 7.0mA;
- 11: 9.3mA.";
            sw = rw; hw = r;
            reset = 0x1;
        } rgmii1_rxer_ds[5:4];
        field {
            name = "rgmii1_rxer_sl";
            desc = "RGMII1_RXER pin slew rate control.
- 0: Slow slew.
- 1: Fast slew.";
            sw = rw; hw = r;
            reset = 0x0;
        } rgmii1_rxer_sl[3:3];
        field {
            name = "reserved";
            desc = "Reserved.";
            sw = r; hw = w;
            reset = 0x0;
        } reserved_2_0[2:0];
    } PADCTRL_REG34 @ 0x88;
    reg {
        name = "PADCTRL_REG35";
        desc = "PADCTRL_REG35 is the RGMII1_TXER pin drive capability register. PADCTRL_REG35 (offset 0x008C, total reset 0x0000_0058; PROVEN: Hi3535 data sheet, PDF page 178, section 2.4.2).";
        field {
            name = "reserved";
            desc = "Reserved.";
            sw = r; hw = w;
            reset = 0x0;
        } reserved_31_7[31:7];
        field {
            name = "rgmii1_txer_ds";
            desc = "RGMII1_TXER pin drive current control.
- 000: 4.7mA.
- 001: 7.0mA.
- 010: 9.3mA.
- 011: 11.6mA.
- 100: 14.0mA.
- 101: 16.3mA.
- 110: 18.6mA.
- 111: 20.9mA.";
            sw = rw; hw = r;
            reset = 0x5;
        } rgmii1_txer_ds[6:4];
        field {
            name = "rgmii1_txer_sl";
            desc = "RGMII1_TXER pin slew rate control.
- 0: Slow edge;
- 1: Fast edge.";
            sw = rw; hw = r;
            reset = 0x1;
        } rgmii1_txer_sl[3:3];
        field {
            name = "reserved";
            desc = "Reserved.";
            sw = r; hw = w;
            reset = 0x0;
        } reserved_2_0[2:0];
    } PADCTRL_REG35 @ 0x8c;
    reg {
        name = "PADCTRL_REG36";
        desc = "PADCTRL_REG36 is the MDCK pin drive strength register. PADCTRL_REG36 (offset 0x0090, total reset 0x0000_0020; PROVEN: Hi3535 data sheet, PDF page 179, section 2.4.2).";
        field {
            name = "reserved";
            desc = "Reserved.";
            sw = r; hw = w;
            reset = 0x0;
        } reserved_31_6[31:6];
        field {
            name = "mdck_ds";
            desc = "MDCK pin drive current control.
- 00: 2.3mA.
- 01: 4.7mA.
- 10: 7.0mA.
- 11: 9.3mA.";
            sw = rw; hw = r;
            reset = 0x2;
        } mdck_ds[5:4];
        field {
            name = "mdck_sl";
            desc = "MDCK pin slew rate control.
- 0: Slow edge;
- 1: Fast edge.";
            sw = rw; hw = r;
            reset = 0x0;
        } mdck_sl[3:3];
        field {
            name = "reserved";
            desc = "Reserved.";
            sw = r; hw = w;
            reset = 0x0;
        } reserved_2_0[2:0];
    } PADCTRL_REG36 @ 0x90;
    reg {
        name = "PADCTRL_REG37";
        desc = "PADCTRL_REG37 is the MDIO pin drive capability register. PADCTRL_REG37 (offset 0x0094, total reset 0x0000_0010; PROVEN: Hi3535 data sheet, PDF page 179, section 2.4.2).";
        field {
            name = "reserved";
            desc = "Reserved.";
            sw = r; hw = w;
            reset = 0x0;
        } reserved_31_6[31:6];
        field {
            name = "mdio_ds";
            desc = "MDIO pin drive current control.
- 00: 2.3mA;
- 01: 4.7mA;
- 10: 7.0mA;
- 11: 9.3mA.";
            sw = rw; hw = r;
            reset = 0x1;
        } mdio_ds[5:4];
        field {
            name = "mdio_sl";
            desc = "MDIO pin slew rate control.
- 0: Slow edge;
- 1: Fast edge.";
            sw = rw; hw = r;
            reset = 0x0;
        } mdio_sl[3:3];
        field {
            name = "reserved";
            desc = "Reserved.";
            sw = r; hw = w;
            reset = 0x0;
        } reserved_2_0[2:0];
    } PADCTRL_REG37 @ 0x94;
    reg {
        name = "PADCTRL_REG38";
        desc = "PADCTRL_REG38 is the IR_IN pin drive strength register. PADCTRL_REG38 (offset 0x0098, total reset 0x0000_0000; PROVEN: Hi3535 data sheet, PDF page 180, section 2.4.2).";
        field {
            name = "reserved";
            desc = "Reserved.";
            sw = r; hw = w;
            reset = 0x0;
        } reserved_31_6[31:6];
        field {
            name = "ir_in_ds";
            desc = "IR_IN pin drive current control.
- 00: 2.9mA;
- 01: 5.9mA;
- 10: 8.8mA;
- 11: 11.8mA.";
            sw = rw; hw = r;
            reset = 0x0;
        } ir_in_ds[5:4];
        field {
            name = "ir_in_sl";
            desc = "IR_IN pin slew rate control.
- 0: Slow edge;
- 1: Fast edge.";
            sw = rw; hw = r;
            reset = 0x0;
        } ir_in_sl[3:3];
        field {
            name = "reserved";
            desc = "Reserved.";
            sw = r; hw = w;
            reset = 0x0;
        } reserved_2_0[2:0];
    } PADCTRL_REG38 @ 0x98;
    reg {
        name = "PADCTRL_REG39";
        desc = "PADCTRL_REG39 is the SFC_DIO pin drive capability register. PADCTRL_REG39 (offset 0x009C, total reset 0x0000_0010; PROVEN: Hi3535 data sheet, PDF page 181, section 2.4.2).";
        field {
            name = "reserved";
            desc = "Reserved.";
            sw = r; hw = w;
            reset = 0x0;
        } reserved_31_6[31:6];
        field {
            name = "sfc_dio_ds";
            desc = "SFC_DIO pin drive current control.
- 00: 4.7mA.
- 01: 9.3mA.
- 10: 14mA.
- 11: 18.3mA.";
            sw = rw; hw = r;
            reset = 0x1;
        } sfc_dio_ds[5:4];
        field {
            name = "sfc_dio_sl";
            desc = "SFC_DIO pin slew rate control.
- 0: Slow edge.
- 1: Fast edge.";
            sw = rw; hw = r;
            reset = 0x0;
        } sfc_dio_sl[3:3];
        field {
            name = "reserved";
            desc = "Reserved.";
            sw = r; hw = w;
            reset = 0x0;
        } reserved_2_0[2:0];
    } PADCTRL_REG39 @ 0x9c;
    reg {
        name = "PADCTRL_REG40";
        desc = "PADCTRL_REG40 is the SFC_WP_IO2 pin drive strength register. PADCTRL_REG40 (offset 0x00A0, total reset 0x0000_0010; PROVEN: Hi3535 data sheet, PDF page 182, section 2.4.2).";
        field {
            name = "reserved";
            desc = "Reserved.";
            sw = r; hw = w;
            reset = 0x0;
        } reserved_31_6[31:6];
        field {
            name = "sfc_wp_io2_ds";
            desc = "SFC_WP_IO2 pin drive current control.
- 00: 4.7mA;
- 01: 9.3mA;
- 10: 14mA;
- 11: 18.3mA.";
            sw = rw; hw = r;
            reset = 0x1;
        } sfc_wp_io2_ds[5:4];
        field {
            name = "sfc_wp_io2_sl";
            desc = "SFC_WP_IO2 pin slew rate control.
- 0: Slow edge.
- 1: Fast edge.";
            sw = rw; hw = r;
            reset = 0x0;
        } sfc_wp_io2_sl[3:3];
        field {
            name = "reserved";
            desc = "Reserved.";
            sw = r; hw = w;
            reset = 0x0;
        } reserved_2_0[2:0];
    } PADCTRL_REG40 @ 0xa0;
    reg {
        name = "PADCTRL_REG41";
        desc = "PADCTRL_REG41 is the SFC_CLK pin drive capability register. PADCTRL_REG41 (offset 0x00A4, total reset 0x0000_0020; PROVEN: Hi3535 data sheet, PDF page 182, section 2.4.2).";
        field {
            name = "reserved";
            desc = "Reserved.";
            sw = r; hw = w;
            reset = 0x0;
        } reserved_31_6[31:6];
        field {
            name = "sfc_clk_ds";
            desc = "SFC_CLK pin drive current control.
- 00: 4.7mA;
- 01: 9.3mA;
- 10: 14mA;
- 11: 18.3mA.";
            sw = rw; hw = r;
            reset = 0x2;
        } sfc_clk_ds[5:4];
        field {
            name = "sfc_clk_sl";
            desc = "SFC_CLK pin slew rate control.
- 0: Slow edge;
- 1: Fast edge.";
            sw = rw; hw = r;
            reset = 0x0;
        } sfc_clk_sl[3:3];
        field {
            name = "reserved";
            desc = "Reserved.";
            sw = r; hw = w;
            reset = 0x0;
        } reserved_2_0[2:0];
    } PADCTRL_REG41 @ 0xa4;
    reg {
        name = "PADCTRL_REG42";
        desc = "PADCTRL_REG42 is the SFC_DOI pin drive capability register. PADCTRL_REG42 (offset 0x00A8, total reset 0x0000_0010; PROVEN: Hi3535 data sheet, PDF page 183, section 2.4.2).";
        field {
            name = "reserved";
            desc = "Reserved.";
            sw = r; hw = w;
            reset = 0x0;
        } reserved_31_6[31:6];
        field {
            name = "sfc_doi_ds";
            desc = "SFC_DOI pin drive current control.
- 00: 4.7mA;
- 01: 9.3mA;
- 10: 14mA;
- 11: 18.3mA.";
            sw = rw; hw = r;
            reset = 0x1;
        } sfc_doi_ds[5:4];
        field {
            name = "sfc_doi_sl";
            desc = "SFC_DOI pin slew rate control.
- 0: Slow edge;
- 1: Fast edge.";
            sw = rw; hw = r;
            reset = 0x0;
        } sfc_doi_sl[3:3];
        field {
            name = "reserved";
            desc = "Reserved.";
            sw = r; hw = w;
            reset = 0x0;
        } reserved_2_0[2:0];
    } PADCTRL_REG42 @ 0xa8;
    reg {
        name = "PADCTRL_REG43";
        desc = "PADCTRL_REG43 is the SFC_HOLD_IO3 pin drive strength register. PADCTRL_REG43 (offset 0x00AC, total reset 0x0000_0010; PROVEN: Hi3535 data sheet, PDF page 184, section 2.4.2).";
        field {
            name = "reserved";
            desc = "Reserved.";
            sw = r; hw = w;
            reset = 0x0;
        } reserved_31_6[31:6];
        field {
            name = "sfc_hold_io3_ds";
            desc = "SFC_HOLD_IO3 pin drive current control.
- 00: 4.7mA;
- 01: 9.3mA;
- 10: 14mA;
- 11: 18.3mA.";
            sw = rw; hw = r;
            reset = 0x1;
        } sfc_hold_io3_ds[5:4];
        field {
            name = "sfc_hold_io3_sl";
            desc = "SFC_HOLD_IO3 pin slew rate control.
- 0: Slow edge;
- 1: Fast edge.";
            sw = rw; hw = r;
            reset = 0x0;
        } sfc_hold_io3_sl[3:3];
        field {
            name = "reserved";
            desc = "Reserved.";
            sw = r; hw = w;
            reset = 0x0;
        } reserved_2_0[2:0];
    } PADCTRL_REG43 @ 0xac;
    reg {
        name = "PADCTRL_REG44";
        desc = "PADCTRL_REG44 is the SFC_CS0N pin drive capability register. PADCTRL_REG44 (offset 0x00B0, total reset 0x0000_0010; PROVEN: Hi3535 data sheet, PDF page 185, section 2.4.2).";
        field {
            name = "reserved";
            desc = "Reserved.";
            sw = r; hw = w;
            reset = 0x0;
        } reserved_31_6[31:6];
        field {
            name = "sfc_cs0n_ds";
            desc = "SFC_CS0N pin drive current control.
- 00: 4.7mA;
- 01: 9.3mA;
- 10: 14mA;
- 11: 18.3mA.";
            sw = rw; hw = r;
            reset = 0x1;
        } sfc_cs0n_ds[5:4];
        field {
            name = "sfc_cs0n_sl";
            desc = "SFC_CS0N pin slew rate control.
- 0: Slow slew.
- 1: Fast slew.";
            sw = rw; hw = r;
            reset = 0x0;
        } sfc_cs0n_sl[3:3];
        field {
            name = "reserved";
            desc = "Reserved.";
            sw = r; hw = w;
            reset = 0x0;
        } reserved_2_0[2:0];
    } PADCTRL_REG44 @ 0xb0;
    reg {
        name = "PADCTRL_REG45";
        desc = "PADCTRL_REG45 is the SFC_CS1N pin drive capability register. PADCTRL_REG45 (offset 0x00B4, total reset 0x0000_0010; PROVEN: Hi3535 data sheet, PDF page 185, section 2.4.2).";
        field {
            name = "reserved";
            desc = "Reserved.";
            sw = r; hw = w;
            reset = 0x0;
        } reserved_31_6[31:6];
        field {
            name = "sfc_cs1n_ds";
            desc = "SFC_CS1N pin drive current control.
- 00: 4.7mA;
- 01: 9.3mA;
- 10: 14mA;
- 11: 18.3mA.";
            sw = rw; hw = r;
            reset = 0x1;
        } sfc_cs1n_ds[5:4];
        field {
            name = "sfc_cs1n_sl";
            desc = "SFC_CS1N pin slew rate control.
- 0: Slow slew.
- 1: Fast slew.";
            sw = rw; hw = r;
            reset = 0x0;
        } sfc_cs1n_sl[3:3];
        field {
            name = "reserved";
            desc = "Reserved.";
            sw = r; hw = w;
            reset = 0x0;
        } reserved_2_0[2:0];
    } PADCTRL_REG45 @ 0xb4;
    reg {
        name = "PADCTRL_REG46";
        desc = "PADCTRL_REG46 is the NF_DQ0 pin drive capability register. PADCTRL_REG46 (offset 0x00B8, total reset 0x0000_0020; PROVEN: Hi3535 data sheet, PDF page 186, section 2.4.2).";
        field {
            name = "reserved";
            desc = "Reserved.";
            sw = r; hw = w;
            reset = 0x0;
        } reserved_31_6[31:6];
        field {
            name = "nf_dq0_ds";
            desc = "NF_DQ0 pin drive current control.
- 00: 2.3mA;
- 01: 4.7mA;
- 10: 7.0mA;
- 11: 9.3mA.";
            sw = rw; hw = r;
            reset = 0x2;
        } nf_dq0_ds[5:4];
        field {
            name = "nf_dq0_sl";
            desc = "NF_DQ0 pin slew rate control.
- 0: Slow edge;
- 1: Fast edge.";
            sw = rw; hw = r;
            reset = 0x0;
        } nf_dq0_sl[3:3];
        field {
            name = "reserved";
            desc = "Reserved.";
            sw = r; hw = w;
            reset = 0x0;
        } reserved_2_0[2:0];
    } PADCTRL_REG46 @ 0xb8;
    reg {
        name = "PADCTRL_REG47";
        desc = "PADCTRL_REG47 is the NF_DQ1 pin drive strength register. PADCTRL_REG47 (offset 0x00BC, total reset 0x0000_0020; PROVEN: Hi3535 data sheet, PDF page 187, section 2.4.2).";
        field {
            name = "reserved";
            desc = "Reserved.";
            sw = r; hw = w;
            reset = 0x0;
        } reserved_31_6[31:6];
        field {
            name = "nf_dq1_ds";
            desc = "NF_DQ1 pin drive current control.
- 00: 2.3mA.
- 01: 4.7mA.
- 10: 7.0mA.
- 11: 9.3mA.";
            sw = rw; hw = r;
            reset = 0x2;
        } nf_dq1_ds[5:4];
        field {
            name = "nf_dq1_sl";
            desc = "NF_DQ1 pin slew rate control.
- 0: Slow edge;
- 1: Fast edge.";
            sw = rw; hw = r;
            reset = 0x0;
        } nf_dq1_sl[3:3];
        field {
            name = "reserved";
            desc = "Reserved.";
            sw = r; hw = w;
            reset = 0x0;
        } reserved_2_0[2:0];
    } PADCTRL_REG47 @ 0xbc;
    reg {
        name = "PADCTRL_REG48";
        desc = "PADCTRL_REG48 is the NF_DQ2 pin drive capability register. PADCTRL_REG48 (offset 0x00C0, total reset 0x0000_0020; PROVEN: Hi3535 data sheet, PDF page 188, section 2.4.2).";
        field {
            name = "reserved";
            desc = "Reserved.";
            sw = r; hw = w;
            reset = 0x0;
        } reserved_31_6[31:6];
        field {
            name = "nf_dq2_ds";
            desc = "NF_DQ2 pin drive current control.
- 00: 2.3mA;
- 01: 4.7mA;
- 10: 7.0mA;
- 11: 9.3mA.";
            sw = rw; hw = r;
            reset = 0x2;
        } nf_dq2_ds[5:4];
        field {
            name = "nf_dq2_sl";
            desc = "NF_DQ2 pin slew rate control.
- 0: Slow edge;
- 1: Fast edge.";
            sw = rw; hw = r;
            reset = 0x0;
        } nf_dq2_sl[3:3];
        field {
            name = "reserved";
            desc = "Reserved.";
            sw = r; hw = w;
            reset = 0x0;
        } reserved_2_0[2:0];
    } PADCTRL_REG48 @ 0xc0;
    reg {
        name = "PADCTRL_REG49";
        desc = "PADCTRL_REG49 is the NF_DQ3 pin drive strength register. PADCTRL_REG49 (offset 0x00C4, total reset 0x0000_0020; PROVEN: Hi3535 data sheet, PDF page 188, section 2.4.2).";
        field {
            name = "reserved";
            desc = "Reserved.";
            sw = r; hw = w;
            reset = 0x0;
        } reserved_31_6[31:6];
        field {
            name = "nf_dq3_ds";
            desc = "NF_DQ3 pin drive current control.
- 00: 2.3mA;
- 01: 4.7mA;
- 10: 7.0mA;
- 11: 9.3mA.";
            sw = rw; hw = r;
            reset = 0x2;
        } nf_dq3_ds[5:4];
        field {
            name = "nf_dq3_sl";
            desc = "NF_DQ3 pin slew rate control.
- 0: Slow edge.
- 1: Fast edge.";
            sw = rw; hw = r;
            reset = 0x0;
        } nf_dq3_sl[3:3];
        field {
            name = "reserved";
            desc = "Reserved.";
            sw = r; hw = w;
            reset = 0x0;
        } reserved_2_0[2:0];
    } PADCTRL_REG49 @ 0xc4;
    reg {
        name = "PADCTRL_REG50";
        desc = "PADCTRL_REG50 is the NF_DQ4 pin drive capability register. PADCTRL_REG50 (offset 0x00C8, total reset 0x0000_0020; PROVEN: Hi3535 data sheet, PDF page 189, section 2.4.2).";
        field {
            name = "reserved";
            desc = "Reserved.";
            sw = r; hw = w;
            reset = 0x0;
        } reserved_31_6[31:6];
        field {
            name = "nf_dq4_ds";
            desc = "NF_DQ4 pin drive current control.
- 00: 2.3mA;
- 01: 4.7mA;
- 10: 7.0mA;
- 11: 9.3mA.";
            sw = rw; hw = r;
            reset = 0x2;
        } nf_dq4_ds[5:4];
        field {
            name = "nf_dq4_sl";
            desc = "NF_DQ4 pin slew rate control.
- 0: Slow edge;
- 1: Fast edge.";
            sw = rw; hw = r;
            reset = 0x0;
        } nf_dq4_sl[3:3];
        field {
            name = "reserved";
            desc = "Reserved.";
            sw = r; hw = w;
            reset = 0x0;
        } reserved_2_0[2:0];
    } PADCTRL_REG50 @ 0xc8;
    reg {
        name = "PADCTRL_REG51";
        desc = "PADCTRL_REG51 is the NF_DQ5 pin drive capability register. PADCTRL_REG51 (offset 0x00CC, total reset 0x0000_0020; PROVEN: Hi3535 data sheet, PDF page 190, section 2.4.2).";
        field {
            name = "reserved";
            desc = "Reserved.";
            sw = r; hw = w;
            reset = 0x0;
        } reserved_31_6[31:6];
        field {
            name = "nf_dq5_ds";
            desc = "NF_DQ5 pin drive current control.
- 00: 2.3mA;
- 01: 4.7mA;
- 10: 7.0mA;
- 11: 9.3mA.";
            sw = rw; hw = r;
            reset = 0x2;
        } nf_dq5_ds[5:4];
        field {
            name = "nf_dq5_sl";
            desc = "NF_DQ5 pin slew rate control.
- 0: Slow slew.
- 1: Fast slew.";
            sw = rw; hw = r;
            reset = 0x0;
        } nf_dq5_sl[3:3];
        field {
            name = "reserved";
            desc = "Reserved.";
            sw = r; hw = w;
            reset = 0x0;
        } reserved_2_0[2:0];
    } PADCTRL_REG51 @ 0xcc;
    reg {
        name = "PADCTRL_REG52";
        desc = "PADCTRL_REG52 is the NF_DQ6 pin drive strength register. PADCTRL_REG52 (offset 0x00D0, total reset 0x0000_0020; PROVEN: Hi3535 data sheet, PDF page 191, section 2.4.2).";
        field {
            name = "reserved";
            desc = "Reserved.";
            sw = r; hw = w;
            reset = 0x0;
        } reserved_31_6[31:6];
        field {
            name = "nf_dq6_ds";
            desc = "NF_DQ6 pin drive current control.
- 00: 2.3 mA.
- 01: 4.7 mA.
- 10: 7.0 mA.
- 11: 9.3 mA.";
            sw = rw; hw = r;
            reset = 0x2;
        } nf_dq6_ds[5:4];
        field {
            name = "nf_dq6_sl";
            desc = "NF_DQ6 pin slew rate control.
- 0: Slow edge;
- 1: Fast edge.";
            sw = rw; hw = r;
            reset = 0x0;
        } nf_dq6_sl[3:3];
        field {
            name = "reserved";
            desc = "Reserved.";
            sw = r; hw = w;
            reset = 0x0;
        } reserved_2_0[2:0];
    } PADCTRL_REG52 @ 0xd0;
    reg {
        name = "PADCTRL_REG53";
        desc = "PADCTRL_REG53 is the NF_DQ7 pin drive capability register. PADCTRL_REG53 (offset 0x00D4, total reset 0x0000_0020; PROVEN: Hi3535 data sheet, PDF page 191, section 2.4.2).";
        field {
            name = "reserved";
            desc = "Reserved.";
            sw = r; hw = w;
            reset = 0x0;
        } reserved_31_6[31:6];
        field {
            name = "nf_dq7_ds";
            desc = "NF_DQ7 pin drive current control.
- 00: 2.3mA;
- 01: 4.7mA;
- 10: 7.0mA;
- 11: 9.3mA.";
            sw = rw; hw = r;
            reset = 0x2;
        } nf_dq7_ds[5:4];
        field {
            name = "nf_dq7_sl";
            desc = "NF_DQ7 pin slew rate control.
- 0: Slow edge;
- 1: Fast edge.";
            sw = rw; hw = r;
            reset = 0x0;
        } nf_dq7_sl[3:3];
        field {
            name = "reserved";
            desc = "Reserved.";
            sw = r; hw = w;
            reset = 0x0;
        } reserved_2_0[2:0];
    } PADCTRL_REG53 @ 0xd4;
    reg {
        name = "PADCTRL_REG54";
        desc = "PADCTRL_REG54 is the NF_CSN0 pin drive strength register. PADCTRL_REG54 (offset 0x00D8, total reset 0x0000_0020; PROVEN: Hi3535 data sheet, PDF page 192, section 2.4.2).";
        field {
            name = "reserved";
            desc = "Reserved.";
            sw = r; hw = w;
            reset = 0x0;
        } reserved_31_6[31:6];
        field {
            name = "nf_csn0_ds";
            desc = "NF_CSN0 pin drive current control.
- 00: 2.3mA;
- 01: 4.7mA;
- 10: 7.0mA;
- 11: 9.3mA.";
            sw = rw; hw = r;
            reset = 0x2;
        } nf_csn0_ds[5:4];
        field {
            name = "nf_csn0_sl";
            desc = "NF_CSN0 pin slew rate control.
- 0: Slow edge;
- 1: Fast edge.";
            sw = rw; hw = r;
            reset = 0x0;
        } nf_csn0_sl[3:3];
        field {
            name = "reserved";
            desc = "Reserved.";
            sw = r; hw = w;
            reset = 0x0;
        } reserved_2_0[2:0];
    } PADCTRL_REG54 @ 0xd8;
    reg {
        name = "PADCTRL_REG55";
        desc = "PADCTRL_REG55 is the NF_CSN1 pin drive capability register. PADCTRL_REG55 (offset 0x00DC, total reset 0x0000_0020; PROVEN: Hi3535 data sheet, PDF page 193, section 2.4.2).";
        field {
            name = "reserved";
            desc = "Reserved.";
            sw = r; hw = w;
            reset = 0x0;
        } reserved_31_6[31:6];
        field {
            name = "nf_csn1_ds";
            desc = "NF_CSN1 pin drive current control.
- 00: 2.3mA.
- 01: 4.7mA.
- 10: 7.0mA.
- 11: 9.3mA.";
            sw = rw; hw = r;
            reset = 0x2;
        } nf_csn1_ds[5:4];
        field {
            name = "nf_csn1_sl";
            desc = "NF_CSN1 pin slew rate control.
- 0: Slow edge;
- 1: Fast edge.";
            sw = rw; hw = r;
            reset = 0x0;
        } nf_csn1_sl[3:3];
        field {
            name = "reserved";
            desc = "Reserved.";
            sw = r; hw = w;
            reset = 0x0;
        } reserved_2_0[2:0];
    } PADCTRL_REG55 @ 0xdc;
    reg {
        name = "PADCTRL_REG56";
        desc = "PADCTRL_REG56 is the NF_RDY0 pin drive capability register. PADCTRL_REG56 (offset 0x00E0, total reset 0x0000_0020; PROVEN: Hi3535 data sheet, PDF page 194, section 2.4.2).";
        field {
            name = "reserved";
            desc = "Reserved.";
            sw = r; hw = w;
            reset = 0x0;
        } reserved_31_6[31:6];
        field {
            name = "nf_rdy0_ds";
            desc = "NF_RDY0 pin drive current control.
- 00: 2.3mA;
- 01: 4.7mA;
- 10: 7.0mA;
- 11: 9.3mA.";
            sw = rw; hw = r;
            reset = 0x2;
        } nf_rdy0_ds[5:4];
        field {
            name = "nf_rdy0_sl";
            desc = "NF_RDY0 pin slew rate control.
- 0: Slow slew.
- 1: Fast slew.";
            sw = rw; hw = r;
            reset = 0x0;
        } nf_rdy0_sl[3:3];
        field {
            name = "reserved";
            desc = "Reserved.";
            sw = r; hw = w;
            reset = 0x0;
        } reserved_2_0[2:0];
    } PADCTRL_REG56 @ 0xe0;
    reg {
        name = "PADCTRL_REG57";
        desc = "PADCTRL_REG57 is the NF_RDY1 pin drive capability register. PADCTRL_REG57 (offset 0x00E4, total reset 0x0000_0020; PROVEN: Hi3535 data sheet, PDF page 194, section 2.4.2).";
        field {
            name = "reserved";
            desc = "Reserved.";
            sw = r; hw = w;
            reset = 0x0;
        } reserved_31_6[31:6];
        field {
            name = "nf_rdy1_ds";
            desc = "NF_RDY1 pin drive current control.
- 00: 2.3mA;
- 01: 4.7mA;
- 10: 7.0mA;
- 11: 9.3mA.";
            sw = rw; hw = r;
            reset = 0x2;
        } nf_rdy1_ds[5:4];
        field {
            name = "nf_rdy1_sl";
            desc = "NF_RDY1 pin slew rate control.
- 0: Slow edge.
- 1: Fast edge.";
            sw = rw; hw = r;
            reset = 0x0;
        } nf_rdy1_sl[3:3];
        field {
            name = "reserved";
            desc = "Reserved.";
            sw = r; hw = w;
            reset = 0x0;
        } reserved_2_0[2:0];
    } PADCTRL_REG57 @ 0xe4;
    reg {
        name = "PADCTRL_REG58";
        desc = "PADCTRL_REG58 is the NF_REN pin drive strength register. PADCTRL_REG58 (offset 0x00E8, total reset 0x0000_0010; PROVEN: Hi3535 data sheet, PDF page 195, section 2.4.2).";
        field {
            name = "reserved";
            desc = "Reserved.";
            sw = r; hw = w;
            reset = 0x0;
        } reserved_31_6[31:6];
        field {
            name = "nf_ren_ds";
            desc = "NF_REN pin drive current control.
- 00: 4.7mA;
- 01: 9.3mA;
- 10: 14mA;
- 11: 18.3mA.";
            sw = rw; hw = r;
            reset = 0x1;
        } nf_ren_ds[5:4];
        field {
            name = "nf_ren_sl";
            desc = "NF_REN pin slew rate control.
- 0: Slow edge;
- 1: Fast edge.";
            sw = rw; hw = r;
            reset = 0x0;
        } nf_ren_sl[3:3];
        field {
            name = "reserved";
            desc = "Reserved.";
            sw = r; hw = w;
            reset = 0x0;
        } reserved_2_0[2:0];
    } PADCTRL_REG58 @ 0xe8;
    reg {
        name = "PADCTRL_REG59";
        desc = "PADCTRL_REG59 is the NF_CLE pin drive capability register. PADCTRL_REG59 (offset 0x00EC, total reset 0x0000_0020; PROVEN: Hi3535 data sheet, PDF page 196, section 2.4.2).";
        field {
            name = "reserved";
            desc = "Reserved.";
            sw = r; hw = w;
            reset = 0x0;
        } reserved_31_6[31:6];
        field {
            name = "nf_cle_ds";
            desc = "NF_CLE pin drive current control.
- 00: 2.3mA;
- 01: 4.7mA;
- 10: 7.0mA;
- 11: 9.3mA.";
            sw = rw; hw = r;
            reset = 0x2;
        } nf_cle_ds[5:4];
        field {
            name = "nf_cle_sl";
            desc = "NF_CLE pin slew rate control.
- 0: Slow edge;
- 1: Fast edge.";
            sw = rw; hw = r;
            reset = 0x0;
        } nf_cle_sl[3:3];
        field {
            name = "reserved";
            desc = "Reserved.";
            sw = r; hw = w;
            reset = 0x0;
        } reserved_2_0[2:0];
    } PADCTRL_REG59 @ 0xec;
    reg {
        name = "PADCTRL_REG60";
        desc = "PADCTRL_REG60 is the NF_ALE pin drive capability register. PADCTRL_REG60 (offset 0x00F0, total reset 0x0000_0020; PROVEN: Hi3535 data sheet, PDF page 197, section 2.4.2).";
        field {
            name = "reserved";
            desc = "Reserved.";
            sw = r; hw = w;
            reset = 0x0;
        } reserved_31_6[31:6];
        field {
            name = "nf_ale_ds";
            desc = "NF_ALE pin drive current control.
- 00: 2.3mA;
- 01: 4.7mA;
- 10: 7.0mA;
- 11: 9.3mA.";
            sw = rw; hw = r;
            reset = 0x2;
        } nf_ale_ds[5:4];
        field {
            name = "nf_ale_sl";
            desc = "NF_ALE pin slew rate control.
- 0: Slow slew.
- 1: Fast slew.";
            sw = rw; hw = r;
            reset = 0x0;
        } nf_ale_sl[3:3];
        field {
            name = "reserved";
            desc = "Reserved.";
            sw = r; hw = w;
            reset = 0x0;
        } reserved_2_0[2:0];
    } PADCTRL_REG60 @ 0xf0;
    reg {
        name = "PADCTRL_REG61";
        desc = "PADCTRL_REG61 is the NF_WEN pin drive capability register. PADCTRL_REG61 (offset 0x00F4, total reset 0x0000_0010; PROVEN: Hi3535 data sheet, PDF page 197, section 2.4.2).";
        field {
            name = "reserved";
            desc = "Reserved.";
            sw = r; hw = w;
            reset = 0x0;
        } reserved_31_6[31:6];
        field {
            name = "nf_wen_ds";
            desc = "NF_WEN pin drive current control.
- 00: 4.7mA.
- 01: 9.3mA.
- 10: 14mA.
- 11: 18.3mA.";
            sw = rw; hw = r;
            reset = 0x1;
        } nf_wen_ds[5:4];
        field {
            name = "nf_wen_sl";
            desc = "NF_WEN pin slew rate control.
- 0: Slow edge.
- 1: Fast edge.";
            sw = rw; hw = r;
            reset = 0x0;
        } nf_wen_sl[3:3];
        field {
            name = "reserved";
            desc = "Reserved.";
            sw = r; hw = w;
            reset = 0x0;
        } reserved_2_0[2:0];
    } PADCTRL_REG61 @ 0xf4;
    reg {
        name = "PADCTRL_REG62";
        desc = "PADCTRL_REG62 is the JTAG_EN pin drive capability register. PADCTRL_REG62 (offset 0x00F8, total reset 0x0000_0010; PROVEN: Hi3535 data sheet, PDF page 198, section 2.4.2).";
        field {
            name = "reserved";
            desc = "Reserved.";
            sw = r; hw = w;
            reset = 0x0;
        } reserved_31_6[31:6];
        field {
            name = "jtag_en_ds";
            desc = "JTAG_EN pin drive current control.
- 00: 2.3mA;
- 01: 4.7mA;
- 10: 7.0mA;
- 11: 9.3mA.";
            sw = rw; hw = r;
            reset = 0x1;
        } jtag_en_ds[5:4];
        field {
            name = "jtag_en_sl";
            desc = "JTAG_EN pin slew rate control.
- 0: Slow edge;
- 1: Fast edge.";
            sw = rw; hw = r;
            reset = 0x0;
        } jtag_en_sl[3:3];
        field {
            name = "reserved";
            desc = "Reserved.";
            sw = r; hw = w;
            reset = 0x0;
        } reserved_2_0[2:0];
    } PADCTRL_REG62 @ 0xf8;
    reg {
        name = "PADCTRL_REG63";
        desc = "PADCTRL_REG63 is the JTAG_TRSTN pin drive strength register. PADCTRL_REG63 (offset 0x00FC, total reset 0x0000_0000; PROVEN: Hi3535 data sheet, PDF page 199, section 2.4.2).";
        field {
            name = "reserved";
            desc = "Reserved.";
            sw = r; hw = w;
            reset = 0x0;
        } reserved_31_6[31:6];
        field {
            name = "jtag_trstn_ds";
            desc = "JTAG_TRSTN pin drive current control.
- 00: 2.9mA;
- 01: 5.9mA;
- 10: 8.8mA;
- 11: 11.8mA.";
            sw = rw; hw = r;
            reset = 0x0;
        } jtag_trstn_ds[5:4];
        field {
            name = "jtag_trstn_sl";
            desc = "JTAG_TRSTN pin slew rate control.
- 0: Slow edge;
- 1: Fast edge.";
            sw = rw; hw = r;
            reset = 0x0;
        } jtag_trstn_sl[3:3];
        field {
            name = "reserved";
            desc = "Reserved.";
            sw = r; hw = w;
            reset = 0x0;
        } reserved_2_0[2:0];
    } PADCTRL_REG63 @ 0xfc;
    reg {
        name = "PADCTRL_REG64";
        desc = "PADCTRL_REG64 is the JTAG_TCK pin drive capability register. PADCTRL_REG64 (offset 0x0100, total reset 0x0000_0020; PROVEN: Hi3535 data sheet, PDF page 200, section 2.4.2).";
        field {
            name = "reserved";
            desc = "Reserved.";
            sw = r; hw = w;
            reset = 0x0;
        } reserved_31_6[31:6];
        field {
            name = "jtag_tck_ds";
            desc = "JTAG_TCK pin drive current control.
- 00: 2.9mA;
- 01: 5.9mA;
- 10: 8.8mA;
- 11: 11.8mA.";
            sw = rw; hw = r;
            reset = 0x2;
        } jtag_tck_ds[5:4];
        field {
            name = "jtag_tck_sl";
            desc = "JTAG_TCK pin slew rate control.
- 0: Slow edge;
- 1: Fast edge.";
            sw = rw; hw = r;
            reset = 0x0;
        } jtag_tck_sl[3:3];
        field {
            name = "reserved";
            desc = "Reserved.";
            sw = r; hw = w;
            reset = 0x0;
        } reserved_2_0[2:0];
    } PADCTRL_REG64 @ 0x100;
    reg {
        name = "PADCTRL_REG65";
        desc = "PADCTRL_REG65 is the JTAG_TMS pin drive strength register. PADCTRL_REG65 (offset 0x0104, total reset 0x0000_0000; PROVEN: Hi3535 data sheet, PDF page 200, section 2.4.2).";
        field {
            name = "reserved";
            desc = "Reserved.";
            sw = r; hw = w;
            reset = 0x0;
        } reserved_31_6[31:6];
        field {
            name = "jtag_tms_ds";
            desc = "JTAG_TMS pin drive current control.
- 00: 2.9mA;
- 01: 5.9mA;
- 10: 8.8mA;
- 11: 11.8mA.";
            sw = rw; hw = r;
            reset = 0x0;
        } jtag_tms_ds[5:4];
        field {
            name = "jtag_tms_sl";
            desc = "JTAG_TMS pin slew rate control.
- 0: Slow slew.
- 1: Fast slew.";
            sw = rw; hw = r;
            reset = 0x0;
        } jtag_tms_sl[3:3];
        field {
            name = "reserved";
            desc = "Reserved.";
            sw = r; hw = w;
            reset = 0x0;
        } reserved_2_0[2:0];
    } PADCTRL_REG65 @ 0x104;
    reg {
        name = "PADCTRL_REG66";
        desc = "PADCTRL_REG66 is the JTAG_TDO pin drive capability register. PADCTRL_REG66 (offset 0x0108, total reset 0x0000_0000; PROVEN: Hi3535 data sheet, PDF page 201, section 2.4.2).";
        field {
            name = "reserved";
            desc = "Reserved.";
            sw = r; hw = w;
            reset = 0x0;
        } reserved_31_6[31:6];
        field {
            name = "jtag_tdo_ds";
            desc = "JTAG_TDO pin drive current control.
- 00: 2.9 mA.
- 01: 5.9 mA.
- 10: 8.8 mA.
- 11: 11.8 mA.";
            sw = rw; hw = r;
            reset = 0x0;
        } jtag_tdo_ds[5:4];
        field {
            name = "jtag_tdo_sl";
            desc = "JTAG_TDO pin slew rate control.
- 0: Slow edge;
- 1: Fast edge.";
            sw = rw; hw = r;
            reset = 0x0;
        } jtag_tdo_sl[3:3];
        field {
            name = "reserved";
            desc = "Reserved.";
            sw = r; hw = w;
            reset = 0x0;
        } reserved_2_0[2:0];
    } PADCTRL_REG66 @ 0x108;
    reg {
        name = "PADCTRL_REG67";
        desc = "PADCTRL_REG67 is the JTAG_TDI pin drive capability register. PADCTRL_REG67 (offset 0x010C, total reset 0x0000_0000; PROVEN: Hi3535 data sheet, PDF page 202, section 2.4.2).";
        field {
            name = "reserved";
            desc = "Reserved.";
            sw = r; hw = w;
            reset = 0x0;
        } reserved_31_6[31:6];
        field {
            name = "jtag_tdi_ds";
            desc = "JTAG_TDI pin drive current control.
- 00: 2.9mA;
- 01: 5.9mA;
- 10: 8.8mA;
- 11: 11.8mA.";
            sw = rw; hw = r;
            reset = 0x0;
        } jtag_tdi_ds[5:4];
        field {
            name = "jtag_tdi_sl";
            desc = "JTAG_TDI pin slew rate control.
- 0: Slow edge.
- 1: Fast edge.";
            sw = rw; hw = r;
            reset = 0x0;
        } jtag_tdi_sl[3:3];
        field {
            name = "reserved";
            desc = "Reserved.";
            sw = r; hw = w;
            reset = 0x0;
        } reserved_2_0[2:0];
    } PADCTRL_REG67 @ 0x10c;
    reg {
        name = "PADCTRL_REG68";
        desc = "PADCTRL_REG68 is the RSTN pin drive capability register. PADCTRL_REG68 (offset 0x0110, total reset 0x0000_0010; PROVEN: Hi3535 data sheet, PDF page 203, section 2.4.2).";
        field {
            name = "reserved";
            desc = "Reserved.";
            sw = r; hw = w;
            reset = 0x0;
        } reserved_31_6[31:6];
        field {
            name = "rstn_ds";
            desc = "RSTN pin drive current control.
- 00: 2.3mA.
- 01: 4.7mA.
- 10: 7.0mA.
- 11: 9.3mA.";
            sw = rw; hw = r;
            reset = 0x1;
        } rstn_ds[5:4];
        field {
            name = "rstn_sl";
            desc = "RSTN pin slew rate control.
- 0: Slow edge;
- 1: Fast edge.";
            sw = rw; hw = r;
            reset = 0x0;
        } rstn_sl[3:3];
        field {
            name = "reserved";
            desc = "Reserved.";
            sw = r; hw = w;
            reset = 0x0;
        } reserved_2_0[2:0];
    } PADCTRL_REG68 @ 0x110;
    reg {
        name = "PADCTRL_REG69";
        desc = "PADCTRL_REG69 is the WDG_RSTN pin drive strength register. PADCTRL_REG69 (offset 0x0114, total reset 0x0000_0010; PROVEN: Hi3535 data sheet, PDF page 203, section 2.4.2).";
        field {
            name = "reserved";
            desc = "Reserved.";
            sw = r; hw = w;
            reset = 0x0;
        } reserved_31_6[31:6];
        field {
            name = "wdg_rstn_ds";
            desc = "WDG_RSTN pin drive current control.
- 00: 2.3 mA.
- 01: 4.7 mA.
- 10: 7.0 mA.
- 11: 9.3 mA.";
            sw = rw; hw = r;
            reset = 0x1;
        } wdg_rstn_ds[5:4];
        field {
            name = "wdg_rstn_sl";
            desc = "WDG_RSTN pin slew rate control.
- 0: Slow edge;
- 1: Fast edge.";
            sw = rw; hw = r;
            reset = 0x0;
        } wdg_rstn_sl[3:3];
        field {
            name = "reserved";
            desc = "Reserved.";
            sw = r; hw = w;
            reset = 0x0;
        } reserved_2_0[2:0];
    } PADCTRL_REG69 @ 0x114;
    reg {
        name = "PADCTRL_REG70";
        desc = "PADCTRL_REG70 is the TEST_MODE pin drive strength register. PADCTRL_REG70 (offset 0x0118, total reset 0x0000_0010; PROVEN: Hi3535 data sheet, PDF page 204, section 2.4.2).";
        field {
            name = "reserved";
            desc = "Reserved.";
            sw = r; hw = w;
            reset = 0x0;
        } reserved_31_6[31:6];
        field {
            name = "test_mode_ds";
            desc = "TEST_MODE pin drive current control.
- 00: 2.3mA;
- 01: 4.7mA;
- 10: 7.0mA;
- 11: 9.3mA.";
            sw = rw; hw = r;
            reset = 0x1;
        } test_mode_ds[5:4];
        field {
            name = "test_mode_sl";
            desc = "TEST_MODE pin slew rate control.
- 0: Slow edge;
- 1: Fast edge.";
            sw = rw; hw = r;
            reset = 0x0;
        } test_mode_sl[3:3];
        field {
            name = "reserved";
            desc = "Reserved.";
            sw = r; hw = w;
            reset = 0x0;
        } reserved_2_0[2:0];
    } PADCTRL_REG70 @ 0x118;
    reg {
        name = "PADCTRL_REG71";
        desc = "PADCTRL_REG71 is the USB2_OVRCUR0 pin drive capability register. PADCTRL_REG71 (offset 0x011C, total reset 0x0000_0000; PROVEN: Hi3535 data sheet, PDF page 205, section 2.4.2).";
        field {
            name = "reserved";
            desc = "Reserved.";
            sw = r; hw = w;
            reset = 0x0;
        } reserved_31_6[31:6];
        field {
            name = "usb2_ovrcur0_ds";
            desc = "USB2_OVRCUR0 pin drive current control.
- 00: 2.9mA;
- 01: 5.9mA;
- 10: 8.8mA;
- 11: 11.8mA.";
            sw = rw; hw = r;
            reset = 0x0;
        } usb2_ovrcur0_ds[5:4];
        field {
            name = "usb2_ovrcur0_sl";
            desc = "USB2_OVRCUR0 pin slew rate control.
- 0: Slow edge;
- 1: Fast edge.";
            sw = rw; hw = r;
            reset = 0x0;
        } usb2_ovrcur0_sl[3:3];
        field {
            name = "reserved";
            desc = "Reserved.";
            sw = r; hw = w;
            reset = 0x0;
        } reserved_2_0[2:0];
    } PADCTRL_REG71 @ 0x11c;
    reg {
        name = "PADCTRL_REG72";
        desc = "PADCTRL_REG72 is the USB2_PWREN0 pin drive capability register. PADCTRL_REG72 (offset 0x0120, total reset 0x0000_0000; PROVEN: Hi3535 data sheet, PDF page 206, section 2.4.2).";
        field {
            name = "reserved";
            desc = "Reserved.";
            sw = r; hw = w;
            reset = 0x0;
        } reserved_31_6[31:6];
        field {
            name = "usb2_pwren0_ds";
            desc = "USB2_PWREN0 pin drive current control.
- 00: 2.9mA.
- 01: 5.9mA.
- 10: 8.8mA.
- 11: 11.8mA.";
            sw = rw; hw = r;
            reset = 0x0;
        } usb2_pwren0_ds[5:4];
        field {
            name = "usb2_pwren0_sl";
            desc = "USB2_PWREN0 pin slew rate control.
- 0: Slow edge;
- 1: Fast edge.";
            sw = rw; hw = r;
            reset = 0x0;
        } usb2_pwren0_sl[3:3];
        field {
            name = "reserved";
            desc = "Reserved.";
            sw = r; hw = w;
            reset = 0x0;
        } reserved_2_0[2:0];
    } PADCTRL_REG72 @ 0x120;
    reg {
        name = "PADCTRL_REG73";
        desc = "PADCTRL_REG73 is the USB2_OVRCUR1 pin drive capability register. PADCTRL_REG73 (offset 0x0124, total reset 0x0000_0000; PROVEN: Hi3535 data sheet, PDF page 207, section 2.4.2).";
        field {
            name = "reserved";
            desc = "Reserved.";
            sw = r; hw = w;
            reset = 0x0;
        } reserved_31_6[31:6];
        field {
            name = "usb2_ovrcur1_ds";
            desc = "USB2_OVRCUR1 pin drive current control.
- 00: 2.9 mA.
- 01: 5.9 mA.
- 10: 8.8 mA.
- 11: 11.8 mA.";
            sw = rw; hw = r;
            reset = 0x0;
        } usb2_ovrcur1_ds[5:4];
        field {
            name = "usb2_ovrcur1_sl";
            desc = "USB2_OVRCUR1 pin slew rate control.
- 0: Slow edge;
- 1: Fast edge.";
            sw = rw; hw = r;
            reset = 0x0;
        } usb2_ovrcur1_sl[3:3];
        field {
            name = "reserved";
            desc = "Reserved.";
            sw = r; hw = w;
            reset = 0x0;
        } reserved_2_0[2:0];
    } PADCTRL_REG73 @ 0x124;
    reg {
        name = "PADCTRL_REG74";
        desc = "PADCTRL_REG74 is the USB2_PWREN1 pin drive strength register. PADCTRL_REG74 (offset 0x0128, total reset 0x0000_0000; PROVEN: Hi3535 data sheet, PDF page 208, section 2.4.2).";
        field {
            name = "reserved";
            desc = "Reserved.";
            sw = r; hw = w;
            reset = 0x0;
        } reserved_31_6[31:6];
        field {
            name = "usb2_pwren1_ds";
            desc = "USB2_PWREN1 pin drive current control.
- 00: 2.9mA;
- 01: 5.9mA;
- 10: 8.8mA;
- 11: 11.8mA.";
            sw = rw; hw = r;
            reset = 0x0;
        } usb2_pwren1_ds[5:4];
        field {
            name = "usb2_pwren1_sl";
            desc = "USB2_PWREN1 pin slew rate control.
- 0: Slow edge;
- 1: Fast edge.";
            sw = rw; hw = r;
            reset = 0x0;
        } usb2_pwren1_sl[3:3];
        field {
            name = "reserved";
            desc = "Reserved.";
            sw = r; hw = w;
            reset = 0x0;
        } reserved_2_0[2:0];
    } PADCTRL_REG74 @ 0x128;
    reg {
        name = "PADCTRL_REG75";
        desc = "PADCTRL_REG75 is the USB3_OVRCUR pin drive capability register. PADCTRL_REG75 (offset 0x012C, total reset 0x0000_0000; PROVEN: Hi3535 data sheet, PDF page 209, section 2.4.2).";
        field {
            name = "reserved";
            desc = "Reserved.";
            sw = r; hw = w;
            reset = 0x0;
        } reserved_31_6[31:6];
        field {
            name = "usb3_ovrcur_ds";
            desc = "USB3_OVRCUR pin drive current control.
- 00: 2.9mA.
- 01: 5.9mA.
- 10: 8.8mA.
- 11: 11.8mA.";
            sw = rw; hw = r;
            reset = 0x0;
        } usb3_ovrcur_ds[5:4];
        field {
            name = "usb3_ovrcur_sl";
            desc = "USB3_OVRCUR pin slew rate control.
- 0: Slow edge;
- 1: Fast edge.";
            sw = rw; hw = r;
            reset = 0x0;
        } usb3_ovrcur_sl[3:3];
        field {
            name = "reserved";
            desc = "Reserved.";
            sw = r; hw = w;
            reset = 0x0;
        } reserved_2_0[2:0];
    } PADCTRL_REG75 @ 0x12c;
    reg {
        name = "PADCTRL_REG76";
        desc = "PADCTRL_REG76 is the USB3_PWREN pin drive strength register. PADCTRL_REG76 (offset 0x0130, total reset 0x0000_0000; PROVEN: Hi3535 data sheet, PDF page 210, section 2.4.2).";
        field {
            name = "reserved";
            desc = "Reserved.";
            sw = r; hw = w;
            reset = 0x0;
        } reserved_31_6[31:6];
        field {
            name = "usb3_pwren_ds";
            desc = "USB3_PWREN pin drive current control.
- 00: 2.9mA;
- 01: 5.9mA;
- 10: 8.8mA;
- 11: 11.8mA.";
            sw = rw; hw = r;
            reset = 0x0;
        } usb3_pwren_ds[5:4];
        field {
            name = "usb3_pwren_sl";
            desc = "USB3_PWREN pin slew rate control.
- 0: Slow edge.
- 1: Fast edge.";
            sw = rw; hw = r;
            reset = 0x0;
        } usb3_pwren_sl[3:3];
        field {
            name = "reserved";
            desc = "Reserved.";
            sw = r; hw = w;
            reset = 0x0;
        } reserved_2_0[2:0];
    } PADCTRL_REG76 @ 0x130;
    reg {
        name = "PADCTRL_REG77";
        desc = "PADCTRL_REG77 is the HDMI_HOTPLUG pin drive capability register. PADCTRL_REG77 (offset 0x0134, total reset 0x0000_0010; PROVEN: Hi3535 data sheet, PDF page 211, section 2.4.2).";
        field {
            name = "reserved";
            desc = "Reserved.";
            sw = r; hw = w;
            reset = 0x0;
        } reserved_31_6[31:6];
        field {
            name = "hdmi_hotplug_ds";
            desc = "HDMI_HOTPLUG pin drive current control.
- 00: 2.9 mA.
- 01: 5.9 mA.
- 10: 8.8 mA.
- 11: 11.8 mA.";
            sw = rw; hw = r;
            reset = 0x1;
        } hdmi_hotplug_ds[5:4];
        field {
            name = "hdmi_hotplug_sl";
            desc = "HDMI_HOTPLUG pin slew rate control.
- 0: Slow edge;
- 1: Fast edge.";
            sw = rw; hw = r;
            reset = 0x0;
        } hdmi_hotplug_sl[3:3];
        field {
            name = "reserved";
            desc = "Reserved.";
            sw = r; hw = w;
            reset = 0x0;
        } reserved_2_0[2:0];
    } PADCTRL_REG77 @ 0x134;
    reg {
        name = "PADCTRL_REG78";
        desc = "PADCTRL_REG78 is the HDMI_CEC pin drive capability register. PADCTRL_REG78 (offset 0x0138, total reset 0x0000_0010; PROVEN: Hi3535 data sheet, PDF page 212, section 2.4.2).";
        field {
            name = "reserved";
            desc = "Reserved.";
            sw = r; hw = w;
            reset = 0x0;
        } reserved_31_6[31:6];
        field {
            name = "hdmi_cec_ds";
            desc = "HDMI_CEC pin drive current control.
- 00: 2.3mA;
- 01: 4.7mA;
- 10: 7.0mA;
- 11: 9.3mA.";
            sw = rw; hw = r;
            reset = 0x1;
        } hdmi_cec_ds[5:4];
        field {
            name = "hdmi_cec_sl";
            desc = "HDMI_CEC pin slew rate control.
- 0: Slow slew.
- 1: Fast slew.";
            sw = rw; hw = r;
            reset = 0x0;
        } hdmi_cec_sl[3:3];
        field {
            name = "reserved";
            desc = "Reserved.";
            sw = r; hw = w;
            reset = 0x0;
        } reserved_2_0[2:0];
    } PADCTRL_REG78 @ 0x138;
    reg {
        name = "PADCTRL_REG79";
        desc = "PADCTRL_REG79 is the HDMI_SDA pin drive capability register. PADCTRL_REG79 (offset 0x013C, total reset 0x0000_0010; PROVEN: Hi3535 data sheet, PDF page 212, section 2.4.2).";
        field {
            name = "reserved";
            desc = "Reserved.";
            sw = r; hw = w;
            reset = 0x0;
        } reserved_31_6[31:6];
        field {
            name = "hdmi_sda_ds";
            desc = "HDMI_SDA pin drive current control.
- 00: 2.9mA;
- 01: 5.9mA;
- 10: 8.8mA;
- 11: 11.8mA.";
            sw = rw; hw = r;
            reset = 0x1;
        } hdmi_sda_ds[5:4];
        field {
            name = "hdmi_sda_sl";
            desc = "HDMI_SDA pin slew rate control.
- 0: Slow edge;
- 1: Fast edge.";
            sw = rw; hw = r;
            reset = 0x0;
        } hdmi_sda_sl[3:3];
        field {
            name = "reserved";
            desc = "Reserved.";
            sw = r; hw = w;
            reset = 0x0;
        } reserved_2_0[2:0];
    } PADCTRL_REG79 @ 0x13c;
    reg {
        name = "PADCTRL_REG80";
        desc = "PADCTRL_REG80 is the HDMI_SCL pin drive capability register. PADCTRL_REG80 (offset 0x0140, total reset 0x0000_0010; PROVEN: Hi3535 data sheet, PDF page 213, section 2.4.2).";
        field {
            name = "reserved";
            desc = "Reserved.";
            sw = r; hw = w;
            reset = 0x0;
        } reserved_31_6[31:6];
        field {
            name = "hdmi_scl_ds";
            desc = "HDMI_SCL pin drive current control.
- 00: 2.9mA;
- 01: 5.9mA;
- 10: 8.8mA;
- 11: 11.8mA.";
            sw = rw; hw = r;
            reset = 0x1;
        } hdmi_scl_ds[5:4];
        field {
            name = "hdmi_scl_sl";
            desc = "HDMI_SCL pin slew rate control.
- 0: Slow edge;
- 1: Fast edge.";
            sw = rw; hw = r;
            reset = 0x0;
        } hdmi_scl_sl[3:3];
        field {
            name = "reserved";
            desc = "Reserved.";
            sw = r; hw = w;
            reset = 0x0;
        } reserved_2_0[2:0];
    } PADCTRL_REG80 @ 0x140;
    reg {
        name = "PADCTRL_REG81";
        desc = "PADCTRL_REG81 is the UART0_RTSN pin drive strength register. PADCTRL_REG81 (offset 0x0144, total reset 0x0000_0000; PROVEN: Hi3535 data sheet, PDF page 214, section 2.4.2).";
        field {
            name = "reserved";
            desc = "Reserved.";
            sw = r; hw = w;
            reset = 0x0;
        } reserved_31_6[31:6];
        field {
            name = "uart0_rtsn_ds";
            desc = "UART0_RTSN pin drive current control.
- 00: 2.9 mA.
- 01: 5.9 mA.
- 10: 8.8 mA.
- 11: 11.8 mA.";
            sw = rw; hw = r;
            reset = 0x0;
        } uart0_rtsn_ds[5:4];
        field {
            name = "uart0_rtsn_sl";
            desc = "UART0_RTSN pin slew rate control.
- 0: Slow edge;
- 1: Fast edge.";
            sw = rw; hw = r;
            reset = 0x0;
        } uart0_rtsn_sl[3:3];
        field {
            name = "reserved";
            desc = "Reserved.";
            sw = r; hw = w;
            reset = 0x0;
        } reserved_2_0[2:0];
    } PADCTRL_REG81 @ 0x144;
    reg {
        name = "PADCTRL_REG82";
        desc = "PADCTRL_REG82 is the UART0_RXD pin drive capability register. PADCTRL_REG82 (offset 0x0148, total reset 0x0000_0000; PROVEN: Hi3535 data sheet, PDF page 215, section 2.4.2).";
        field {
            name = "reserved";
            desc = "Reserved.";
            sw = r; hw = w;
            reset = 0x0;
        } reserved_31_6[31:6];
        field {
            name = "uart0_rxd_ds";
            desc = "UART0_RXD pin drive current control.
- 00: 2.9mA;
- 01: 5.9mA;
- 10: 8.8mA;
- 11: 11.8mA.";
            sw = rw; hw = r;
            reset = 0x0;
        } uart0_rxd_ds[5:4];
        field {
            name = "uart0_rxd_sl";
            desc = "UART0_RXD pin slew rate control.
- 0: Slow slew.
- 1: Fast slew.";
            sw = rw; hw = r;
            reset = 0x0;
        } uart0_rxd_sl[3:3];
        field {
            name = "reserved";
            desc = "Reserved.";
            sw = r; hw = w;
            reset = 0x0;
        } reserved_2_0[2:0];
    } PADCTRL_REG82 @ 0x148;
    reg {
        name = "PADCTRL_REG83";
        desc = "PADCTRL_REG83 is the UART0_TXD pin drive capability register. PADCTRL_REG83 (offset 0x014C, total reset 0x0000_0000; PROVEN: Hi3535 data sheet, PDF page 216, section 2.4.2).";
        field {
            name = "reserved";
            desc = "Reserved.";
            sw = r; hw = w;
            reset = 0x0;
        } reserved_31_6[31:6];
        field {
            name = "uart0_txd_ds";
            desc = "UART0_TXD pin drive current control.
- 00: 2.9mA;
- 01: 5.9mA;
- 10: 8.8mA;
- 11: 11.8mA.";
            sw = rw; hw = r;
            reset = 0x0;
        } uart0_txd_ds[5:4];
        field {
            name = "uart0_txd_sl";
            desc = "UART0_TXD pin slew rate control.
- 0: Slow edge;
- 1: Fast edge.";
            sw = rw; hw = r;
            reset = 0x0;
        } uart0_txd_sl[3:3];
        field {
            name = "reserved";
            desc = "Reserved.";
            sw = r; hw = w;
            reset = 0x0;
        } reserved_2_0[2:0];
    } PADCTRL_REG83 @ 0x14c;
    reg {
        name = "PADCTRL_REG84";
        desc = "PADCTRL_REG84 is the UART0_CTSN pin drive capability register. PADCTRL_REG84 (offset 0x0150, total reset 0x0000_0000; PROVEN: Hi3535 data sheet, PDF page 217, section 2.4.2).";
        field {
            name = "reserved";
            desc = "Reserved.";
            sw = r; hw = w;
            reset = 0x0;
        } reserved_31_6[31:6];
        field {
            name = "uart0_ctsn_ds";
            desc = "UART0_CTSN pin drive current control.
- 00: 2.9mA;
- 01: 5.9mA;
- 10: 8.8mA;
- 11: 11.8mA.";
            sw = rw; hw = r;
            reset = 0x0;
        } uart0_ctsn_ds[5:4];
        field {
            name = "uart0_ctsn_sl";
            desc = "UART0_CTSN pin slew rate control.
- 0: Slow edge.
- 1: Fast edge.";
            sw = rw; hw = r;
            reset = 0x0;
        } uart0_ctsn_sl[3:3];
        field {
            name = "reserved";
            desc = "Reserved.";
            sw = r; hw = w;
            reset = 0x0;
        } reserved_2_0[2:0];
    } PADCTRL_REG84 @ 0x150;
    reg {
        name = "PADCTRL_REG85";
        desc = "PADCTRL_REG85 is the UART1_RTSN pin drive strength register. PADCTRL_REG85 (offset 0x0154, total reset 0x0000_0010; PROVEN: Hi3535 data sheet, PDF page 218, section 2.4.2).";
        field {
            name = "reserved";
            desc = "Reserved.";
            sw = r; hw = w;
            reset = 0x0;
        } reserved_31_6[31:6];
        field {
            name = "uart1_rtsn_ds";
            desc = "UART1_RTSN pin drive current control.
- 00: 2.3mA;
- 01: 4.7mA;
- 10: 7.0mA;
- 11: 9.3mA.";
            sw = rw; hw = r;
            reset = 0x1;
        } uart1_rtsn_ds[5:4];
        field {
            name = "uart1_rtsn_sl";
            desc = "UART1_RTSN pin slew rate control.
- 0: Slow edge;
- 1: Fast edge.";
            sw = rw; hw = r;
            reset = 0x0;
        } uart1_rtsn_sl[3:3];
        field {
            name = "reserved";
            desc = "Reserved.";
            sw = r; hw = w;
            reset = 0x0;
        } reserved_2_0[2:0];
    } PADCTRL_REG85 @ 0x154;
    reg {
        name = "PADCTRL_REG86";
        desc = "PADCTRL_REG86 is the UART1_RXD pin drive capability register. PADCTRL_REG86 (offset 0x0158, total reset 0x0000_0010; PROVEN: Hi3535 data sheet, PDF page 219, section 2.4.2).";
        field {
            name = "reserved";
            desc = "Reserved.";
            sw = r; hw = w;
            reset = 0x0;
        } reserved_31_6[31:6];
        field {
            name = "uart1_rxd_ds";
            desc = "UART1_RXD pin drive current control.
- 00: 2.3 mA.
- 01: 4.7 mA.
- 10: 7.0 mA.
- 11: 9.3 mA.";
            sw = rw; hw = r;
            reset = 0x1;
        } uart1_rxd_ds[5:4];
        field {
            name = "uart1_rxd_sl";
            desc = "UART1_RXD pin slew rate control.
- 0: Slow edge;
- 1: Fast edge.";
            sw = rw; hw = r;
            reset = 0x0;
        } uart1_rxd_sl[3:3];
        field {
            name = "reserved";
            desc = "Reserved.";
            sw = r; hw = w;
            reset = 0x0;
        } reserved_2_0[2:0];
    } PADCTRL_REG86 @ 0x158;
    reg {
        name = "PADCTRL_REG87";
        desc = "PADCTRL_REG87 is the UART1_CTSN pin drive strength register. PADCTRL_REG87 (offset 0x015C, total reset 0x0000_0010; PROVEN: Hi3535 data sheet, PDF page 220, section 2.4.2).";
        field {
            name = "reserved";
            desc = "Reserved.";
            sw = r; hw = w;
            reset = 0x0;
        } reserved_31_6[31:6];
        field {
            name = "uart1_ctsn_ds";
            desc = "UART1_CTSN pin drive current control.
- 00: 2.3mA.
- 01: 4.7mA.
- 10: 7.0mA.
- 11: 9.3mA.";
            sw = rw; hw = r;
            reset = 0x1;
        } uart1_ctsn_ds[5:4];
        field {
            name = "uart1_ctsn_sl";
            desc = "UART1_CTSN pin slew rate control.
- 0: Slow edge.
- 1: Fast edge.";
            sw = rw; hw = r;
            reset = 0x0;
        } uart1_ctsn_sl[3:3];
        field {
            name = "reserved";
            desc = "Reserved.";
            sw = r; hw = w;
            reset = 0x0;
        } reserved_2_0[2:0];
    } PADCTRL_REG87 @ 0x15c;
    reg {
        name = "PADCTRL_REG88";
        desc = "PADCTRL_REG88 is the UART1_TXD pin drive capability register. PADCTRL_REG88 (offset 0x0160, total reset 0x0000_0010; PROVEN: Hi3535 data sheet, PDF page 221, section 2.4.2).";
        field {
            name = "reserved";
            desc = "Reserved.";
            sw = r; hw = w;
            reset = 0x0;
        } reserved_31_6[31:6];
        field {
            name = "uart1_txd_ds";
            desc = "UART1_TXD pin drive current control.
- 00: 2.3mA.
- 01: 4.7mA.
- 10: 7.0mA.
- 11: 9.3mA.";
            sw = rw; hw = r;
            reset = 0x1;
        } uart1_txd_ds[5:4];
        field {
            name = "uart1_txd_sl";
            desc = "UART1_TXD pin slew rate control.
- 0: Slow edge;
- 1: Fast edge.";
            sw = rw; hw = r;
            reset = 0x0;
        } uart1_txd_sl[3:3];
        field {
            name = "reserved";
            desc = "Reserved.";
            sw = r; hw = w;
            reset = 0x0;
        } reserved_2_0[2:0];
    } PADCTRL_REG88 @ 0x160;
    reg {
        name = "PADCTRL_REG89";
        desc = "PADCTRL_REG89 is the UART2_RXD pin drive capability register. PADCTRL_REG89 (offset 0x0164, total reset 0x0000_0010; PROVEN: Hi3535 data sheet, PDF page 222, section 2.4.2).";
        field {
            name = "reserved";
            desc = "Reserved.";
            sw = r; hw = w;
            reset = 0x0;
        } reserved_31_6[31:6];
        field {
            name = "uart2_rxd_ds";
            desc = "UART2_RXD pin drive current control.
- 00: 2.3mA;
- 01: 4.7mA;
- 10: 7.0mA;
- 11: 9.3mA.";
            sw = rw; hw = r;
            reset = 0x1;
        } uart2_rxd_ds[5:4];
        field {
            name = "uart2_rxd_sl";
            desc = "UART2_RXD pin slew rate control.
- 0: Slow edge.
- 1: Fast edge.";
            sw = rw; hw = r;
            reset = 0x0;
        } uart2_rxd_sl[3:3];
        field {
            name = "reserved";
            desc = "Reserved.";
            sw = r; hw = w;
            reset = 0x0;
        } reserved_2_0[2:0];
    } PADCTRL_REG89 @ 0x164;
    reg {
        name = "PADCTRL_REG90";
        desc = "PADCTRL_REG90 is the UART2_TXD pin drive strength register. PADCTRL_REG90 (offset 0x0168, total reset 0x0000_0010; PROVEN: Hi3535 data sheet, PDF page 223, section 2.4.2).";
        field {
            name = "reserved";
            desc = "Reserved.";
            sw = r; hw = w;
            reset = 0x0;
        } reserved_31_6[31:6];
        field {
            name = "uart2_txd_ds";
            desc = "UART2_TXD pin drive current control.
- 00: 2.3mA;
- 01: 4.7mA;
- 10: 7.0mA;
- 11: 9.3mA.";
            sw = rw; hw = r;
            reset = 0x1;
        } uart2_txd_ds[5:4];
        field {
            name = "uart2_txd_sl";
            desc = "UART2_TXD pin slew rate control.
- 0: Slow edge;
- 1: Fast edge.";
            sw = rw; hw = r;
            reset = 0x0;
        } uart2_txd_sl[3:3];
        field {
            name = "reserved";
            desc = "Reserved.";
            sw = r; hw = w;
            reset = 0x0;
        } reserved_2_0[2:0];
    } PADCTRL_REG90 @ 0x168;
    reg {
        name = "PADCTRL_REG91";
        desc = "PADCTRL_REG91 is the UART3_RXD pin drive capability register. PADCTRL_REG91 (offset 0x016C, total reset 0x0000_0000; PROVEN: Hi3535 data sheet, PDF page 224, section 2.4.2).";
        field {
            name = "reserved";
            desc = "Reserved.";
            sw = r; hw = w;
            reset = 0x0;
        } reserved_31_6[31:6];
        field {
            name = "uart3_rxd_ds";
            desc = "UART3_RXD pin drive current control.
- 00: 2.9mA;
- 01: 5.9mA;
- 10: 8.8mA;
- 11: 11.8mA.";
            sw = rw; hw = r;
            reset = 0x0;
        } uart3_rxd_ds[5:4];
        field {
            name = "uart3_rxd_sl";
            desc = "UART3_RXD pin slew rate control.
- 0: Slow edge;
- 1: Fast edge.";
            sw = rw; hw = r;
            reset = 0x0;
        } uart3_rxd_sl[3:3];
        field {
            name = "reserved";
            desc = "Reserved.";
            sw = r; hw = w;
            reset = 0x0;
        } reserved_2_0[2:0];
    } PADCTRL_REG91 @ 0x16c;
    reg {
        name = "PADCTRL_REG92";
        desc = "PADCTRL_REG92 is the UART3_TXD pin drive strength register. PADCTRL_REG92 (offset 0x0170, total reset 0x0000_0000; PROVEN: Hi3535 data sheet, PDF page 225, section 2.4.2).";
        field {
            name = "reserved";
            desc = "Reserved.";
            sw = r; hw = w;
            reset = 0x0;
        } reserved_31_6[31:6];
        field {
            name = "uart3_txd_ds";
            desc = "UART3_TXD pin drive current control.
- 00: 2.9mA.
- 01: 5.9mA.
- 10: 8.8mA.
- 11: 11.8mA.";
            sw = rw; hw = r;
            reset = 0x0;
        } uart3_txd_ds[5:4];
        field {
            name = "uart3_txd_sl";
            desc = "UART3_TXD pin slew rate control.
- 0: Slow edge;
- 1: Fast edge.";
            sw = rw; hw = r;
            reset = 0x0;
        } uart3_txd_sl[3:3];
        field {
            name = "reserved";
            desc = "Reserved.";
            sw = r; hw = w;
            reset = 0x0;
        } reserved_2_0[2:0];
    } PADCTRL_REG92 @ 0x170;
    reg {
        name = "PADCTRL_REG93";
        desc = "PADCTRL_REG93 is the SATA_LED_N0 pin drive capability register. PADCTRL_REG93 (offset 0x0174, total reset 0x0000_0000; PROVEN: Hi3535 data sheet, PDF page 226, section 2.4.2).";
        field {
            name = "reserved";
            desc = "Reserved.";
            sw = r; hw = w;
            reset = 0x0;
        } reserved_31_6[31:6];
        field {
            name = "sata_led_n0_ds";
            desc = "SATA_LED_N0 pin drive current control.
- 00: 2.9mA;
- 01: 5.9mA;
- 10: 8.8mA;
- 11: 11.8mA.";
            sw = rw; hw = r;
            reset = 0x0;
        } sata_led_n0_ds[5:4];
        field {
            name = "sata_led_n0_sl";
            desc = "SATA_LED_N0 pin slew rate control.
- 0: Slow edge;
- 1: Fast edge.";
            sw = rw; hw = r;
            reset = 0x0;
        } sata_led_n0_sl[3:3];
        field {
            name = "reserved";
            desc = "Reserved.";
            sw = r; hw = w;
            reset = 0x0;
        } reserved_2_0[2:0];
    } PADCTRL_REG93 @ 0x174;
    reg {
        name = "PADCTRL_REG94";
        desc = "PADCTRL_REG94 is the SATA_LED_N1 pin drive capability register. PADCTRL_REG94 (offset 0x0178, total reset 0x0000_0000; PROVEN: Hi3535 data sheet, PDF page 227, section 2.4.2).";
        field {
            name = "reserved";
            desc = "Reserved.";
            sw = r; hw = w;
            reset = 0x0;
        } reserved_31_6[31:6];
        field {
            name = "sata_led_n1_ds";
            desc = "SATA_LED_N1 pin drive current control.
- 00: 2.9 mA.
- 01: 5.9 mA.
- 10: 8.8 mA.
- 11: 11.8 mA.";
            sw = rw; hw = r;
            reset = 0x0;
        } sata_led_n1_ds[5:4];
        field {
            name = "sata_led_n1_sl";
            desc = "SATA_LED_N1 pin slew rate control.
- 0: Slow slew.
- 1: Fast slew.";
            sw = rw; hw = r;
            reset = 0x0;
        } sata_led_n1_sl[3:3];
        field {
            name = "reserved";
            desc = "Reserved.";
            sw = r; hw = w;
            reset = 0x0;
        } reserved_2_0[2:0];
    } PADCTRL_REG94 @ 0x178;
    reg {
        name = "PADCTRL_REG95";
        desc = "PADCTRL_REG95 is the SATA_LED_N2 pin drive capability register. PADCTRL_REG95 (offset 0x017C, total reset 0x0000_0000; PROVEN: Hi3535 data sheet, PDF page 228, section 2.4.2).";
        field {
            name = "reserved";
            desc = "Reserved.";
            sw = r; hw = w;
            reset = 0x0;
        } reserved_31_6[31:6];
        field {
            name = "sata_led_n2_ds";
            desc = "SATA_LED_N2 pin drive current control.
- 00: 2.9mA;
- 01: 5.9mA;
- 10: 8.8mA;
- 11: 11.8mA.";
            sw = rw; hw = r;
            reset = 0x0;
        } sata_led_n2_ds[5:4];
        field {
            name = "sata_led_n2_sl";
            desc = "SATA_LED_N2 pin slew rate control.
- 0: Slow edge;
- 1: Fast edge.";
            sw = rw; hw = r;
            reset = 0x0;
        } sata_led_n2_sl[3:3];
        field {
            name = "reserved";
            desc = "Reserved.";
            sw = r; hw = w;
            reset = 0x0;
        } reserved_2_0[2:0];
    } PADCTRL_REG95 @ 0x17c;
    reg {
        name = "PADCTRL_REG96";
        desc = "PADCTRL_REG96 is the I2C_SDA pin drive strength register. PADCTRL_REG96 (offset 0x0180, total reset 0x0000_0010; PROVEN: Hi3535 data sheet, PDF page 229, section 2.4.2).";
        field {
            name = "reserved";
            desc = "Reserved.";
            sw = r; hw = w;
            reset = 0x0;
        } reserved_31_6[31:6];
        field {
            name = "i2c_sda_ds";
            desc = "I2C_SDA pin drive current control.
- 00: 2.9mA;
- 01: 5.9mA;
- 10: 8.8mA;
- 11: 11.8mA.";
            sw = rw; hw = r;
            reset = 0x1;
        } i2c_sda_ds[5:4];
        field {
            name = "i2c_sda_sl";
            desc = "I2C_SDA pin slew rate control.
- 0: Slow edge;
- 1: Fast edge.";
            sw = rw; hw = r;
            reset = 0x0;
        } i2c_sda_sl[3:3];
        field {
            name = "reserved";
            desc = "Reserved.";
            sw = r; hw = w;
            reset = 0x0;
        } reserved_2_0[2:0];
    } PADCTRL_REG96 @ 0x180;
    reg {
        name = "PADCTRL_REG97";
        desc = "PADCTRL_REG97 is the I2C_SCL pin drive capability register. PADCTRL_REG97 (offset 0x0184, total reset 0x0000_0010; PROVEN: Hi3535 data sheet, PDF page 229, section 2.4.2).";
        field {
            name = "reserved";
            desc = "Reserved.";
            sw = r; hw = w;
            reset = 0x0;
        } reserved_31_6[31:6];
        field {
            name = "i2c_scl_ds";
            desc = "I2C_SCL pin drive current control.
- 00: 2.9mA.
- 01: 5.9mA.
- 10: 8.8mA.
- 11: 11.8mA.";
            sw = rw; hw = r;
            reset = 0x1;
        } i2c_scl_ds[5:4];
        field {
            name = "i2c_scl_sl";
            desc = "I2C_SCL pin slew rate control.
- 0: Slow edge;
- 1: Fast edge.";
            sw = rw; hw = r;
            reset = 0x0;
        } i2c_scl_sl[3:3];
        field {
            name = "reserved";
            desc = "Reserved.";
            sw = r; hw = w;
            reset = 0x0;
        } reserved_2_0[2:0];
    } PADCTRL_REG97 @ 0x184;
    reg {
        name = "PADCTRL_REG98";
        desc = "PADCTRL_REG98 is the PWM_SVB0 pin drive strength register. PADCTRL_REG98 (offset 0x0188, total reset 0x0000_0010; PROVEN: Hi3535 data sheet, PDF page 230, section 2.4.2).";
        field {
            name = "reserved";
            desc = "Reserved.";
            sw = r; hw = w;
            reset = 0x0;
        } reserved_31_6[31:6];
        field {
            name = "pwm_svb0_ds";
            desc = "PWM_SVB0 pin drive current control.
- 00: 2.3mA;
- 01: 4.7mA;
- 10: 7.0mA;
- 11: 9.3mA.";
            sw = rw; hw = r;
            reset = 0x1;
        } pwm_svb0_ds[5:4];
        field {
            name = "pwm_svb0_sl";
            desc = "PWM_SVB0 pin slew rate control.
- 0: Slow slew.
- 1: Fast slew.";
            sw = rw; hw = r;
            reset = 0x0;
        } pwm_svb0_sl[3:3];
        field {
            name = "reserved";
            desc = "Reserved.";
            sw = r; hw = w;
            reset = 0x0;
        } reserved_2_0[2:0];
    } PADCTRL_REG98 @ 0x188;
    reg {
        name = "PADCTRL_REG99";
        desc = "PADCTRL_REG99 is the PWM_SVB1 pin drive capability register. PADCTRL_REG99 (offset 0x018C, total reset 0x0000_0010; PROVEN: Hi3535 data sheet, PDF page 231, section 2.4.2).";
        field {
            name = "reserved";
            desc = "Reserved.";
            sw = r; hw = w;
            reset = 0x0;
        } reserved_31_6[31:6];
        field {
            name = "pwm_svb1_ds";
            desc = "PWM_SVB1 pin drive current control.
- 00: 2.3mA;
- 01: 4.7mA;
- 10: 7.0mA;
- 11: 9.3mA.";
            sw = rw; hw = r;
            reset = 0x1;
        } pwm_svb1_ds[5:4];
        field {
            name = "pwm_svb1_sl";
            desc = "PWM_SVB1 pin slew rate control.
- 0: Slow edge;
- 1: Fast edge.";
            sw = rw; hw = r;
            reset = 0x0;
        } pwm_svb1_sl[3:3];
        field {
            name = "reserved";
            desc = "Reserved.";
            sw = r; hw = w;
            reset = 0x0;
        } reserved_2_0[2:0];
    } PADCTRL_REG99 @ 0x18c;
    reg {
        name = "PADCTRL_REG100";
        desc = "PADCTRL_REG100 is the GPIO0_0 pin drive strength register. PADCTRL_REG100 (offset 0x0190, total reset 0x0000_0000; PROVEN: Hi3535 data sheet, PDF page 232, section 2.4.2).";
        field {
            name = "reserved";
            desc = "Reserved.";
            sw = r; hw = w;
            reset = 0x0;
        } reserved_31_6[31:6];
        field {
            name = "gpio0_0_ds";
            desc = "GPIO0_0 pin drive current control.
- 00: 2.9mA;
- 01: 5.9mA;
- 10: 8.8mA;
- 11: 11.8mA.";
            sw = rw; hw = r;
            reset = 0x0;
        } gpio0_0_ds[5:4];
        field {
            name = "gpio0_0_sl";
            desc = "GPIO0_0 pin slew rate control.
- 0: Slow slew.
- 1: Fast slew.";
            sw = rw; hw = r;
            reset = 0x0;
        } gpio0_0_sl[3:3];
        field {
            name = "reserved";
            desc = "Reserved.";
            sw = r; hw = w;
            reset = 0x0;
        } reserved_2_0[2:0];
    } PADCTRL_REG100 @ 0x190;
    reg {
        name = "PADCTRL_REG101";
        desc = "PADCTRL_REG101 is the GPIO0_1 pin drive capability register. PADCTRL_REG101 (offset 0x0194, total reset 0x0000_0000; PROVEN: Hi3535 data sheet, PDF page 232, section 2.4.2).";
        field {
            name = "reserved";
            desc = "Reserved.";
            sw = r; hw = w;
            reset = 0x0;
        } reserved_31_6[31:6];
        field {
            name = "gpio0_1_ds";
            desc = "GPIO0_1 pin drive current control.
- 00: 2.9mA.
- 01: 5.9mA.
- 10: 8.8mA.
- 11: 11.8mA.";
            sw = rw; hw = r;
            reset = 0x0;
        } gpio0_1_ds[5:4];
        field {
            name = "gpio0_1_sl";
            desc = "GPIO0_1 pin slew rate control.
- 0: Slow slew.
- 1: Fast slew.";
            sw = rw; hw = r;
            reset = 0x0;
        } gpio0_1_sl[3:3];
        field {
            name = "reserved";
            desc = "Reserved.";
            sw = r; hw = w;
            reset = 0x0;
        } reserved_2_0[2:0];
    } PADCTRL_REG101 @ 0x194;
    reg {
        name = "PADCTRL_REG102";
        desc = "PADCTRL_REG102 is the GPIO0_2 pin drive capability register. PADCTRL_REG102 (offset 0x0198, total reset 0x0000_0000; PROVEN: Hi3535 data sheet, PDF page 233, section 2.4.2).";
        field {
            name = "reserved";
            desc = "Reserved.";
            sw = r; hw = w;
            reset = 0x0;
        } reserved_31_6[31:6];
        field {
            name = "gpio0_2_ds";
            desc = "GPIO0_2 pin drive current control.
- 00: 2.9mA;
- 01: 5.9mA;
- 10: 8.8mA;
- 11: 11.8mA.";
            sw = rw; hw = r;
            reset = 0x0;
        } gpio0_2_ds[5:4];
        field {
            name = "gpio0_2_sl";
            desc = "GPIO0_2 pin slew rate control.
- 0: Slow edge;
- 1: Fast edge.";
            sw = rw; hw = r;
            reset = 0x0;
        } gpio0_2_sl[3:3];
        field {
            name = "reserved";
            desc = "Reserved.";
            sw = r; hw = w;
            reset = 0x0;
        } reserved_2_0[2:0];
    } PADCTRL_REG102 @ 0x198;
    reg {
        name = "PADCTRL_REG103";
        desc = "PADCTRL_REG103 is the GPIO0_3 pin drive strength register. PADCTRL_REG103 (offset 0x019C, total reset 0x0000_0000; PROVEN: Hi3535 data sheet, PDF page 234, section 2.4.2).";
        field {
            name = "reserved";
            desc = "Reserved.";
            sw = r; hw = w;
            reset = 0x0;
        } reserved_31_6[31:6];
        field {
            name = "gpio0_3_ds";
            desc = "GPIO0_3 pin drive current control.
- 00: 2.9mA;
- 01: 5.9mA;
- 10: 8.8mA;
- 11: 11.8mA.";
            sw = rw; hw = r;
            reset = 0x0;
        } gpio0_3_ds[5:4];
        field {
            name = "gpio0_3_sl";
            desc = "GPIO0_3 pin slew rate control.
- 0: Slow edge;
- 1: Fast edge.";
            sw = rw; hw = r;
            reset = 0x0;
        } gpio0_3_sl[3:3];
        field {
            name = "reserved";
            desc = "Reserved.";
            sw = r; hw = w;
            reset = 0x0;
        } reserved_2_0[2:0];
    } PADCTRL_REG103 @ 0x19c;
    reg {
        name = "PADCTRL_REG104";
        desc = "PADCTRL_REG104 is the GPIO0_4 pin drive capability register. PADCTRL_REG104 (offset 0x01A0, total reset 0x0000_0000; PROVEN: Hi3535 data sheet, PDF page 235, section 2.4.2).";
        field {
            name = "reserved";
            desc = "Reserved.";
            sw = r; hw = w;
            reset = 0x0;
        } reserved_31_6[31:6];
        field {
            name = "gpio0_4_ds";
            desc = "GPIO0_4 pin drive current control.
- 00: 2.9mA.
- 01: 5.9mA.
- 10: 8.8mA.
- 11: 11.8mA.";
            sw = rw; hw = r;
            reset = 0x0;
        } gpio0_4_ds[5:4];
        field {
            name = "gpio0_4_sl";
            desc = "GPIO0_4 pin slew rate control.
- 0: Slow edge;
- 1: Fast edge.";
            sw = rw; hw = r;
            reset = 0x0;
        } gpio0_4_sl[3:3];
        field {
            name = "reserved";
            desc = "Reserved.";
            sw = r; hw = w;
            reset = 0x0;
        } reserved_2_0[2:0];
    } PADCTRL_REG104 @ 0x1a0;
    reg {
        name = "PADCTRL_REG105";
        desc = "PADCTRL_REG105 is the GPIO0_5 pin drive capability register. PADCTRL_REG105 (offset 0x01A4, total reset 0x0000_0000; PROVEN: Hi3535 data sheet, PDF page 235, section 2.4.2).";
        field {
            name = "reserved";
            desc = "Reserved.";
            sw = r; hw = w;
            reset = 0x0;
        } reserved_31_6[31:6];
        field {
            name = "gpio0_5_ds";
            desc = "GPIO0_5 pin drive current control.
- 00: 2.9 mA.
- 01: 5.9 mA.
- 10: 8.8 mA.
- 11: 11.8 mA.";
            sw = rw; hw = r;
            reset = 0x0;
        } gpio0_5_ds[5:4];
        field {
            name = "gpio0_5_sl";
            desc = "GPIO0_5 pin slew rate control.
- 0: Slow edge;
- 1: Fast edge.";
            sw = rw; hw = r;
            reset = 0x0;
        } gpio0_5_sl[3:3];
        field {
            name = "reserved";
            desc = "Reserved.";
            sw = r; hw = w;
            reset = 0x0;
        } reserved_2_0[2:0];
    } PADCTRL_REG105 @ 0x1a4;
    reg {
        name = "PADCTRL_REG106";
        desc = "PADCTRL_REG106 is the GPIO0_6 pin drive strength register. PADCTRL_REG106 (offset 0x01A8, total reset 0x0000_0020; PROVEN: Hi3535 data sheet, PDF page 236, section 2.4.2).";
        field {
            name = "reserved";
            desc = "Reserved.";
            sw = r; hw = w;
            reset = 0x0;
        } reserved_31_6[31:6];
        field {
            name = "gpio0_6_ds";
            desc = "GPIO0_6 pin drive current control.
- 00: 5.9mA.
- 01: 11.8mA.
- 10: 17.6mA.
- 11: 23.5mA.";
            sw = rw; hw = r;
            reset = 0x2;
        } gpio0_6_ds[5:4];
        field {
            name = "gpio0_6_sl";
            desc = "GPIO0_6 pin slew rate control.
- 0: Slow edge;
- 1: Fast edge.";
            sw = rw; hw = r;
            reset = 0x0;
        } gpio0_6_sl[3:3];
        field {
            name = "reserved";
            desc = "Reserved.";
            sw = r; hw = w;
            reset = 0x0;
        } reserved_2_0[2:0];
    } PADCTRL_REG106 @ 0x1a8;
    reg {
        name = "PADCTRL_REG107";
        desc = "PADCTRL_REG107 is the GPIO0_7 pin drive capability register. PADCTRL_REG107 (offset 0x01AC, total reset 0x0000_0020; PROVEN: Hi3535 data sheet, PDF page 237, section 2.4.2).";
        field {
            name = "reserved";
            desc = "Reserved.";
            sw = r; hw = w;
            reset = 0x0;
        } reserved_31_6[31:6];
        field {
            name = "gpio0_7_ds";
            desc = "GPIO0_7 pin drive current control.
- 00: 5.9mA;
- 01: 11.8mA;
- 10: 17.6mA;
- 11: 23.5mA.";
            sw = rw; hw = r;
            reset = 0x2;
        } gpio0_7_ds[5:4];
        field {
            name = "gpio0_7_sl";
            desc = "GPIO0_7 pin slew rate control.
- 0: Slow edge;
- 1: Fast edge.";
            sw = rw; hw = r;
            reset = 0x0;
        } gpio0_7_sl[3:3];
        field {
            name = "reserved";
            desc = "Reserved.";
            sw = r; hw = w;
            reset = 0x0;
        } reserved_2_0[2:0];
    } PADCTRL_REG107 @ 0x1ac;
    reg {
        name = "PADCTRL_REG108";
        desc = "PADCTRL_REG108 is the GPIO1_0 pin drive capability register. PADCTRL_REG108 (offset 0x01B0, total reset 0x0000_0000; PROVEN: Hi3535 data sheet, PDF page 238, section 2.4.2).";
        field {
            name = "reserved";
            desc = "Reserved.";
            sw = r; hw = w;
            reset = 0x0;
        } reserved_31_6[31:6];
        field {
            name = "gpio1_0_ds";
            desc = "GPIO1_0 pin drive current control.
- 00: 2.9mA;
- 01: 5.9mA;
- 10: 8.8mA;
- 11: 11.8mA.";
            sw = rw; hw = r;
            reset = 0x0;
        } gpio1_0_ds[5:4];
        field {
            name = "gpio1_0_sl";
            desc = "GPIO1_0 pin slew rate control.
- 0: Slow edge.
- 1: Fast edge.";
            sw = rw; hw = r;
            reset = 0x0;
        } gpio1_0_sl[3:3];
        field {
            name = "reserved";
            desc = "Reserved.";
            sw = r; hw = w;
            reset = 0x0;
        } reserved_2_0[2:0];
    } PADCTRL_REG108 @ 0x1b0;
    reg {
        name = "PADCTRL_REG109";
        desc = "PADCTRL_REG109 is the GPIO1_1 pin drive strength register. PADCTRL_REG109 (offset 0x01B4, total reset 0x0000_0000; PROVEN: Hi3535 data sheet, PDF page 238, section 2.4.2).";
        field {
            name = "reserved";
            desc = "Reserved.";
            sw = r; hw = w;
            reset = 0x0;
        } reserved_31_6[31:6];
        field {
            name = "gpio1_1_ds";
            desc = "GPIO1_1 pin drive current control.
- 00: 2.9mA.
- 01: 5.9mA.
- 10: 8.8mA.
- 11: 11.8mA.";
            sw = rw; hw = r;
            reset = 0x0;
        } gpio1_1_ds[5:4];
        field {
            name = "gpio1_1_sl";
            desc = "GPIO1_1 pin slew rate control.
- 0: Slow edge;
- 1: Fast edge.";
            sw = rw; hw = r;
            reset = 0x0;
        } gpio1_1_sl[3:3];
        field {
            name = "reserved";
            desc = "Reserved.";
            sw = r; hw = w;
            reset = 0x0;
        } reserved_2_0[2:0];
    } PADCTRL_REG109 @ 0x1b4;
    reg {
        name = "PADCTRL_REG110";
        desc = "PADCTRL_REG110 is the GPIO1_2 pin drive capability register. PADCTRL_REG110 (offset 0x01B8, total reset 0x0000_0000; PROVEN: Hi3535 data sheet, PDF page 239, section 2.4.2).";
        field {
            name = "reserved";
            desc = "Reserved.";
            sw = r; hw = w;
            reset = 0x0;
        } reserved_31_6[31:6];
        field {
            name = "gpio1_2_ds";
            desc = "GPIO1_2 pin drive current control.
- 00: 2.9 mA.
- 01: 5.9 mA.
- 10: 8.8 mA.
- 11: 11.8 mA.";
            sw = rw; hw = r;
            reset = 0x0;
        } gpio1_2_ds[5:4];
        field {
            name = "gpio1_2_sl";
            desc = "GPIO1_2 pin slew rate control.
- 0: Slow edge;
- 1: Fast edge.";
            sw = rw; hw = r;
            reset = 0x0;
        } gpio1_2_sl[3:3];
        field {
            name = "reserved";
            desc = "Reserved.";
            sw = r; hw = w;
            reset = 0x0;
        } reserved_2_0[2:0];
    } PADCTRL_REG110 @ 0x1b8;
    reg {
        name = "PADCTRL_REG111";
        desc = "PADCTRL_REG111 is the GPIO1_3 pin drive strength register. PADCTRL_REG111 (offset 0x01BC, total reset 0x0000_0000; PROVEN: Hi3535 data sheet, PDF page 240, section 2.4.2).";
        field {
            name = "reserved";
            desc = "Reserved.";
            sw = r; hw = w;
            reset = 0x0;
        } reserved_31_6[31:6];
        field {
            name = "gpio1_3_ds";
            desc = "GPIO1_3 pin drive current control.
- 00: 2.9mA;
- 01: 5.9mA;
- 10: 8.8mA;
- 11: 11.8mA.";
            sw = rw; hw = r;
            reset = 0x0;
        } gpio1_3_ds[5:4];
        field {
            name = "gpio1_3_sl";
            desc = "GPIO1_3 pin slew rate control.
- 0: Slow edge;
- 1: Fast edge.";
            sw = rw; hw = r;
            reset = 0x0;
        } gpio1_3_sl[3:3];
        field {
            name = "reserved";
            desc = "Reserved.";
            sw = r; hw = w;
            reset = 0x0;
        } reserved_2_0[2:0];
    } PADCTRL_REG111 @ 0x1bc;
    reg {
        name = "PADCTRL_REG112";
        desc = "PADCTRL_REG112 is the GPIO1_4 pin drive capability register. PADCTRL_REG112 (offset 0x01C0, total reset 0x0000_0000; PROVEN: Hi3535 data sheet, PDF page 241, section 2.4.2).";
        field {
            name = "reserved";
            desc = "Reserved.";
            sw = r; hw = w;
            reset = 0x0;
        } reserved_31_6[31:6];
        field {
            name = "gpio1_4_ds";
            desc = "GPIO1_4 pin drive current control.
- 00: 2.9mA;
- 01: 5.9mA;
- 10: 8.8mA;
- 11: 11.8mA.";
            sw = rw; hw = r;
            reset = 0x0;
        } gpio1_4_ds[5:4];
        field {
            name = "gpio1_4_sl";
            desc = "GPIO1_4 pin slew rate control.
- 0: Slow edge;
- 1: Fast edge.";
            sw = rw; hw = r;
            reset = 0x0;
        } gpio1_4_sl[3:3];
        field {
            name = "reserved";
            desc = "Reserved.";
            sw = r; hw = w;
            reset = 0x0;
        } reserved_2_0[2:0];
    } PADCTRL_REG112 @ 0x1c0;
    reg {
        name = "PADCTRL_REG113";
        desc = "PADCTRL_REG113 is the GPIO1_5 pin drive capability register. PADCTRL_REG113 (offset 0x01C4, total reset 0x0000_0000; PROVEN: Hi3535 data sheet, PDF page 241, section 2.4.2).";
        field {
            name = "reserved";
            desc = "Reserved.";
            sw = r; hw = w;
            reset = 0x0;
        } reserved_31_6[31:6];
        field {
            name = "gpio1_5_ds";
            desc = "GPIO1_5 pin drive current control.
- 00: 2.9mA;
- 01: 5.9mA;
- 10: 8.8mA;
- 11: 11.8mA.";
            sw = rw; hw = r;
            reset = 0x0;
        } gpio1_5_ds[5:4];
        field {
            name = "gpio1_5_sl";
            desc = "GPIO1_5 pin slew rate control.
- 0: Slow slew.
- 1: Fast slew.";
            sw = rw; hw = r;
            reset = 0x0;
        } gpio1_5_sl[3:3];
        field {
            name = "reserved";
            desc = "Reserved.";
            sw = r; hw = w;
            reset = 0x0;
        } reserved_2_0[2:0];
    } PADCTRL_REG113 @ 0x1c4;
    reg {
        name = "PADCTRL_REG114";
        desc = "PADCTRL_REG114 is the GPIO1_6 pin drive strength register. PADCTRL_REG114 (offset 0x01C8, total reset 0x0000_0000; PROVEN: Hi3535 data sheet, PDF page 242, section 2.4.2).";
        field {
            name = "reserved";
            desc = "Reserved.";
            sw = r; hw = w;
            reset = 0x0;
        } reserved_31_6[31:6];
        field {
            name = "gpio1_6_ds";
            desc = "GPIO1_6 pin drive current control.
- 00: 2.9mA;
- 01: 5.9mA;
- 10: 8.8mA;
- 11: 11.8mA.";
            sw = rw; hw = r;
            reset = 0x0;
        } gpio1_6_ds[5:4];
        field {
            name = "gpio1_6_sl";
            desc = "GPIO1_6 pin slew rate control.
- 0: Slow edge.
- 1: Fast edge.";
            sw = rw; hw = r;
            reset = 0x0;
        } gpio1_6_sl[3:3];
        field {
            name = "reserved";
            desc = "Reserved.";
            sw = r; hw = w;
            reset = 0x0;
        } reserved_2_0[2:0];
    } PADCTRL_REG114 @ 0x1c8;
    reg {
        name = "PADCTRL_REG115";
        desc = "PADCTRL_REG115 is the GPIO1_7 pin drive capability register. PADCTRL_REG115 (offset 0x01CC, total reset 0x0000_0000; PROVEN: Hi3535 data sheet, PDF page 243, section 2.4.2).";
        field {
            name = "reserved";
            desc = "Reserved.";
            sw = r; hw = w;
            reset = 0x0;
        } reserved_31_6[31:6];
        field {
            name = "gpio1_7_ds";
            desc = "GPIO1_7 pin drive current control.
- 00: 2.9mA.
- 01: 5.9mA.
- 10: 8.8mA.
- 11: 11.8mA.";
            sw = rw; hw = r;
            reset = 0x0;
        } gpio1_7_ds[5:4];
        field {
            name = "gpio1_7_sl";
            desc = "GPIO1_7 pin slew rate control.
- 0: Slow edge;
- 1: Fast edge.";
            sw = rw; hw = r;
            reset = 0x0;
        } gpio1_7_sl[3:3];
        field {
            name = "reserved";
            desc = "Reserved.";
            sw = r; hw = w;
            reset = 0x0;
        } reserved_2_0[2:0];
    } PADCTRL_REG115 @ 0x1cc;
    reg {
        name = "PADCTRL_REG116";
        desc = "PADCTRL_REG116 is the VOU1120_DATA0 pin drive capability register. PADCTRL_REG116 (offset 0x01D0, total reset 0x0000_0050; PROVEN: Hi3535 data sheet, PDF page 244, section 2.4.2).";
        field {
            name = "reserved";
            desc = "Reserved.";
            sw = r; hw = w;
            reset = 0x0;
        } reserved_31_7[31:7];
        field {
            name = "vou1120_data0_ds";
            desc = "VOU1120_DATA0 pin drive current control.
- 000: 4.7mA;
- 001: 7.0mA;
- 010: 9.3mA;
- 011: 11.6mA;
- 100: 14.0mA;
- 101: 16.3mA;
- 110: 18.6mA;
- 111: 20.9mA.";
            sw = r; hw = w;
            reset = 0x5;
        } vou1120_data0_ds[6:4];
        field {
            name = "vou1120_data0_sl";
            desc = "VOU1120_DATA0 pin slew rate control.
- 0: Slow edge;
- 1: Fast edge.";
            sw = r; hw = w;
            reset = 0x0;
        } vou1120_data0_sl[3:3];
        field {
            name = "reserved";
            desc = "Reserved.";
            sw = r; hw = w;
            reset = 0x0;
        } reserved_2_0[2:0];
    } PADCTRL_REG116 @ 0x1d0;
    reg {
        name = "PADCTRL_REG117";
        desc = "PADCTRL_REG117 is the VOU1120_DATA1 pin drive strength register. PADCTRL_REG117 (offset 0x01D4, total reset 0x0000_0050; PROVEN: Hi3535 data sheet, PDF page 245, section 2.4.2).";
        field {
            name = "reserved";
            desc = "Reserved.";
            sw = r; hw = w;
            reset = 0x0;
        } reserved_31_7[31:7];
        field {
            name = "vou1120_data1_ds";
            desc = "VOU1120_DATA1 pin drive current control.
- 000: 4.7mA;
- 001: 7.0mA;
- 010: 9.3mA;
- 011: 11.6mA;
- 100: 14.0mA;
- 101: 16.3mA;
- 110: 18.6mA;
- 111: 20.9mA.";
            sw = r; hw = w;
            reset = 0x5;
        } vou1120_data1_ds[6:4];
        field {
            name = "vou1120_data1_sl";
            desc = "VOU1120_DATA1 pin slew rate control.
- 0: Slow edge;
- 1: Fast edge.";
            sw = r; hw = w;
            reset = 0x0;
        } vou1120_data1_sl[3:3];
        field {
            name = "reserved";
            desc = "Reserved.";
            sw = r; hw = w;
            reset = 0x0;
        } reserved_2_0[2:0];
    } PADCTRL_REG117 @ 0x1d4;
    reg {
        name = "PADCTRL_REG118";
        desc = "PADCTRL_REG118 is the VOU1120_DATA2 pin drive capability register. PADCTRL_REG118 (offset 0x01D8, total reset 0x0000_0020; PROVEN: Hi3535 data sheet, PDF page 246, section 2.4.2).";
        field {
            name = "reserved";
            desc = "Reserved.";
            sw = r; hw = w;
            reset = 0x0;
        } reserved_31_7[31:7];
        field {
            name = "vou1120_data2_ds";
            desc = "VOU1120_DATA2 pin drive current control.
- 000: 4.7mA.
- 001: 7.0mA.
- 010: 9.3mA.
- 011: 11.6mA.
- 100: 14.0mA.
- 101: 16.3mA.
- 110: 18.6mA.
- 111: 20.9mA.";
            sw = r; hw = w;
            reset = 0x2;
        } vou1120_data2_ds[6:4];
        field {
            name = "vou1120_data2_sl";
            desc = "VOU1120_DATA2 pin slew rate control.
- 0: Slow edge;
- 1: Fast edge.";
            sw = r; hw = w;
            reset = 0x0;
        } vou1120_data2_sl[3:3];
        field {
            name = "reserved";
            desc = "Reserved.";
            sw = r; hw = w;
            reset = 0x0;
        } reserved_2_0[2:0];
    } PADCTRL_REG118 @ 0x1d8;
    reg {
        name = "PADCTRL_REG119";
        desc = "PADCTRL_REG119 is the VOU1120_DATA3 pin drive capability register. PADCTRL_REG119 (offset 0x01DC, total reset 0x0000_0050; PROVEN: Hi3535 data sheet, PDF page 247, section 2.4.2).";
        field {
            name = "reserved";
            desc = "Reserved.";
            sw = r; hw = w;
            reset = 0x0;
        } reserved_31_7[31:7];
        field {
            name = "vou1120_data3_ds";
            desc = "VOU1120_DATA3 pin drive current control.
- 000: 4.7mA;
- 001: 7.0mA;
- 010: 9.3mA;
- 011: 11.6mA;
- 100: 14.0mA;
- 101: 16.3mA;
- 110: 18.6mA;
- 111: 20.9mA.";
            sw = r; hw = w;
            reset = 0x5;
        } vou1120_data3_ds[6:4];
        field {
            name = "vou1120_data3_sl";
            desc = "VOU1120_DATA3 pin slew rate control.
- 0: Slow edge;
- 1: Fast edge.";
            sw = rw; hw = r;
            reset = 0x0;
        } vou1120_data3_sl[3:3];
        field {
            name = "reserved";
            desc = "Reserved.";
            sw = r; hw = w;
            reset = 0x0;
        } reserved_2_0[2:0];
    } PADCTRL_REG119 @ 0x1dc;
    reg {
        name = "PADCTRL_REG120";
        desc = "PADCTRL_REG120 is the VOU1120_DATA4 pin drive capability register. PADCTRL_REG120 (offset 0x01E0, total reset 0x0000_0050; PROVEN: Hi3535 data sheet, PDF page 248, section 2.4.2).";
        field {
            name = "reserved";
            desc = "Reserved.";
            sw = r; hw = w;
            reset = 0x0;
        } reserved_31_7[31:7];
        field {
            name = "vou1120_data4_ds";
            desc = "VOU1120_DATA4 pin drive current control.
- 000: 4.7 mA.
- 001: 7.0 mA.
- 010: 9.3 mA.
- 011: 11.6 mA.
- 100: 14.0 mA.
- 101: 16.3 mA.
- 110: 18.6 mA.
- 111: 20.9 mA.";
            sw = rw; hw = r;
            reset = 0x5;
        } vou1120_data4_ds[6:4];
        field {
            name = "vou1120_data4_sl";
            desc = "VOU1120_DATA4 pin slew rate control.
- 0: Slow edge;
- 1: Fast edge.";
            sw = rw; hw = r;
            reset = 0x0;
        } vou1120_data4_sl[3:3];
        field {
            name = "reserved";
            desc = "Reserved.";
            sw = r; hw = w;
            reset = 0x0;
        } reserved_2_0[2:0];
    } PADCTRL_REG120 @ 0x1e0;
    reg {
        name = "PADCTRL_REG121";
        desc = "PADCTRL_REG121 is the VOU1120_DATA5 pin drive capability register. PADCTRL_REG121 (offset 0x01E4, total reset 0x0000_0050; PROVEN: Hi3535 data sheet, PDF page 249, section 2.4.2).";
        field {
            name = "reserved";
            desc = "Reserved.";
            sw = r; hw = w;
            reset = 0x0;
        } reserved_31_7[31:7];
        field {
            name = "vou1120_data5_ds";
            desc = "VOU1120_DATA5 pin drive current control.
- 000: 4.7mA;
- 001: 7.0mA;
- 010: 9.3mA;
- 011: 11.6mA;
- 100: 14.0mA;
- 101: 16.3mA;
- 110: 18.6mA;
- 111: 20.9mA.";
            sw = rw; hw = r;
            reset = 0x5;
        } vou1120_data5_ds[6:4];
        field {
            name = "vou1120_data5_sl";
            desc = "VOU1120_DATA5 pin slew rate control.
- 0: Slow edge;
- 1: Fast edge.";
            sw = rw; hw = r;
            reset = 0x0;
        } vou1120_data5_sl[3:3];
        field {
            name = "reserved";
            desc = "Reserved.";
            sw = r; hw = w;
            reset = 0x0;
        } reserved_2_0[2:0];
    } PADCTRL_REG121 @ 0x1e4;
    reg {
        name = "PADCTRL_REG122";
        desc = "PADCTRL_REG122 is the VOU1120_DATA6 pin drive strength register. PADCTRL_REG122 (offset 0x01E8, total reset 0x0000_0050; PROVEN: Hi3535 data sheet, PDF page 250, section 2.4.2).";
        field {
            name = "reserved";
            desc = "Reserved.";
            sw = r; hw = w;
            reset = 0x0;
        } reserved_31_7[31:7];
        field {
            name = "vou1120_data6_ds";
            desc = "VOU1120_DATA6 pin drive current control.
- 000: 4.7mA;
- 001: 7.0mA;
- 010: 9.3mA;
- 011: 11.6mA;
- 100: 14.0mA;
- 101: 16.3mA;
- 110: 18.6mA;
- 111: 20.9mA.";
            sw = rw; hw = r;
            reset = 0x5;
        } vou1120_data6_ds[6:4];
        field {
            name = "vou1120_data6_sl";
            desc = "VOU1120_DATA6 pin slew rate control.
- 0: Slow edge;
- 1: Fast edge.";
            sw = rw; hw = r;
            reset = 0x0;
        } vou1120_data6_sl[3:3];
        field {
            name = "reserved";
            desc = "Reserved.";
            sw = r; hw = w;
            reset = 0x0;
        } reserved_2_0[2:0];
    } PADCTRL_REG122 @ 0x1e8;
    reg {
        name = "PADCTRL_REG123";
        desc = "PADCTRL_REG123 is the VOU1120_DATA7 pin drive capability register. PADCTRL_REG123 (offset 0x01EC, total reset 0x0000_0050; PROVEN: Hi3535 data sheet, PDF page 251, section 2.4.2).";
        field {
            name = "reserved";
            desc = "Reserved.";
            sw = r; hw = w;
            reset = 0x0;
        } reserved_31_7[31:7];
        field {
            name = "vou1120_data7_ds";
            desc = "VOU1120_DATA7 pin drive current control.
- 000: 4.7mA.
- 001: 7.0mA.
- 010: 9.3mA.
- 011: 11.6mA.
- 100: 14.0mA.
- 101: 16.3mA.
- 110: 18.6mA.
- 111: 20.9mA.";
            sw = rw; hw = r;
            reset = 0x5;
        } vou1120_data7_ds[6:4];
        field {
            name = "vou1120_data7_sl";
            desc = "VOU1120_DATA7 pin slew rate control.
- 0: Slow edge;
- 1: Fast edge.";
            sw = rw; hw = r;
            reset = 0x0;
        } vou1120_data7_sl[3:3];
        field {
            name = "reserved";
            desc = "Reserved.";
            sw = r; hw = w;
            reset = 0x0;
        } reserved_2_0[2:0];
    } PADCTRL_REG123 @ 0x1ec;
    reg {
        name = "PADCTRL_REG124";
        desc = "PADCTRL_REG124 is the VOU1120_DATA8 pin drive strength register. PADCTRL_REG124 (offset 0x01F0, total reset 0x0000_0050; PROVEN: Hi3535 data sheet, PDF page 252, section 2.4.2).";
        field {
            name = "reserved";
            desc = "Reserved.";
            sw = r; hw = w;
            reset = 0x0;
        } reserved_31_7[31:7];
        field {
            name = "vou1120_data8_ds";
            desc = "VOU1120_DATA8 pin drive current control.
- 000: 4.7mA;
- 001: 7.0mA;
- 010: 9.3mA;
- 011: 11.6mA;
- 100: 14.0mA;
- 101: 16.3mA;
- 110: 18.6mA;
- 111: 20.9mA.";
            sw = rw; hw = r;
            reset = 0x5;
        } vou1120_data8_ds[6:4];
        field {
            name = "vou1120_data8_sl";
            desc = "VOU1120_DATA8 pin slew rate control.
- 0: Slow edge;
- 1: Fast edge.";
            sw = rw; hw = r;
            reset = 0x0;
        } vou1120_data8_sl[3:3];
        field {
            name = "reserved";
            desc = "Reserved.";
            sw = r; hw = w;
            reset = 0x0;
        } reserved_2_0[2:0];
    } PADCTRL_REG124 @ 0x1f0;
    reg {
        name = "PADCTRL_REG125";
        desc = "PADCTRL_REG125 is the VOU1120_DATA9 pin drive capability register. PADCTRL_REG125 (offset 0x01F4, total reset 0x0000_0050; PROVEN: Hi3535 data sheet, PDF page 253, section 2.4.2).";
        field {
            name = "reserved";
            desc = "Reserved.";
            sw = r; hw = w;
            reset = 0x0;
        } reserved_31_7[31:7];
        field {
            name = "vou1120_data9_ds";
            desc = "VOU1120_DATA9 pin drive current control.
- 000: 4.7mA;
- 001: 7.0mA;
- 010: 9.3mA;
- 011: 11.6mA;
- 100: 14.0mA;
- 101: 16.3mA;
- 110: 18.6mA;
- 111: 20.9mA.";
            sw = rw; hw = r;
            reset = 0x5;
        } vou1120_data9_ds[6:4];
        field {
            name = "vou1120_data9_sl";
            desc = "VOU1120_DATA9 pin slew rate control.
- 0: Slow edge.
- 1: Fast edge.";
            sw = rw; hw = r;
            reset = 0x0;
        } vou1120_data9_sl[3:3];
        field {
            name = "reserved";
            desc = "Reserved.";
            sw = r; hw = w;
            reset = 0x0;
        } reserved_2_0[2:0];
    } PADCTRL_REG125 @ 0x1f4;
    reg {
        name = "PADCTRL_REG126";
        desc = "PADCTRL_REG126 is the VOU1120_DATA10 pin drive capability register. PADCTRL_REG126 (offset 0x01F8, total reset 0x0000_0050; PROVEN: Hi3535 data sheet, PDF page 254, section 2.4.2).";
        field {
            name = "reserved";
            desc = "Reserved.";
            sw = r; hw = w;
            reset = 0x0;
        } reserved_31_7[31:7];
        field {
            name = "vou1120_data10_ds";
            desc = "VOU1120_DATA10 pin drive current control.
- 000: 4.7 mA.
- 001: 7.0 mA.
- 010: 9.3 mA.
- 011: 11.6 mA.
- 100: 14.0 mA.
- 101: 16.3 mA.
- 110: 18.6 mA.
- 111: 20.9 mA.";
            sw = rw; hw = r;
            reset = 0x5;
        } vou1120_data10_ds[6:4];
        field {
            name = "vou1120_data10_sl";
            desc = "VOU1120_DATA10 pin slew rate control.
- 0: Slow edge;
- 1: Fast edge.";
            sw = rw; hw = r;
            reset = 0x0;
        } vou1120_data10_sl[3:3];
        field {
            name = "reserved";
            desc = "Reserved.";
            sw = r; hw = w;
            reset = 0x0;
        } reserved_2_0[2:0];
    } PADCTRL_REG126 @ 0x1f8;
    reg {
        name = "PADCTRL_REG127";
        desc = "PADCTRL_REG127 is the VOU1120_DATA11 pin drive capability register. PADCTRL_REG127 (offset 0x01FC, total reset 0x0000_0050; PROVEN: Hi3535 data sheet, PDF page 255, section 2.4.2).";
        field {
            name = "reserved";
            desc = "Reserved.";
            sw = r; hw = w;
            reset = 0x0;
        } reserved_31_7[31:7];
        field {
            name = "vou1120_data11_ds";
            desc = "VOU1120_DATA11 pin drive current control.
- 000: 4.7mA.
- 001: 7.0mA.
- 010: 9.3mA.
- 011: 11.6mA.
- 100: 14.0mA.
- 101: 16.3mA.
- 110: 18.6mA.
- 111: 20.9mA.";
            sw = rw; hw = r;
            reset = 0x5;
        } vou1120_data11_ds[6:4];
        field {
            name = "vou1120_data11_sl";
            desc = "VOU1120_DATA11 pin slew rate control.
- 0: Slow edge;
- 1: Fast edge.";
            sw = rw; hw = r;
            reset = 0x0;
        } vou1120_data11_sl[3:3];
        field {
            name = "reserved";
            desc = "Reserved.";
            sw = r; hw = w;
            reset = 0x0;
        } reserved_2_0[2:0];
    } PADCTRL_REG127 @ 0x1fc;
    reg {
        name = "PADCTRL_REG128";
        desc = "PADCTRL_REG128 is the VOU1120_DATA12 pin drive strength register. PADCTRL_REG128 (offset 0x0200, total reset 0x0000_0050; PROVEN: Hi3535 data sheet, PDF page 256, section 2.4.2).";
        field {
            name = "reserved";
            desc = "Reserved.";
            sw = r; hw = w;
            reset = 0x0;
        } reserved_31_7[31:7];
        field {
            name = "vou1120_data12_ds";
            desc = "VOU1120_DATA12 pin drive current control.
- 000: 4.7mA;
- 001: 7.0mA;
- 010: 9.3mA;
- 011: 11.6mA;
- 100: 14.0mA;
- 101: 16.3mA;
- 110: 18.6mA;
- 111: 20.9mA.";
            sw = rw; hw = r;
            reset = 0x5;
        } vou1120_data12_ds[6:4];
        field {
            name = "vou1120_data12_sl";
            desc = "VOU1120_DATA12 pin slew rate control.
- 0: Slow edge;
- 1: Fast edge.";
            sw = rw; hw = r;
            reset = 0x0;
        } vou1120_data12_sl[3:3];
        field {
            name = "reserved";
            desc = "Reserved.";
            sw = r; hw = w;
            reset = 0x0;
        } reserved_2_0[2:0];
    } PADCTRL_REG128 @ 0x200;
    reg {
        name = "PADCTRL_REG129";
        desc = "PADCTRL_REG129 is the VOU1120_DATA13 pin drive capability register. PADCTRL_REG129 (offset 0x0204, total reset 0x0000_0050; PROVEN: Hi3535 data sheet, PDF page 257, section 2.4.2).";
        field {
            name = "reserved";
            desc = "Reserved.";
            sw = r; hw = w;
            reset = 0x0;
        } reserved_31_7[31:7];
        field {
            name = "vou1120_data13_ds";
            desc = "VOU1120_DATA13 pin drive current control.
- 000: 4.7mA;
- 001: 7.0mA;
- 010: 9.3mA;
- 011: 11.6mA;
- 100: 14.0mA;
- 101: 16.3mA;
- 110: 18.6mA;
- 111: 20.9mA.";
            sw = rw; hw = r;
            reset = 0x5;
        } vou1120_data13_ds[6:4];
        field {
            name = "vou1120_data13_sl";
            desc = "VOU1120_DATA13 pin slew rate control.
- 0: Slow edge;
- 1: Fast edge.";
            sw = rw; hw = r;
            reset = 0x0;
        } vou1120_data13_sl[3:3];
        field {
            name = "reserved";
            desc = "Reserved.";
            sw = r; hw = w;
            reset = 0x0;
        } reserved_2_0[2:0];
    } PADCTRL_REG129 @ 0x204;
    reg {
        name = "PADCTRL_REG130";
        desc = "PADCTRL_REG130 is the VOU1120_DATA14 pin drive capability register. PADCTRL_REG130 (offset 0x0208, total reset 0x0000_0050; PROVEN: Hi3535 data sheet, PDF page 258, section 2.4.2).";
        field {
            name = "reserved";
            desc = "Reserved.";
            sw = r; hw = w;
            reset = 0x0;
        } reserved_31_7[31:7];
        field {
            name = "vou1120_data14_ds";
            desc = "VOU1120_DATA14 pin drive current control.
- 000: 4.7mA;
- 001: 7.0mA;
- 010: 9.3mA;
- 011: 11.6mA;
- 100: 14.0mA;
- 101: 16.3mA;
- 110: 18.6mA;
- 111: 20.9mA.";
            sw = rw; hw = r;
            reset = 0x5;
        } vou1120_data14_ds[6:4];
        field {
            name = "vou1120_data14_sl";
            desc = "VOU1120_DATA14 pin slew rate control.
- 0: Slow slew.
- 1: Fast slew.";
            sw = rw; hw = r;
            reset = 0x0;
        } vou1120_data14_sl[3:3];
        field {
            name = "reserved";
            desc = "Reserved.";
            sw = r; hw = w;
            reset = 0x0;
        } reserved_2_0[2:0];
    } PADCTRL_REG130 @ 0x208;
    reg {
        name = "PADCTRL_REG131";
        desc = "PADCTRL_REG131 is the VOU1120_DATA15 pin drive capability register. PADCTRL_REG131 (offset 0x020C, total reset 0x0000_0050; PROVEN: Hi3535 data sheet, PDF page 259, section 2.4.2).";
        field {
            name = "reserved";
            desc = "Reserved.";
            sw = r; hw = w;
            reset = 0x0;
        } reserved_31_7[31:7];
        field {
            name = "vou1120_data15_ds";
            desc = "VOU1120_DATA15 pin drive current control.
- 000: 4.7mA;
- 001: 7.0mA;
- 010: 9.3mA;
- 011: 11.6mA;
- 100: 14.0mA;
- 101: 16.3mA;
- 110: 18.6mA;
- 111: 20.9mA.";
            sw = rw; hw = r;
            reset = 0x5;
        } vou1120_data15_ds[6:4];
        field {
            name = "vou1120_data15_sl";
            desc = "VOU1120_DATA15 pin slew rate control.
- 0: Slow edge.
- 1: Fast edge.";
            sw = rw; hw = r;
            reset = 0x0;
        } vou1120_data15_sl[3:3];
        field {
            name = "reserved";
            desc = "Reserved.";
            sw = r; hw = w;
            reset = 0x0;
        } reserved_2_0[2:0];
    } PADCTRL_REG131 @ 0x20c;
    reg {
        name = "PADCTRL_REG132";
        desc = "PADCTRL_REG132 is the VOU1120_CLK pin drive capability register. PADCTRL_REG132 (offset 0x0210, total reset 0x0000_0058; PROVEN: Hi3535 data sheet, PDF page 260, section 2.4.2).";
        field {
            name = "reserved";
            desc = "Reserved.";
            sw = r; hw = w;
            reset = 0x0;
        } reserved_31_7[31:7];
        field {
            name = "vou1120_clk_ds";
            desc = "VOU1120_CLK pin drive current control.
- 000: 4.7 mA.
- 001: 7.0 mA.
- 010: 9.3 mA.
- 011: 11.6 mA.
- 100: 14.0 mA.
- 101: 16.3 mA.
- 110: 18.6 mA.
- 111: 20.9 mA.";
            sw = rw; hw = r;
            reset = 0x5;
        } vou1120_clk_ds[6:4];
        field {
            name = "vou1120_clk_sl";
            desc = "VOU1120_CLK pin slew rate control.
- 0: Slow edge;
- 1: Fast edge.";
            sw = rw; hw = r;
            reset = 0x1;
        } vou1120_clk_sl[3:3];
        field {
            name = "reserved";
            desc = "Reserved.";
            sw = r; hw = w;
            reset = 0x0;
        } reserved_2_0[2:0];
    } PADCTRL_REG132 @ 0x210;
};

`endif
