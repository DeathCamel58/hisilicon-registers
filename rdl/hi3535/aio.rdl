`ifndef EHI3535_AIO_RDL
`define EHI3535_AIO_RDL
regfile eHI3535_AIO {
    name = "Audio interface (AIO)";
    desc = "Audio interface (AIO). 43 registers extracted programmatically from the Hi3535 H.264 codec processor (Hi3535 user guide) data sheet (Issue 00B08, 2014-02-25); chapter 12.1.6, table 12-2. Field names, bit ranges, access types and reset values are taken from the register tables; reset values are the data sheet total reset values split onto the fields (per-field values where the table has them). Label: PROVEN. Hardware not verified here (no board).";
    reg {
        name = "AIAO_INT_ENA";
        desc = "AIAO_INT_ENA is the AIO module interrupt enable register. AIAO_INT_ENA (offset 0x0000, total reset 0x0000_0000; PROVEN: Hi3535 data sheet, PDF page 1172, section 12.1.6).";
        field {
            name = "reserved";
            desc = "Reserved.";
            sw = rw; hw = r;
            reset = 0x0;
        } reserved_31_18[31:18];
        field {
            name = "tx_ch1_int_ena";
            desc = "Interrupt enable of transmit channel 1.
- 0: Disable;
- 1: Enable.";
            sw = rw; hw = r;
            reset = 0x0;
        } tx_ch1_int_ena[17:17];
        field {
            name = "tx_ch0_int_ena";
            desc = "Interrupt enable of transmit channel 0.
- 0: Disable;
- 1: Enable.";
            sw = rw; hw = r;
            reset = 0x0;
        } tx_ch0_int_ena[16:16];
        field {
            name = "reserved";
            desc = "Reserved.";
            sw = rw; hw = r;
            reset = 0x0;
        } reserved_15_1[15:1];
        field {
            name = "rx_ch0_int_ena";
            desc = "Interrupt enable of receive channel 0.
- 0: Disable.
- 1: Enable.";
            sw = rw; hw = r;
            reset = 0x0;
        } rx_ch0_int_ena[0:0];
    } AIAO_INT_ENA @ 0x0;
    reg {
        name = "AIAO_INT_STATUS";
        desc = "AIAO_INT_STATUS is the interrupt status register of the AIO module. AIAO_INT_STATUS (offset 0x0004, total reset 0x0000_0000; PROVEN: Hi3535 data sheet, PDF page 1173, section 12.1.6).";
        field {
            name = "reserved";
            desc = "Reserved.";
            sw = r; hw = w;
            reset = 0x0;
        } reserved_31_18[31:18];
        field {
            name = "tx_ch1_int_status";
            desc = "Interrupt status of transmit channel 1.
- 0: No interrupt status;
- 1: Interrupt status present.";
            sw = r; hw = w;
            reset = 0x0;
        } tx_ch1_int_status[17:17];
        field {
            name = "tx_ch0_int_status";
            desc = "Interrupt status of transmit channel 0.
- 0: No interrupt status;
- 1: Interrupt status present.";
            sw = r; hw = w;
            reset = 0x0;
        } tx_ch0_int_status[16:16];
        field {
            name = "reserved";
            desc = "Reserved.";
            sw = r; hw = w;
            reset = 0x0;
        } reserved_15_1[15:1];
        field {
            name = "rx_ch0_int_status";
            desc = "Interrupt status of receive channel 0.
- 0: No interrupt status;
- 1: Interrupt status present.";
            sw = r; hw = w;
            reset = 0x0;
        } rx_ch0_int_status[0:0];
    } AIAO_INT_STATUS @ 0x4;
    reg {
        name = "AIAO_INT_RAW";
        desc = "AIAO_INT_RAW is the raw interrupt register of the AIO module. AIAO_INT_RAW (offset 0x0008, total reset 0x0000_0000; PROVEN: Hi3535 data sheet, PDF page 1174, section 12.1.6).";
        field {
            name = "reserved";
            desc = "Reserved.";
            sw = r; hw = w;
            reset = 0x0;
        } reserved_31_18[31:18];
        field {
            name = "tx_ch1_int_raw";
            desc = "Raw interrupt of transmit channel 1.
- 0: No raw interrupt;
- 1: Raw interrupt present.";
            sw = r; hw = w;
            reset = 0x0;
        } tx_ch1_int_raw[17:17];
        field {
            name = "tx_ch0_int_raw";
            desc = "Raw interrupt of transmit channel 0.
- 0: No raw interrupt.
- 1: Raw interrupt present.";
            sw = r; hw = w;
            reset = 0x0;
        } tx_ch0_int_raw[16:16];
        field {
            name = "reserved";
            desc = "Reserved.";
            sw = r; hw = w;
            reset = 0x0;
        } reserved_15_1[15:1];
        field {
            name = "rx_ch0_int_raw";
            desc = "Raw interrupt of receive channel 0.
- 0: No raw interrupt;
- 1: Raw interrupt present.";
            sw = r; hw = w;
            reset = 0x0;
        } rx_ch0_int_raw[0:0];
    } AIAO_INT_RAW @ 0x8;
    reg {
        name = "AIAO_SWITCH_RX_BCLK";
        desc = "AIAO_SWITCH_RX_BCLK is the AIO I2S RX BCLK SWITCH configuration register. AIAO_SWITCH_RX_BCLK (offset 0x0028, total reset 0x7654_3210; PROVEN: Hi3535 data sheet, PDF page 1174, section 12.1.6).";
        field {
            name = "reserved";
            desc = "Reserved.";
            sw = rw; hw = r;
            reset = 0x7654321;
        } reserved_31_4[31:4];
        field {
            name = "inner_bclk_ws_sel_rx_00";
            desc = "Internal BCLK select of the receive channel.
- 0000: Select BCLK0;
- 1000: Select BCLK8;
- 1001: Select BCLK9; Others: Reserved.";
            sw = rw; hw = r;
            reset = 0x0;
        } inner_bclk_ws_sel_rx_00[3:0];
    } AIAO_SWITCH_RX_BCLK @ 0x28;
    reg {
        name = "AIAO_SWITCH_TX_BCLK";
        desc = "AIAO_SWITCH_TX_BCLK is the AIO I2S TX BCLK SWITCH configuration register. AIAO_SWITCH_TX_BCLK (offset 0x002C, total reset 0x7654_3210; PROVEN: Hi3535 data sheet, PDF page 1175, section 12.1.6).";
        field {
            name = "reserved";
            desc = "Reserved.";
            sw = rw; hw = r;
            reset = 0x765432;
        } reserved_31_8[31:8];
        field {
            name = "inner_bclk_ws_sel_tx_01";
            desc = "Internal BCLK select of transmit channel 1.
- 0000: Select BCLK0.
- 1000: Select BCLK8.
- 1001: Select BCLK9. Others: Reserved.";
            sw = rw; hw = r;
            reset = 0x1;
        } inner_bclk_ws_sel_tx_01[7:4];
        field {
            name = "inner_bclk_ws_sel_tx_00";
            desc = "Internal BCLK select of transmit channel 0.
- 0000: Select BCLK0;
- 1000: Select BCLK8;
- 1001: Select BCLK9;
Others: Reserved.";
            sw = rw; hw = r;
            reset = 0x0;
        } inner_bclk_ws_sel_tx_00[3:0];
    } AIAO_SWITCH_TX_BCLK @ 0x2c;
    reg {
        name = "AIAO_STATUS";
        desc = "AIAO_STATUS is the AIO status register. AIAO_STATUS (offset 0x0030, total reset 0x0000_0000; PROVEN: Hi3535 data sheet, PDF page 1176, section 12.1.6).";
        field {
            name = "reserved";
            desc = "Reserved.";
            sw = r; hw = w;
            reset = 0x0;
        } reserved_31_1[31:1];
        field {
            name = "srst_rdy";
            desc = "Soft reset status signal.
- 0: Reset in progress;
- 1: Reset complete.";
            sw = r; hw = w;
            reset = 0x0;
        } srst_rdy[0:0];
    } AIAO_STATUS @ 0x30;
    reg {
        name = "I2S_CRG_CFG0_00";
        desc = "I2S_CRG_CFG0_00 is I2S00 CRG configuration register 0. I2S_CRG_CFG0_00 (offset 0x0100, total reset 0x00AA_AAAA; PROVEN: Hi3535 data sheet, PDF page 1176, section 12.1.6).";
        field {
            name = "reserved";
            desc = "Reserved.";
            sw = rw; hw = r;
            reset = 0x0;
        } reserved_31_27[31:27];
        field {
            name = "aiao_mclk_div";
            desc = "Divided clock configuration value of MCLK; the value is (MCLK0/AIO clock source frequency) x 2^27. For the MCLK0 clock source frequency, see 3.2 Clocks.";
            sw = rw; hw = r;
            reset = 0xaaaaaa;
        } aiao_mclk_div[26:0];
    } I2S_CRG_CFG0_00 @ 0x100;
    reg {
        name = "I2S_CRG_CFG1_00";
        desc = "I2S_CRG_CFG1_00 is I2S00 CRG configuration register 1. I2S_CRG_CFG1_00 (offset 0x0104, total reset 0x0000_0131; PROVEN: Hi3535 data sheet, PDF page 1177, section 12.1.6).";
        field {
            name = "reserved";
            desc = "Reserved.";
            sw = rw; hw = r;
            reset = 0x0;
        } reserved_31_14[31:14];
        field {
            name = "aiao_bclkout_pctrl";
            desc = "BCLKOUT polarity control.
- 0: Normal;
- 1: Inverted.";
            sw = rw; hw = r;
            reset = 0x0;
        } aiao_bclkout_pctrl[13:13];
        field {
            name = "aiao_bclkin_pctrl";
            desc = "BCLKIN polarity control.
- 0: Normal;
- 1: Inverted.";
            sw = rw; hw = r;
            reset = 0x0;
        } aiao_bclkin_pctrl[12:12];
        field {
            name = "aiao_bclk_sel";
            desc = "BCLK/FCLK select.
- 0: Clock generated internally;
- 1: Clock input from an external Audio DAC chip.";
            sw = rw; hw = r;
            reset = 0x0;
        } aiao_bclk_sel[11:11];
        field {
            name = "aiao_bclk_oen";
            desc = "BCLK/FCLK IO oen control.
- 0: BCLK/FCLK IO is an output;
- 1: BCLK/FCLK IO is an input. Note: Must be used together with aiao_bclk_sel to select the I2S interface master/slave mode.";
            sw = rw; hw = r;
            reset = 0x0;
        } aiao_bclk_oen[10:10];
        field {
            name = "reserved";
            desc = "Reserved.";
            sw = rw; hw = r;
            reset = 0x0;
        } reserved_9_9[9:9];
        field {
            name = "aiao_cken";
            desc = "Clock status.
- 0: Off.
- 1: On.";
            sw = rw; hw = r;
            reset = 0x1;
        } aiao_cken[8:8];
        field {
            name = "reserved";
            desc = "Reserved extension.";
            sw = rw; hw = r;
            reset = 0x0;
        } reserved_7_7[7:7];
        field {
            name = "aiao_fsclk_div";
            desc = "Divider relationship between the bit clock BCLK and the sampling clock FS.
- 000: FS is BCLK divided by 16;
- 001: FS is BCLK divided by 32;
- 010: FS is BCLK divided by 48;
- 011: FS is BCLK divided by 64;
- 100: FS is BCLK divided by 128;
- 101: FS is BCLK divided by 256; Others: FS is BCLK divided by 8.";
            sw = rw; hw = r;
            reset = 0x3;
        } aiao_fsclk_div[6:4];
        field {
            name = "aiao_bclk_div";
            desc = "Divider relationship between the master clock MCLK and the bit clock BCLK.
- 0000: BCLK is MCLK divided by 1;
- 0001: BCLK is MCLK divided by 3;
- 0010: BCLK is MCLK divided by 2;
- 0011: BCLK is MCLK divided by 4;
- 0100: BCLK is MCLK divided by 6;
- 0101: BCLK is MCLK divided by 8;
- 0110: BCLK is MCLK divided by 12;
- 0111: BCLK is MCLK divided by 16;
- 1000: BCLK is MCLK divided by 24;
- 1001: BCLK is MCLK divided by 32;
- 1010: BCLK is MCLK divided by 48;
- 1011: BCLK is MCLK divided by 64; Others: BCLK is MCLK divided by 8.";
            sw = rw; hw = r;
            reset = 0x1;
        } aiao_bclk_div[3:0];
    } I2S_CRG_CFG1_00 @ 0x104;
    reg {
        name = "I2S_CRG_CFG0_08";
        desc = "I2S_CRG_CFG0_08 is I2S08 CRG configuration register 0. I2S_CRG_CFG0_08 (offset 0x0140, total reset 0x00AA_AAAA; PROVEN: Hi3535 data sheet, PDF page 1178, section 12.1.6).";
        field {
            name = "reserved";
            desc = "Reserved.";
            sw = rw; hw = r;
            reset = 0x0;
        } reserved_31_27[31:27];
        field {
            name = "aiao_mclk_div";
            desc = "Divided clock configuration value of MCLK. The configured value is (MCLK0 / AIO clock source frequency) x 2^27. For the MCLK0 clock source frequency, see 3.2 Clocks.";
            sw = rw; hw = r;
            reset = 0xaaaaaa;
        } aiao_mclk_div[26:0];
    } I2S_CRG_CFG0_08 @ 0x140;
    reg {
        name = "I2S_CRG_CFG1_08";
        desc = "I2S_CRG_CFG1_08 is I2S08 CRG configuration register 1. I2S_CRG_CFG1_08 (offset 0x0144, total reset 0x0000_0131; PROVEN: Hi3535 data sheet, PDF page 1179, section 12.1.6).";
        field {
            name = "reserved";
            desc = "Reserved.";
            sw = rw; hw = r;
            reset = 0x0;
        } reserved_31_14[31:14];
        field {
            name = "aiao_bclkout_pctrl";
            desc = "BCLKOUT polarity control.
- 0: Normal;
- 1: Inverted.";
            sw = rw; hw = r;
            reset = 0x0;
        } aiao_bclkout_pctrl[13:13];
        field {
            name = "aiao_bclkin_pctrl";
            desc = "BCLKIN polarity control.
- 0: Normal;
- 1: Inverted.";
            sw = rw; hw = r;
            reset = 0x0;
        } aiao_bclkin_pctrl[12:12];
        field {
            name = "aiao_bclk_sel";
            desc = "BCLK/FCLK select.
- 0: Clock generated internally;
- 1: Clock input from an external Audio DAC chip.";
            sw = rw; hw = r;
            reset = 0x0;
        } aiao_bclk_sel[11:11];
        field {
            name = "aiao_bclk_oen";
            desc = "BCLK/FCLK IO oen control.
- 0: The BCLK/FCLK IO is an output (AIO is in master mode).
- 1: The BCLK/FCLK IO is an input (AIO is in slave mode). Note: Must be used together with aiao_bclk_sel to select the I2S interface master/slave mode.";
            sw = rw; hw = r;
            reset = 0x0;
        } aiao_bclk_oen[10:10];
        field {
            name = "reserved";
            desc = "Reserved.";
            sw = rw; hw = r;
            reset = 0x0;
        } reserved_9_9[9:9];
        field {
            name = "aiao_cken";
            desc = "Clock status.
- 0: Off.
- 1: On.";
            sw = rw; hw = r;
            reset = 0x1;
        } aiao_cken[8:8];
        field {
            name = "reserved";
            desc = "Reserved.";
            sw = rw; hw = r;
            reset = 0x0;
        } reserved_7_7[7:7];
        field {
            name = "aiao_fsclk_div";
            desc = "Divider relationship between the bit clock BCLK and the sampling clock FS.
- 000: FS is BCLK divided by 16;
- 001: FS is BCLK divided by 32;
- 010: FS is BCLK divided by 48;
- 011: FS is BCLK divided by 64;
- 100: FS is BCLK divided by 128;
- 101: FS is BCLK divided by 256; Others: FS is BCLK divided by 8.";
            sw = rw; hw = r;
            reset = 0x3;
        } aiao_fsclk_div[6:4];
        field {
            name = "aiao_bclk_div";
            desc = "Divider relationship between the master clock MCLK and the bit clock BCLK.
- 0000: BCLK is MCLK divided by 1;
- 0001: BCLK is MCLK divided by 3;
- 0010: BCLK is MCLK divided by 2;
- 0011: BCLK is MCLK divided by 4;
- 0100: BCLK is MCLK divided by 6;
- 0101: BCLK is MCLK divided by 8;
- 0110: BCLK is MCLK divided by 12;
- 0111: BCLK is MCLK divided by 16;
- 1000: BCLK is MCLK divided by 24;
- 1001: BCLK is MCLK divided by 32;
- 1010: BCLK is MCLK divided by 48;
- 1011: BCLK is MCLK divided by 64; Others: BCLK is MCLK divided by 8.";
            sw = rw; hw = r;
            reset = 0x1;
        } aiao_bclk_div[3:0];
    } I2S_CRG_CFG1_08 @ 0x144;
    reg {
        name = "I2S_CRG_CFG0_09";
        desc = "I2S_CRG_CFG0_09 is I2S09 CRG configuration register 0. I2S_CRG_CFG0_09 (offset 0x0148, total reset 0x00AA_AAAA; PROVEN: Hi3535 data sheet, PDF page 1180, section 12.1.6).";
        field {
            name = "reserved";
            desc = "Reserved.";
            sw = rw; hw = r;
            reset = 0x0;
        } reserved_31_27[31:27];
        field {
            name = "aiao_mclk_div";
            desc = "Divided clock configuration value of MCLK; the value is (MCLK0/AIO clock source frequency) x 2^27. For the MCLK0 clock source frequency, see 3.2 Clocks.";
            sw = rw; hw = r;
            reset = 0xaaaaaa;
        } aiao_mclk_div[26:0];
    } I2S_CRG_CFG0_09 @ 0x148;
    reg {
        name = "I2S_CRG_CFG1_09";
        desc = "I2S_CRG_CFG1_09 is I2S09 CRG configuration register 1. I2S_CRG_CFG1_09 (offset 0x014C, total reset 0x0000_0131; PROVEN: Hi3535 data sheet, PDF page 1181, section 12.1.6).";
        field {
            name = "reserved";
            desc = "Reserved.";
            sw = rw; hw = r;
            reset = 0x0;
        } reserved_31_14[31:14];
        field {
            name = "aiao_bclkout_pctrl";
            desc = "BCLKOUT polarity control.
- 0: Normal;
- 1: Inverted.";
            sw = rw; hw = r;
            reset = 0x0;
        } aiao_bclkout_pctrl[13:13];
        field {
            name = "aiao_bclkin_pctrl";
            desc = "BCLKIN polarity control.
- 0: Normal;
- 1: Inverted.";
            sw = rw; hw = r;
            reset = 0x0;
        } aiao_bclkin_pctrl[12:12];
        field {
            name = "aiao_bclk_sel";
            desc = "BCLK/FCLK select.
- 0: Clock generated internally;
- 1: Clock input from an external Audio DAC chip.";
            sw = rw; hw = r;
            reset = 0x0;
        } aiao_bclk_sel[11:11];
        field {
            name = "aiao_bclk_oen";
            desc = "BCLK/FCLK IO oen control.
- 0: BCLK/FCLK IO is an output;
- 1: BCLK/FCLK IO is an input. Note: Must be used together with aiao_bclk_sel to select the I2S interface master/slave mode.";
            sw = rw; hw = r;
            reset = 0x0;
        } aiao_bclk_oen[10:10];
        field {
            name = "reserved";
            desc = "Reserved.";
            sw = rw; hw = r;
            reset = 0x0;
        } reserved_9_9[9:9];
        field {
            name = "aiao_cken";
            desc = "Clock status.
- 0: Off.
- 1: On.";
            sw = rw; hw = r;
            reset = 0x1;
        } aiao_cken[8:8];
        field {
            name = "reserved";
            desc = "Reserved extension.";
            sw = rw; hw = r;
            reset = 0x0;
        } reserved_7_7[7:7];
        field {
            name = "aiao_fsclk_div";
            desc = "Divider relationship between the bit clock BCLK and the sampling clock FS.
- 000: FS is BCLK divided by 16;
- 001: FS is BCLK divided by 32;
- 010: FS is BCLK divided by 48;
- 011: FS is BCLK divided by 64;
- 100: FS is BCLK divided by 128;
- 101: FS is BCLK divided by 256; Others: FS is BCLK divided by 8.";
            sw = rw; hw = r;
            reset = 0x3;
        } aiao_fsclk_div[6:4];
        field {
            name = "aiao_bclk_div";
            desc = "Divider relationship between the master clock MCLK and the bit clock BCLK.
- 0000: BCLK is MCLK divided by 1;
- 0001: BCLK is MCLK divided by 3;
- 0010: BCLK is MCLK divided by 2;
- 0011: BCLK is MCLK divided by 4;
- 0100: BCLK is MCLK divided by 6;
- 0101: BCLK is MCLK divided by 8;
- 0110: BCLK is MCLK divided by 12;
- 0111: BCLK is MCLK divided by 16;
- 1000: BCLK is MCLK divided by 24;
- 1001: BCLK is MCLK divided by 32;
- 1010: BCLK is MCLK divided by 48;
- 1011: BCLK is MCLK divided by 64; Others: BCLK is MCLK divided by 8.";
            sw = rw; hw = r;
            reset = 0x1;
        } aiao_bclk_div[3:0];
    } I2S_CRG_CFG1_09 @ 0x14c;
    reg {
        name = "RX_IF_ATTRI";
        desc = "RX_IF_ATTRI is the interface attribute setting register of the receive channel. RX_IF_ATTRI (offset 0x1000, total reset 0xE400_0004; PROVEN: Hi3535 data sheet, PDF page 1183, section 12.1.6).";
        field {
            name = "rx_sd3_sel";
            desc = "SD3 select.
- 00: SD0.
- 01: SD1.
- 10: SD2.
- 11: SD3. Note: Select the channel first, then select the data line.";
            sw = rw; hw = r;
            reset = 0x3;
        } rx_sd3_sel[31:30];
        field {
            name = "rx_sd2_sel";
            desc = "SD2 select
- 00: SD0;
- 01: SD1;
- 10: SD2;
- 11: SD3.
Note: select the channel first, then select the data line.";
            sw = rw; hw = r;
            reset = 0x2;
        } rx_sd2_sel[29:28];
        field {
            name = "rx_sd1_sel";
            desc = "SD1 select.
- 00: SD0.
- 01: SD1.
- 10: SD2.
- 11: SD3. Note: Select the channel first, then select the data line.";
            sw = rw; hw = r;
            reset = 0x1;
        } rx_sd1_sel[27:26];
        field {
            name = "rx_sd0_sel";
            desc = "SD0 select.
- 00: SD0;
- 01: SD1;
- 10: SD2;
- 11: SD3.
Note: Select the channel first, then select the data line.";
            sw = rw; hw = r;
            reset = 0x0;
        } rx_sd0_sel[25:24];
        field {
            name = "rx_sd_source_sel";
            desc = "Source select for SD0, SD1, SD2 and SD3.
- 0000: I2S TX0.
- 0001: I2S TX1.
- 1000: I2S RX0. Others: Reserved.";
            sw = rw; hw = r;
            reset = 0x0;
        } rx_sd_source_sel[23:20];
        field {
            name = "reserved";
            desc = "Reserved.";
            sw = rw; hw = r;
            reset = 0x0;
        } reserved_19_19[19:19];
        field {
            name = "rx_trackmode";
            desc = "Left/right channel mode control in I2S mode.
- 000: No processing;
- 001: Both channels carry the left channel audio;
- 010: Both channels carry the right channel audio;
- 011: The two channels are swapped;
- 100: Both channel outputs carry the sum of the left and right channels;
- 101: Left channel muted, right channel plays its original right channel audio;
- 110: Right channel muted, left channel plays its original left channel audio;
- 111: Left and right channels muted. Note: trackmode is still valid for 1ch reception.";
            sw = rw; hw = r;
            reset = 0x0;
        } rx_trackmode[18:16];
        field {
            name = "rx_sd_offset";
            desc = "In PCM mode, the data is delayed by n BCLK cycles relative to the frame sync signal.
- 0x00: 0 bit clocks;
- 0x01: 1 bit clocks;
- 0x02: 2 bit clocks;
- ...
- 0xFE: 254 bitclocks;
- 0xFF: 255 bitclocks.";
            sw = rw; hw = r;
            reset = 0x0;
        } rx_sd_offset[15:8];
        field {
            name = "rx_multislot_en";
            desc = "Time-division multiplexing valid indication bit.
- 0: Time-division multiplexing mode is invalid, normal mode;
- 1: Time-division multiplexing mode is valid.";
            sw = rw; hw = r;
            reset = 0x0;
        } rx_multislot_en[7:7];
        field {
            name = "reserved";
            desc = "Reserved.";
            sw = rw; hw = r;
            reset = 0x0;
        } reserved_6_6[6:6];
        field {
            name = "rx_ch_num";
            desc = "Receive channel count select. rx_multislot_en = 0
- 00: 1 channel (ch) receive (sd0 data line).
- 01: 2 channel (ch) receive (sd0 data line).
- 10: Reserved.
- 11: 8 channel (ch) receive (sd0, sd1, sd2, sd3 data lines). Others: Reserved. rx_multislot_en = 1 Channel count select for receive in time-division multiplexing mode.
- 00: 2 channel receive (sd0 data line).
- 01: 4 channel receive (sd0 data line).
- 10: 8 channel receive (sd0 data line).
- 11: 16 channel receive (sd0 data line). Note: For multi-channel receive, only data line 0 (sd0) is used.";
            sw = rw; hw = r;
            reset = 0x0;
        } rx_ch_num[5:4];
        field {
            name = "rx_i2s_precision";
            desc = "Data sampling precision configuration bits. rx_multislot_en = 0 I2S normal mode:
- 00: Reserved;
- 01: 16bit;
- 10: 24bit;
- 11: Reserved.

PCM normal mode:
- 00: 8bit;
- 01: 16bit;
Others: Reserved. rx_multislot_en = 1

I2S/PCM mode:
- 00: 8bit;
- 01: 16bit;
Others: Reserved.";
            sw = rw; hw = r;
            reset = 0x1;
        } rx_i2s_precision[3:2];
        field {
            name = "rx_mode";
            desc = "Interface mode select of the receive channel.
- 00: I2S mode.
- 01: PCM mode. Others: Reserved.";
            sw = rw; hw = r;
            reset = 0x0;
        } rx_mode[1:0];
    } RX_IF_ATTRI @ 0x1000;
    reg {
        name = "RX_DSP_CTRL";
        desc = "RX_DSP_CTRL is the control register of the receive processing channel. RX_DSP_CTRL (offset 0x1004, total reset 0x0000_0000; PROVEN: Hi3535 data sheet, PDF page 1186, section 12.1.6).";
        field {
            name = "reserved";
            desc = "Reserved.";
            sw = rw; hw = r;
            reset = 0x0;
        } reserved_31_30[31:30];
        field {
            name = "disable_done";
            desc = "Receive channel stop-complete flag.
- 0: Stop not complete;
- 1: Stop complete.";
            sw = rw; hw = r;
            reset = 0x0;
        } disable_done[29:29];
        field {
            name = "rx_enable";
            desc = "Start/stop indication bit of the receive channel.
- 0: Stop;
- 1: Start.";
            sw = rw; hw = r;
            reset = 0x0;
        } rx_enable[28:28];
        field {
            name = "bypass_en";
            desc = "Processing bypass; the control functions remain in effect.
- 0: Bypass function off.
- 1: Bypass function on; the trackmode function is bypassed.";
            sw = rw; hw = r;
            reset = 0x0;
        } bypass_en[27:27];
        field {
            name = "reserved";
            desc = "Reserved.";
            sw = rw; hw = r;
            reset = 0x0;
        } reserved_26_0[26:0];
    } RX_DSP_CTRL @ 0x1004;
    reg {
        name = "RX_BUFF_SADDR";
        desc = "RX_BUFF_SADDR is the DDR buffer start address register of the receive channel. RX_BUFF_SADDR (offset 0x1080, total reset 0x0000_0000; PROVEN: Hi3535 data sheet, PDF page 1187, section 12.1.6).";
        field {
            name = "rx_buff_saddr";
            desc = "DDR buffer start address of receive channel 0, in bytes. Note: The DDR buffer start address must be aligned to 128 x 2 bits.";
            sw = rw; hw = r;
            reset = 0x0;
        } rx_buff_saddr[31:0];
    } RX_BUFF_SADDR @ 0x1080;
    reg {
        name = "RX_BUFF_SIZE";
        desc = "RX_BUFF_SIZE is the DDR buffer size register of the receive channel. RX_BUFF_SIZE (offset 0x1084, total reset 0x0000_0000; PROVEN: Hi3535 data sheet, PDF page 1187, section 12.1.6).";
        field {
            name = "reserved";
            desc = "Reserved.";
            sw = rw; hw = r;
            reset = 0x0;
        } reserved_31_24[31:24];
        field {
            name = "rx_buff_size";
            desc = "DDR buffer size of the receive channel, in bytes. Note: rx_buff_size must be an integer multiple of 32 bytes.";
            sw = rw; hw = r;
            reset = 0x0;
        } rx_buff_size[23:0];
    } RX_BUFF_SIZE @ 0x1084;
    reg {
        name = "RX_BUFF_WPTR";
        desc = "RX_BUFF_WPTR is the DDR buffer write address register of the receive channel. RX_BUFF_WPTR (offset 0x1088, total reset 0x0000_0000; PROVEN: Hi3535 data sheet, PDF page 1187, section 12.1.6).";
        field {
            name = "reserved";
            desc = "Reserved.";
            sw = rw; hw = r;
            reset = 0x0;
        } reserved_31_24[31:24];
        field {
            name = "rx_buff_wptr";
            desc = "DDR buffer write address of the receive channel, in bytes. Note 1: The write address in the receive direction is maintained by logic and is an offset from the DDR buffer start address. Note 2: Must be aligned to 128 x 2 bits.";
            sw = rw; hw = r;
            reset = 0x0;
        } rx_buff_wptr[23:0];
    } RX_BUFF_WPTR @ 0x1088;
    reg {
        name = "RX_BUFF_RPTR";
        desc = "RX_BUFF_RPTR is the DDR buffer read address register of the receive channel. RX_BUFF_RPTR (offset 0x108C, total reset 0x0000_0000; PROVEN: Hi3535 data sheet, PDF page 1188, section 12.1.6).";
        field {
            name = "reserved";
            desc = "Reserved.";
            sw = rw; hw = r;
            reset = 0x0;
        } reserved_31_24[31:24];
        field {
            name = "rx_buff_rptr";
            desc = "DDR buffer read address of the receive channel, in bytes. Note 1: The read address in the receive direction is maintained by software and is an offset relative to the DDR buffer start address. Note 2: Software works in bytes; the hardware operates internally with 32-byte alignment.";
            sw = rw; hw = r;
            reset = 0x0;
        } rx_buff_rptr[23:0];
    } RX_BUFF_RPTR @ 0x108c;
    reg {
        name = "RX_BUFF_ALFULL_TH";
        desc = "RX_BUFF_ALFULL_TH is the DDR buffer almost-full watermark register of the receive channel. RX_BUFF_ALFULL_TH (offset 0x1090, total reset 0x0000_0000; PROVEN: Hi3535 data sheet, PDF page 1188, section 12.1.6).";
        field {
            name = "reserved";
            desc = "Reserved.";
            sw = rw; hw = r;
            reset = 0x0;
        } reserved_31_24[31:24];
        field {
            name = "rx_buff_alfull_th";
            desc = "Almost-full watermark of the DDR buffer of the receive channel, in bytes. When the writable space of the DDR buffer is smaller than the almost-full watermark, an almost-full raw interrupt is generated. Note: If the rx_alfull_int interrupt is used, rx_buff_alfull_th must be configured as an integer multiple of 16 bytes and greater than or equal to 0x40.";
            sw = rw; hw = r;
            reset = 0x0;
        } rx_buff_alfull_th[23:0];
    } RX_BUFF_ALFULL_TH @ 0x1090;
    reg {
        name = "RX_TRANS_SIZE";
        desc = "RX_TRANS_SIZE is the data transfer length register of the receive channel. RX_TRANS_SIZE (offset 0x1094, total reset 0x0000_0000; PROVEN: Hi3535 data sheet, PDF page 1189, section 12.1.6).";
        field {
            name = "reserved";
            desc = "Reserved.";
            sw = rw; hw = r;
            reset = 0x0;
        } reserved_31_24[31:24];
        field {
            name = "rx_trans_size";
            desc = "Receive channel: when audio data of length rx_trans_size (in bytes) has been received, a transfer done interrupt is generated.";
            sw = rw; hw = r;
            reset = 0x0;
        } rx_trans_size[23:0];
    } RX_TRANS_SIZE @ 0x1094;
    reg {
        name = "RX_WPTR_TMP";
        desc = "RX_WPTR_TMP is the register that saves the write address of the receive channel when the transfer completion interrupt is reported. RX_WPTR_TMP (offset 0x1098, total reset 0x0000_0000; PROVEN: Hi3535 data sheet, PDF page 1189, section 12.1.6).";
        field {
            name = "reserved";
            desc = "Reserved.";
            sw = r; hw = w;
            reset = 0x0;
        } reserved_31_24[31:24];
        field {
            name = "rx_wptr_tmp";
            desc = "Holds the write address of the receive channel, in bytes, when the transfer completion interrupt is reported.";
            sw = r; hw = w;
            reset = 0x0;
        } rx_wptr_tmp[23:0];
    } RX_WPTR_TMP @ 0x1098;
    reg {
        name = "RX_INT_ENA";
        desc = "RX_INT_ENA is the interrupt enable register of the receive channel. RX_INT_ENA (offset 0x10A0, total reset 0x0000_0000; PROVEN: Hi3535 data sheet, PDF page 1190, section 12.1.6).";
        field {
            name = "reserved";
            desc = "Reserved.";
            sw = rw; hw = r;
            reset = 0x0;
        } reserved_31_8[31:8];
        field {
            name = "rx_fifo_lost_int_ena";
            desc = "Frame drop interrupt enable of the receive channel.
- 0: Disable.
- 1: Enable.";
            sw = r; hw = w;
            reset = 0x0;
        } rx_fifo_lost_int_ena[7:7];
        field {
            name = "reserved";
            desc = "Reserved.";
            sw = r; hw = w;
            reset = 0x0;
        } reserved_6_6[6:6];
        field {
            name = "rx_stop_int_ena";
            desc = "Stop interrupt enable of the receive channel.
- 0: Disable;
- 1: Enable.";
            sw = rw; hw = r;
            reset = 0x0;
        } rx_stop_int_ena[5:5];
        field {
            name = "reserved";
            desc = "Reserved";
            sw = rw; hw = r;
            reset = 0x0;
        } reserved_4_4[4:4];
        field {
            name = "rx_bfifo_full_int_ena";
            desc = "Bus FIFO overflow interrupt enable of the receive channel.
- 0: Disable;
- 1: Enable.";
            sw = rw; hw = r;
            reset = 0x0;
        } rx_bfifo_full_int_ena[3:3];
        field {
            name = "rx_alfull_int_ena";
            desc = "Receive channel DDR buffer almost-full interrupt enable.
- 0: Disable;
- 1: Enable.";
            sw = rw; hw = r;
            reset = 0x0;
        } rx_alfull_int_ena[2:2];
        field {
            name = "rx_full_int_ena";
            desc = "DDR buffer full interrupt enable of the receive channel.
- 0: Disable;
- 1: Enable.";
            sw = rw; hw = r;
            reset = 0x0;
        } rx_full_int_ena[1:1];
        field {
            name = "rx_trans_int_ena";
            desc = "Transfer completion interrupt enable of the receive channel.
- 0: Disable;
- 1: Enable.";
            sw = rw; hw = r;
            reset = 0x0;
        } rx_trans_int_ena[0:0];
    } RX_INT_ENA @ 0x10a0;
    reg {
        name = "RX_INT_RAW";
        desc = "RX_INT_RAW is the raw interrupt register of the receive channel. RX_INT_RAW (offset 0x10A4, total reset 0x0000_0000; PROVEN: Hi3535 data sheet, PDF page 1191, section 12.1.6).";
        field {
            name = "reserved";
            desc = "Reserved.";
            sw = r; hw = w;
            reset = 0x0;
        } reserved_31_8[31:8];
        field {
            name = "rx_fifo_lost_int_raw";
            desc = "Raw interrupt for data loss due to full interface data of the receive channel.
- 0: No raw interrupt;
- 1: Raw interrupt present.";
            sw = r; hw = w;
            reset = 0x0;
        } rx_fifo_lost_int_raw[7:7];
        field {
            name = "reserved";
            desc = "Reserved.";
            sw = r; hw = w;
            reset = 0x0;
        } reserved_6_6[6:6];
        field {
            name = "rx_stop_int_raw";
            desc = "Stop raw interrupt of the receive channel.
- 0: No raw interrupt.
- 1: Raw interrupt present.";
            sw = r; hw = w;
            reset = 0x0;
        } rx_stop_int_raw[5:5];
        field {
            name = "reserved";
            desc = "Reserved.";
            sw = r; hw = w;
            reset = 0x0;
        } reserved_4_4[4:4];
        field {
            name = "rx_fifo_full_int_raw";
            desc = "Bus FIFO overflow raw interrupt of the receive channel.
- 0: No raw interrupt.
- 1: Raw interrupt present.";
            sw = r; hw = w;
            reset = 0x0;
        } rx_fifo_full_int_raw[3:3];
        field {
            name = "rx_alfull_int_raw";
            desc = "Raw interrupt of the receive channel DDR buffer almost full.
- 0: No raw interrupt;
- 1: Raw interrupt present.";
            sw = r; hw = w;
            reset = 0x0;
        } rx_alfull_int_raw[2:2];
        field {
            name = "rx_full_int_raw";
            desc = "DDR buffer full raw interrupt of the receive channel.
- 0: No raw interrupt.
- 1: Raw interrupt present.";
            sw = r; hw = w;
            reset = 0x0;
        } rx_full_int_raw[1:1];
        field {
            name = "rx_trans_int_raw";
            desc = "Transfer completion raw interrupt of the receive channel.
- 0: No raw interrupt;
- 1: Raw interrupt present.";
            sw = r; hw = w;
            reset = 0x0;
        } rx_trans_int_raw[0:0];
    } RX_INT_RAW @ 0x10a4;
    reg {
        name = "RX_INT_STATUS";
        desc = "RX_INT_STATUS is the interrupt status register of the receive channel. RX_INT_STATUS (offset 0x10A8, total reset 0x0000_0000; PROVEN: Hi3535 data sheet, PDF page 1192, section 12.1.6).";
        field {
            name = "reserved";
            desc = "Reserved.";
            sw = r; hw = w;
            reset = 0x0;
        } reserved_31_8[31:8];
        field {
            name = "rx_fifo_lost_int_raw";
            desc = "Interrupt status of the receive channel interface data loss because the buffer is full.
- 0: No interrupt status;
- 1: Interrupt status present.";
            sw = r; hw = w;
            reset = 0x0;
        } rx_fifo_lost_int_raw[7:7];
        field {
            name = "reserved";
            desc = "Reserved.";
            sw = r; hw = w;
            reset = 0x0;
        } reserved_6_6[6:6];
        field {
            name = "rx_stop_int_status";
            desc = "Stop interrupt status of the receive channel.
- 0: No interrupt status.
- 1: Interrupt status present.";
            sw = r; hw = w;
            reset = 0x0;
        } rx_stop_int_status[5:5];
        field {
            name = "reserved";
            desc = "Reserved.";
            sw = r; hw = w;
            reset = 0x0;
        } reserved_4_4[4:4];
        field {
            name = "rx_bfifo_full_int_status";
            desc = "Interrupt status of the receive channel bus FIFO overflow.
- 0: No interrupt status;
- 1: Interrupt status present.";
            sw = r; hw = w;
            reset = 0x0;
        } rx_bfifo_full_int_status[3:3];
        field {
            name = "rx_alfull_int_status";
            desc = "DDR buffer almost-full interrupt status of the receive channel.
- 0: No interrupt status;
- 1: Interrupt status present.";
            sw = r; hw = w;
            reset = 0x0;
        } rx_alfull_int_status[2:2];
        field {
            name = "rx_full_int_status";
            desc = "Interrupt status of the receive channel DDR buffer full.
- 0: No interrupt status;
- 1: Interrupt status present.";
            sw = r; hw = w;
            reset = 0x0;
        } rx_full_int_status[1:1];
        field {
            name = "rx_trans_int_status";
            desc = "Transfer done interrupt status of the receive channel.
- 0: No interrupt status.
- 1: Interrupt status present.";
            sw = r; hw = w;
            reset = 0x0;
        } rx_trans_int_status[0:0];
    } RX_INT_STATUS @ 0x10a8;
    reg {
        name = "RX_INT_CLR";
        desc = "RX_INT_CLR is the interrupt clear register of the receive channel. RX_INT_CLR (offset 0x10AC, total reset 0x0000_0000; PROVEN: Hi3535 data sheet, PDF page 1193, section 12.1.6).";
        field {
            name = "reserved";
            desc = "Reserved. (data sheet access type WC)";
            sw = rw; hw = r; onwrite = woclr;
            reset = 0x0;
        } reserved_31_8[31:8];
        field {
            name = "rx_fifo_lost_int_clear";
            desc = "Interface data full loss interrupt clear bit of the receive channel.
- 0: Do not clear;
- 1: Clear the stop interrupt. (data sheet access type WC)";
            sw = rw; hw = r; onwrite = woclr;
            reset = 0x0;
        } rx_fifo_lost_int_clear[7:7];
        field {
            name = "reserved";
            desc = "Reserved. (data sheet access type WC)";
            sw = rw; hw = r; onwrite = woclr;
            reset = 0x0;
        } reserved_6_6[6:6];
        field {
            name = "rx_stop_int_clear";
            desc = "Stop interrupt clear bit of the receive channel.
- 0: Do not clear;
- 1: Clear the stop interrupt. (data sheet access type WC)";
            sw = rw; hw = r; onwrite = woclr;
            reset = 0x0;
        } rx_stop_int_clear[5:5];
        field {
            name = "rx_ififo_full_int_clear";
            desc = "Interface fifo overflow interrupt clear bit of the receive channel.
- 0: Do not clear;
- 1: Clear the fifo overflow interrupt. (data sheet access type WC)";
            sw = rw; hw = r; onwrite = woclr;
            reset = 0x0;
        } rx_ififo_full_int_clear[4:4];
        field {
            name = "rx_bfifo_full_int_clear";
            desc = "Bus FIFO overflow interrupt clear bit of the receive channel.
- 0: Do not clear.
- 1: Clear the FIFO overflow interrupt. (data sheet access type WC)";
            sw = rw; hw = r; onwrite = woclr;
            reset = 0x0;
        } rx_bfifo_full_int_clear[3:3];
        field {
            name = "rx_alfull_int_clear";
            desc = "DDR buffer almost-full interrupt clear bit of the receive channel.
- 0: Do not clear.
- 1: Clear the DDR buffer almost-full interrupt. (data sheet access type WC)";
            sw = rw; hw = r; onwrite = woclr;
            reset = 0x0;
        } rx_alfull_int_clear[2:2];
        field {
            name = "rx_full_int_clear";
            desc = "DDR buffer full interrupt clear bit of the receive channel.
- 0: Do not clear;
- 1: Clear the DDR buffer full interrupt. (data sheet access type WC)";
            sw = rw; hw = r; onwrite = woclr;
            reset = 0x0;
        } rx_full_int_clear[1:1];
        field {
            name = "rx_trans_int_clear";
            desc = "Transfer complete interrupt clear bit of the receive channel.
- 0: Do not clear;
- 1: Clear the transfer complete interrupt.";
            sw = w; hw = r;
            reset = 0x0;
        } rx_trans_int_clear[0:0];
    } RX_INT_CLR @ 0x10ac;
    reg {
        name = "TX_IF_ATTRI";
        desc = "TX_IF_ATTRI is the interface attribute setting register of the transmit channel. TX_IF_ATTRI (offset 0x2000+0x100xm (m = 0~1), total reset 0xE400_0004; PROVEN: Hi3535 data sheet, PDF page 1194, section 12.1.6).";
        field {
            name = "tx_sd3_sel";
            desc = "SD3 select.
- 00: SD0.
- 01: SD1.
- 10: SD2.
- 11: SD3. Note: Select the channel first, then select the data line.";
            sw = rw; hw = r;
            reset = 0x3;
        } tx_sd3_sel[31:30];
        field {
            name = "tx_sd2_sel";
            desc = "SD2 select.
- 00: SD0;
- 01: SD1;
- 10: SD2;
- 11: SD3.
Note: Select the channel first, then select the data line.";
            sw = rw; hw = r;
            reset = 0x2;
        } tx_sd2_sel[29:28];
        field {
            name = "tx_sd1_sel";
            desc = "SD1 select.
- 00: SD0.
- 01: SD1.
- 10: SD2.
- 11: SD3. Note: Select the channel first, then select the data line.";
            sw = rw; hw = r;
            reset = 0x1;
        } tx_sd1_sel[27:26];
        field {
            name = "tx_sd0_sel";
            desc = "SD0 select.
- 00: SD0;
- 01: SD1;
- 10: SD2;
- 11: SD3.
Note: Select the channel first, then select the data line.";
            sw = rw; hw = r;
            reset = 0x0;
        } tx_sd0_sel[25:24];
        field {
            name = "tx_sd_source_sel";
            desc = "SD0, SD1, SD2, SD3 source selection.
- 0000: I2S TX0;
- 0001: I2S TX1;
- 1000: I2S RX0; Others: Reserved.";
            sw = rw; hw = r;
            reset = 0x0;
        } tx_sd_source_sel[23:20];
        field {
            name = "reserved";
            desc = "Reserved.";
            sw = rw; hw = r;
            reset = 0x0;
        } reserved_19_19[19:19];
        field {
            name = "tx_trackmode";
            desc = "Left/right channel mode control in I2S mode.
- 000: No processing;
- 001: Both channels carry the left channel audio;
- 010: Both channels carry the right channel audio;
- 011: The two channels are swapped;
- 100: Both channel outputs carry the sum of the left and right channels;
- 101: Left channel muted, right channel plays its original right channel audio;
- 110: Right channel muted, left channel plays its original left channel audio;
- 111: Left and right channels muted. Note: trackmode is still valid for 1ch reception.";
            sw = rw; hw = r;
            reset = 0x0;
        } tx_trackmode[18:16];
        field {
            name = "tx_sd_offset";
            desc = "In PCM mode, the data is delayed by n BCLK cycles relative to the frame sync signal.
- 0x00: 0 bit clocks;
- 0x01: 1 bit clocks;
- 0x02: 2 bit clocks;
- ...
- 0xFE: 254 bitclocks;
- 0xFF: 255 bitclocks.";
            sw = rw; hw = r;
            reset = 0x0;
        } tx_sd_offset[15:8];
        field {
            name = "reserved";
            desc = "Reserved.";
            sw = rw; hw = r;
            reset = 0x0;
        } reserved_7_7[7:7];
        field {
            name = "tx_underflow_ctrl";
            desc = "Output control on tx channel underrun.
- 0: Output 0 on underrun;
- 1: Output the last sample data on underrun.";
            sw = rw; hw = r;
            reset = 0x0;
        } tx_underflow_ctrl[6:6];
        field {
            name = "tx_ch_num";
            desc = "Transmit channel count select. tx_multislot_en = 0
- 00: 1 channel transmit.
- 01: 2 channel transmit.
- 10: 6 channel transmit.
- 11: 8 channel transmit. Others: Reserved. tx_multislot_en = 1 Channel count select for transmit in time-division multiplexing mode.
- 00: 2 channel transmit.
- 01: 4 channel transmit.
- 10: 8 channel transmit.
- 11: 16 channel transmit. Note 1: For multi-channel transmit, only data line 0 (sd0) is used. Note 2: TX does not support time-division multiplexing mode.";
            sw = rw; hw = r;
            reset = 0x0;
        } tx_ch_num[5:4];
        field {
            name = "tx_i2s_precision";
            desc = "Data sampling precision configuration bits. I2S normal mode:
- 00: Reserved;
- 01: 16bit;
- 10: 24bit;
- 11: Reserved.

PCM normal mode:
- 00: 8bit;
- 01: 16bit;
Other values: reserved.";
            sw = rw; hw = r;
            reset = 0x1;
        } tx_i2s_precision[3:2];
        field {
            name = "tx_mode";
            desc = "Interface mode select of the transmit channel.
- 00: I2S mode.
- 01: PCM mode. Others: Reserved.";
            sw = rw; hw = r;
            reset = 0x0;
        } tx_mode[1:0];
    } TX_IF_ATTRI_0 @ 0x2000;
    reg {
        name = "TX_IF_ATTRI";
        desc = "TX_IF_ATTRI is the interface attribute setting register of the transmit channel. TX_IF_ATTRI (offset 0x2000+0x100xm (m = 0~1), total reset 0xE400_0004; PROVEN: Hi3535 data sheet, PDF page 1194, section 12.1.6).";
        field {
            name = "tx_sd3_sel";
            desc = "SD3 select.
- 00: SD0.
- 01: SD1.
- 10: SD2.
- 11: SD3. Note: Select the channel first, then select the data line.";
            sw = rw; hw = r;
            reset = 0x3;
        } tx_sd3_sel[31:30];
        field {
            name = "tx_sd2_sel";
            desc = "SD2 select.
- 00: SD0;
- 01: SD1;
- 10: SD2;
- 11: SD3.
Note: Select the channel first, then select the data line.";
            sw = rw; hw = r;
            reset = 0x2;
        } tx_sd2_sel[29:28];
        field {
            name = "tx_sd1_sel";
            desc = "SD1 select.
- 00: SD0.
- 01: SD1.
- 10: SD2.
- 11: SD3. Note: Select the channel first, then select the data line.";
            sw = rw; hw = r;
            reset = 0x1;
        } tx_sd1_sel[27:26];
        field {
            name = "tx_sd0_sel";
            desc = "SD0 select.
- 00: SD0;
- 01: SD1;
- 10: SD2;
- 11: SD3.
Note: Select the channel first, then select the data line.";
            sw = rw; hw = r;
            reset = 0x0;
        } tx_sd0_sel[25:24];
        field {
            name = "tx_sd_source_sel";
            desc = "SD0, SD1, SD2, SD3 source selection.
- 0000: I2S TX0;
- 0001: I2S TX1;
- 1000: I2S RX0; Others: Reserved.";
            sw = rw; hw = r;
            reset = 0x0;
        } tx_sd_source_sel[23:20];
        field {
            name = "reserved";
            desc = "Reserved.";
            sw = rw; hw = r;
            reset = 0x0;
        } reserved_19_19[19:19];
        field {
            name = "tx_trackmode";
            desc = "Left/right channel mode control in I2S mode.
- 000: No processing;
- 001: Both channels carry the left channel audio;
- 010: Both channels carry the right channel audio;
- 011: The two channels are swapped;
- 100: Both channel outputs carry the sum of the left and right channels;
- 101: Left channel muted, right channel plays its original right channel audio;
- 110: Right channel muted, left channel plays its original left channel audio;
- 111: Left and right channels muted. Note: trackmode is still valid for 1ch reception.";
            sw = rw; hw = r;
            reset = 0x0;
        } tx_trackmode[18:16];
        field {
            name = "tx_sd_offset";
            desc = "In PCM mode, the data is delayed by n BCLK cycles relative to the frame sync signal.
- 0x00: 0 bit clocks;
- 0x01: 1 bit clocks;
- 0x02: 2 bit clocks;
- ...
- 0xFE: 254 bitclocks;
- 0xFF: 255 bitclocks.";
            sw = rw; hw = r;
            reset = 0x0;
        } tx_sd_offset[15:8];
        field {
            name = "reserved";
            desc = "Reserved.";
            sw = rw; hw = r;
            reset = 0x0;
        } reserved_7_7[7:7];
        field {
            name = "tx_underflow_ctrl";
            desc = "Output control on tx channel underrun.
- 0: Output 0 on underrun;
- 1: Output the last sample data on underrun.";
            sw = rw; hw = r;
            reset = 0x0;
        } tx_underflow_ctrl[6:6];
        field {
            name = "tx_ch_num";
            desc = "Transmit channel count select. tx_multislot_en = 0
- 00: 1 channel transmit.
- 01: 2 channel transmit.
- 10: 6 channel transmit.
- 11: 8 channel transmit. Others: Reserved. tx_multislot_en = 1 Channel count select for transmit in time-division multiplexing mode.
- 00: 2 channel transmit.
- 01: 4 channel transmit.
- 10: 8 channel transmit.
- 11: 16 channel transmit. Note 1: For multi-channel transmit, only data line 0 (sd0) is used. Note 2: TX does not support time-division multiplexing mode.";
            sw = rw; hw = r;
            reset = 0x0;
        } tx_ch_num[5:4];
        field {
            name = "tx_i2s_precision";
            desc = "Data sampling precision configuration bits. I2S normal mode:
- 00: Reserved;
- 01: 16bit;
- 10: 24bit;
- 11: Reserved.

PCM normal mode:
- 00: 8bit;
- 01: 16bit;
Other values: reserved.";
            sw = rw; hw = r;
            reset = 0x1;
        } tx_i2s_precision[3:2];
        field {
            name = "tx_mode";
            desc = "Interface mode select of the transmit channel.
- 00: I2S mode.
- 01: PCM mode. Others: Reserved.";
            sw = rw; hw = r;
            reset = 0x0;
        } tx_mode[1:0];
    } TX_IF_ATTRI_1 @ 0x2100;
    reg {
        name = "TX_DSP_CTRL";
        desc = "TX_DSP_CTRL is the control register of the transmit processing channel. TX_DSP_CTRL (offset 0x2004+0x100xm (m = 0~1), total reset 0x2000_0000; PROVEN: Hi3535 data sheet, PDF page 1197, section 12.1.6).";
        field {
            name = "reserved";
            desc = "Reserved.";
            sw = rw; hw = r;
            reset = 0x0;
        } reserved_31_30[31:30];
        field {
            name = "tx_disable_done";
            desc = "Stop-complete flag of the transmit channel.
- 0: Not complete;
- 1: Complete.";
            sw = r; hw = w;
            reset = 0x1;
        } tx_disable_done[29:29];
        field {
            name = "tx_enable";
            desc = "Start/stop indication bit of the transmit channel.
- 0: Stopped.
- 1: Started.";
            sw = rw; hw = r;
            reset = 0x0;
        } tx_enable[28:28];
        field {
            name = "bypass_en";
            desc = "Processing bypass; the control functions remain in effect.
- 0: Bypass function off.
- 1: Bypass function on; functions such as volume control, trackmode, and fade in/out are bypassed.";
            sw = rw; hw = r;
            reset = 0x0;
        } bypass_en[27:27];
        field {
            name = "reserved";
            desc = "Reserved.";
            sw = rw; hw = r;
            reset = 0x0;
        } reserved_26_24[26:24];
        field {
            name = "fade_out_rate";
            desc = "- 0000: Changes once every 1 sample point;
- 0001: Changes once every 2 sample points;
- 0010: Changes once every 4 sample points;
- 0011: Changes once every 8 sample points;
- 0100: Changes once every 16 sample points;
- 0101: Changes once every 32 sample points;
- 0110: Changes once every 64 sample points;
- 0111: Changes once every 128 sample points; Others: Reserved.";
            sw = rw; hw = r;
            reset = 0x0;
        } fade_out_rate[23:20];
        field {
            name = "fade_in_rate";
            desc = "- 0000: Changes once every 1 sample point;
- 0001: Changes once every 2 sample points;
- 0010: Changes once every 4 sample points;
- 0011: Changes once every 8 sample points;
- 0100: Changes once every 16 sample points;
- 0101: Changes once every 32 sample points;
- 0110: Changes once every 64 sample points;
- 0111: Changes once every 128 sample points; Others: Reserved.";
            sw = rw; hw = r;
            reset = 0x0;
        } fade_in_rate[19:16];
        field {
            name = "reserved";
            desc = "Reserved.";
            sw = rw; hw = r;
            reset = 0x0;
        } reserved_15_15[15:15];
        field {
            name = "volume";
            desc = "Volume. 0x00 to 0x28: Mute;
- 0x29: -80dB;
......
- 0x7E: +5dB;
- 0x7F: +6dB.";
            sw = rw; hw = r;
            reset = 0x0;
        } volume[14:8];
        field {
            name = "reserved";
            desc = "Reserved. Intended for extending volume precision, for example as fractional dB control.";
            sw = rw; hw = r;
            reset = 0x0;
        } reserved_7_2[7:2];
        field {
            name = "mute_fade_en";
            desc = "Mute fade-in/fade-out control.
- 0: Fade-in/fade-out function off;
- 1: Fade-in/fade-out function on.";
            sw = rw; hw = r;
            reset = 0x0;
        } mute_fade_en[1:1];
        field {
            name = "mute_en";
            desc = "Mute control.
- 0: Mute released;
- 1: Mute enabled.";
            sw = rw; hw = r;
            reset = 0x0;
        } mute_en[0:0];
    } TX_DSP_CTRL_0 @ 0x2004;
    reg {
        name = "TX_DSP_CTRL";
        desc = "TX_DSP_CTRL is the control register of the transmit processing channel. TX_DSP_CTRL (offset 0x2004+0x100xm (m = 0~1), total reset 0x2000_0000; PROVEN: Hi3535 data sheet, PDF page 1197, section 12.1.6).";
        field {
            name = "reserved";
            desc = "Reserved.";
            sw = rw; hw = r;
            reset = 0x0;
        } reserved_31_30[31:30];
        field {
            name = "tx_disable_done";
            desc = "Stop-complete flag of the transmit channel.
- 0: Not complete;
- 1: Complete.";
            sw = r; hw = w;
            reset = 0x1;
        } tx_disable_done[29:29];
        field {
            name = "tx_enable";
            desc = "Start/stop indication bit of the transmit channel.
- 0: Stopped.
- 1: Started.";
            sw = rw; hw = r;
            reset = 0x0;
        } tx_enable[28:28];
        field {
            name = "bypass_en";
            desc = "Processing bypass; the control functions remain in effect.
- 0: Bypass function off.
- 1: Bypass function on; functions such as volume control, trackmode, and fade in/out are bypassed.";
            sw = rw; hw = r;
            reset = 0x0;
        } bypass_en[27:27];
        field {
            name = "reserved";
            desc = "Reserved.";
            sw = rw; hw = r;
            reset = 0x0;
        } reserved_26_24[26:24];
        field {
            name = "fade_out_rate";
            desc = "- 0000: Changes once every 1 sample point;
- 0001: Changes once every 2 sample points;
- 0010: Changes once every 4 sample points;
- 0011: Changes once every 8 sample points;
- 0100: Changes once every 16 sample points;
- 0101: Changes once every 32 sample points;
- 0110: Changes once every 64 sample points;
- 0111: Changes once every 128 sample points; Others: Reserved.";
            sw = rw; hw = r;
            reset = 0x0;
        } fade_out_rate[23:20];
        field {
            name = "fade_in_rate";
            desc = "- 0000: Changes once every 1 sample point;
- 0001: Changes once every 2 sample points;
- 0010: Changes once every 4 sample points;
- 0011: Changes once every 8 sample points;
- 0100: Changes once every 16 sample points;
- 0101: Changes once every 32 sample points;
- 0110: Changes once every 64 sample points;
- 0111: Changes once every 128 sample points; Others: Reserved.";
            sw = rw; hw = r;
            reset = 0x0;
        } fade_in_rate[19:16];
        field {
            name = "reserved";
            desc = "Reserved.";
            sw = rw; hw = r;
            reset = 0x0;
        } reserved_15_15[15:15];
        field {
            name = "volume";
            desc = "Volume. 0x00 to 0x28: Mute;
- 0x29: -80dB;
......
- 0x7E: +5dB;
- 0x7F: +6dB.";
            sw = rw; hw = r;
            reset = 0x0;
        } volume[14:8];
        field {
            name = "reserved";
            desc = "Reserved. Intended for extending volume precision, for example as fractional dB control.";
            sw = rw; hw = r;
            reset = 0x0;
        } reserved_7_2[7:2];
        field {
            name = "mute_fade_en";
            desc = "Mute fade-in/fade-out control.
- 0: Fade-in/fade-out function off;
- 1: Fade-in/fade-out function on.";
            sw = rw; hw = r;
            reset = 0x0;
        } mute_fade_en[1:1];
        field {
            name = "mute_en";
            desc = "Mute control.
- 0: Mute released;
- 1: Mute enabled.";
            sw = rw; hw = r;
            reset = 0x0;
        } mute_en[0:0];
    } TX_DSP_CTRL_1 @ 0x2104;
    reg {
        name = "TX_DSP_STATUS";
        desc = "TX_DSP_STATUS is the status register of the transmit processing channel. TX_DSP_STATUS (offset 0x2008+0x100xm (m = 0~1), total reset 0x4000_0079; PROVEN: Hi3535 data sheet, PDF page 1199, section 12.1.6).";
        field {
            name = "tx_enable";
            desc = "tx enable.
- 1: Enable;
- 0: Disable.";
            sw = r; hw = w;
            reset = 0x0;
        } tx_enable[31:31];
        field {
            name = "tx_axi_afifo_rd_aempty";
            desc = "The bus FIFO of the current path is almost empty.
- 1: Almost empty.
- 0: Not almost empty.";
            sw = r; hw = w;
            reset = 0x1;
        } tx_axi_afifo_rd_aempty[30:30];
        field {
            name = "tx_if_afifo_wr_full";
            desc = "The interface FIFO of the current path is full.
- 1: Full.
- 0: Not full.";
            sw = r; hw = w;
            reset = 0x0;
        } tx_if_afifo_wr_full[29:29];
        field {
            name = "proc_256bit_done";
            desc = "The current path has finished processing 256 bits.
- 1: Finished;
- 0: Not finished.";
            sw = r; hw = w;
            reset = 0x0;
        } proc_256bit_done[28:28];
        field {
            name = "if_fifo_wr_en";
            desc = "Write IF FIFO enable of the current path.
- 1: Yes;
- 0: No.";
            sw = r; hw = w;
            reset = 0x0;
        } if_fifo_wr_en[27:27];
        field {
            name = "tx_dsp_stop_done_req";
            desc = "DSP stop request of the current path.
- 1: Present;
- 0: None.";
            sw = r; hw = w;
            reset = 0x0;
        } tx_dsp_stop_done_req[26:26];
        field {
            name = "tx_rd_bus_fifo_cnt";
            desc = "Read bus FIFO counter, reads twice per read.";
            sw = r; hw = w;
            reset = 0x0;
        } tx_rd_bus_fifo_cnt[25:24];
        field {
            name = "state_clr_end";
            desc = "Status clear complete.
- 1: Complete;
- 0: Not complete.";
            sw = r; hw = w;
            reset = 0x0;
        } state_clr_end[23:23];
        field {
            name = "cur_fifo_id";
            desc = "ID of the channel currently being processed.";
            sw = r; hw = w;
            reset = 0x0;
        } cur_fifo_id[22:19];
        field {
            name = "cur_state";
            desc = "State machine state.";
            sw = r; hw = w;
            reset = 0x0;
        } cur_state[18:16];
        field {
            name = "reserved";
            desc = "Reserved.";
            sw = r; hw = w;
            reset = 0x0;
        } reserved_15_8[15:8];
        field {
            name = "tx_axi_afifo_rd_empty";
            desc = "Bus fifo of the current path empty.
- 0: Not empty;
- 1: Empty;";
            sw = r; hw = w;
            reset = 0x0;
        } tx_axi_afifo_rd_empty[7:7];
        field {
            name = "mute_fade_vol";
            desc = "Mute fade-in/fade-out volume. 0x00 to 0x28: Mute.
- 0x29: -80 dB. ...
- 0x7E: +5 dB.
- 0x7F: +6 dB.";
            sw = r; hw = w;
            reset = 0x79;
        } mute_fade_vol[6:0];
    } TX_DSP_STATUS_0 @ 0x2008;
    reg {
        name = "TX_DSP_STATUS";
        desc = "TX_DSP_STATUS is the status register of the transmit processing channel. TX_DSP_STATUS (offset 0x2008+0x100xm (m = 0~1), total reset 0x4000_0079; PROVEN: Hi3535 data sheet, PDF page 1199, section 12.1.6).";
        field {
            name = "tx_enable";
            desc = "tx enable.
- 1: Enable;
- 0: Disable.";
            sw = r; hw = w;
            reset = 0x0;
        } tx_enable[31:31];
        field {
            name = "tx_axi_afifo_rd_aempty";
            desc = "The bus FIFO of the current path is almost empty.
- 1: Almost empty.
- 0: Not almost empty.";
            sw = r; hw = w;
            reset = 0x1;
        } tx_axi_afifo_rd_aempty[30:30];
        field {
            name = "tx_if_afifo_wr_full";
            desc = "The interface FIFO of the current path is full.
- 1: Full.
- 0: Not full.";
            sw = r; hw = w;
            reset = 0x0;
        } tx_if_afifo_wr_full[29:29];
        field {
            name = "proc_256bit_done";
            desc = "The current path has finished processing 256 bits.
- 1: Finished;
- 0: Not finished.";
            sw = r; hw = w;
            reset = 0x0;
        } proc_256bit_done[28:28];
        field {
            name = "if_fifo_wr_en";
            desc = "Write IF FIFO enable of the current path.
- 1: Yes;
- 0: No.";
            sw = r; hw = w;
            reset = 0x0;
        } if_fifo_wr_en[27:27];
        field {
            name = "tx_dsp_stop_done_req";
            desc = "DSP stop request of the current path.
- 1: Present;
- 0: None.";
            sw = r; hw = w;
            reset = 0x0;
        } tx_dsp_stop_done_req[26:26];
        field {
            name = "tx_rd_bus_fifo_cnt";
            desc = "Read bus FIFO counter, reads twice per read.";
            sw = r; hw = w;
            reset = 0x0;
        } tx_rd_bus_fifo_cnt[25:24];
        field {
            name = "state_clr_end";
            desc = "Status clear complete.
- 1: Complete;
- 0: Not complete.";
            sw = r; hw = w;
            reset = 0x0;
        } state_clr_end[23:23];
        field {
            name = "cur_fifo_id";
            desc = "ID of the channel currently being processed.";
            sw = r; hw = w;
            reset = 0x0;
        } cur_fifo_id[22:19];
        field {
            name = "cur_state";
            desc = "State machine state.";
            sw = r; hw = w;
            reset = 0x0;
        } cur_state[18:16];
        field {
            name = "reserved";
            desc = "Reserved.";
            sw = r; hw = w;
            reset = 0x0;
        } reserved_15_8[15:8];
        field {
            name = "tx_axi_afifo_rd_empty";
            desc = "Bus fifo of the current path empty.
- 0: Not empty;
- 1: Empty;";
            sw = r; hw = w;
            reset = 0x0;
        } tx_axi_afifo_rd_empty[7:7];
        field {
            name = "mute_fade_vol";
            desc = "Mute fade-in/fade-out volume. 0x00 to 0x28: Mute.
- 0x29: -80 dB. ...
- 0x7E: +5 dB.
- 0x7F: +6 dB.";
            sw = r; hw = w;
            reset = 0x79;
        } mute_fade_vol[6:0];
    } TX_DSP_STATUS_1 @ 0x2108;
    reg {
        name = "TX_IF_STATUS";
        desc = "TX_IF_STATUS is the status register of the transmit control interface. TX_IF_STATUS (offset 0x200C+0x100xm (m = 0~1), total reset 0x0100_0060; PROVEN: Hi3535 data sheet, PDF page 1200, section 12.1.6).";
        field {
            name = "if_fifo_empty_cnt";
            desc = "Interface FIFO empty counter.";
            sw = r; hw = w;
            reset = 0x0;
        } if_fifo_empty_cnt[31:28];
        field {
            name = "reserved";
            desc = "Reserved.";
            sw = r; hw = w;
            reset = 0x0;
        } reserved_27_26[27:26];
        field {
            name = "i2s_tx_afifo_raddr";
            desc = "if fifo read address.";
            sw = r; hw = w;
            reset = 0x0;
        } i2s_tx_afifo_raddr[25:25];
        field {
            name = "i2s_tx_afifo_rd_aempty";
            desc = "IF FIFO read almost empty.";
            sw = r; hw = w;
            reset = 0x1;
        } i2s_tx_afifo_rd_aempty[24:24];
        field {
            name = "reserved";
            desc = "Reserved.";
            sw = r; hw = w;
            reset = 0x0;
        } reserved_23_18[23:18];
        field {
            name = "i2s_tx_afifo_waddr";
            desc = "if fifo write address.";
            sw = r; hw = w;
            reset = 0x0;
        } i2s_tx_afifo_waddr[17:17];
        field {
            name = "i2s_tx_afifo_wr_afull";
            desc = "if fifo write almost full.";
            sw = r; hw = w;
            reset = 0x0;
        } i2s_tx_afifo_wr_afull[16:16];
        field {
            name = "tx_bit_cnt";
            desc = "Transmit bit counter.";
            sw = r; hw = w;
            reset = 0x0;
        } tx_bit_cnt[15:8];
        field {
            name = "reserved";
            desc = "Reserved.";
            sw = r; hw = w;
            reset = 0x0;
        } reserved_7_7[7:7];
        field {
            name = "i2s_tx_ctrl_stop_done";
            desc = "if ctrl stop done.";
            sw = r; hw = w;
            reset = 0x1;
        } i2s_tx_ctrl_stop_done[6:6];
        field {
            name = "i2s_tx_afifo_rd_empty";
            desc = "if fifo empty.";
            sw = r; hw = w;
            reset = 0x1;
        } i2s_tx_afifo_rd_empty[5:5];
        field {
            name = "reserved";
            desc = "Reserved.";
            sw = r; hw = w;
            reset = 0x0;
        } reserved_4_3[4:3];
        field {
            name = "cur_state";
            desc = "State machine state of rx_if_ctrl.";
            sw = r; hw = w;
            reset = 0x0;
        } cur_state[2:0];
    } TX_IF_STATUS_0 @ 0x200c;
    reg {
        name = "TX_IF_STATUS";
        desc = "TX_IF_STATUS is the status register of the transmit control interface. TX_IF_STATUS (offset 0x200C+0x100xm (m = 0~1), total reset 0x0100_0060; PROVEN: Hi3535 data sheet, PDF page 1200, section 12.1.6).";
        field {
            name = "if_fifo_empty_cnt";
            desc = "Interface FIFO empty counter.";
            sw = r; hw = w;
            reset = 0x0;
        } if_fifo_empty_cnt[31:28];
        field {
            name = "reserved";
            desc = "Reserved.";
            sw = r; hw = w;
            reset = 0x0;
        } reserved_27_26[27:26];
        field {
            name = "i2s_tx_afifo_raddr";
            desc = "if fifo read address.";
            sw = r; hw = w;
            reset = 0x0;
        } i2s_tx_afifo_raddr[25:25];
        field {
            name = "i2s_tx_afifo_rd_aempty";
            desc = "IF FIFO read almost empty.";
            sw = r; hw = w;
            reset = 0x1;
        } i2s_tx_afifo_rd_aempty[24:24];
        field {
            name = "reserved";
            desc = "Reserved.";
            sw = r; hw = w;
            reset = 0x0;
        } reserved_23_18[23:18];
        field {
            name = "i2s_tx_afifo_waddr";
            desc = "if fifo write address.";
            sw = r; hw = w;
            reset = 0x0;
        } i2s_tx_afifo_waddr[17:17];
        field {
            name = "i2s_tx_afifo_wr_afull";
            desc = "if fifo write almost full.";
            sw = r; hw = w;
            reset = 0x0;
        } i2s_tx_afifo_wr_afull[16:16];
        field {
            name = "tx_bit_cnt";
            desc = "Transmit bit counter.";
            sw = r; hw = w;
            reset = 0x0;
        } tx_bit_cnt[15:8];
        field {
            name = "reserved";
            desc = "Reserved.";
            sw = r; hw = w;
            reset = 0x0;
        } reserved_7_7[7:7];
        field {
            name = "i2s_tx_ctrl_stop_done";
            desc = "if ctrl stop done.";
            sw = r; hw = w;
            reset = 0x1;
        } i2s_tx_ctrl_stop_done[6:6];
        field {
            name = "i2s_tx_afifo_rd_empty";
            desc = "if fifo empty.";
            sw = r; hw = w;
            reset = 0x1;
        } i2s_tx_afifo_rd_empty[5:5];
        field {
            name = "reserved";
            desc = "Reserved.";
            sw = r; hw = w;
            reset = 0x0;
        } reserved_4_3[4:3];
        field {
            name = "cur_state";
            desc = "State machine state of rx_if_ctrl.";
            sw = r; hw = w;
            reset = 0x0;
        } cur_state[2:0];
    } TX_IF_STATUS_1 @ 0x210c;
    reg {
        name = "TX_DMAR_STATUS";
        desc = "TX_DMAR_STATUS is the transmit DMAW status register. TX_DMAR_STATUS (offset 0x2010+0x100xm (m = 0~1), total reset 0x0000_0200; PROVEN: Hi3535 data sheet, PDF page 1201, section 12.1.6).";
        field {
            name = "reserved";
            desc = "Reserved.";
            sw = r; hw = w;
            reset = 0x0;
        } reserved_31_30[31:30];
        field {
            name = "tx_fifo_raddr";
            desc = "Read pointer of the bus FIFO.";
            sw = r; hw = w;
            reset = 0x0;
        } tx_fifo_raddr[29:24];
        field {
            name = "reserved";
            desc = "Reserved.";
            sw = r; hw = w;
            reset = 0x0;
        } reserved_23_22[23:22];
        field {
            name = "tx_fifo_waddr";
            desc = "Write pointer of the bus fifo.";
            sw = r; hw = w;
            reset = 0x0;
        } tx_fifo_waddr[21:16];
        field {
            name = "reserved";
            desc = "Reserved.";
            sw = r; hw = w;
            reset = 0x0;
        } reserved_15_15[15:15];
        field {
            name = "tx_fifo_full";
            desc = "bus fifo full.";
            sw = r; hw = w;
            reset = 0x0;
        } tx_fifo_full[14:14];
        field {
            name = "state_clr_end";
            desc = "Status clear completed.";
            sw = r; hw = w;
            reset = 0x0;
        } state_clr_end[13:13];
        field {
            name = "trans_finish_ind";
            desc = "One burst transfer completed.
- 0: Not completed;
- 1: Completed.";
            sw = r; hw = w;
            reset = 0x0;
        } trans_finish_ind[12:12];
        field {
            name = "vcmdready";
            desc = "Transfer command complete.
- 0: Not complete;
- 1: Complete.";
            sw = r; hw = w;
            reset = 0x0;
        } vcmdready[11:11];
        field {
            name = "vtrans";
            desc = "Transfer command start.";
            sw = r; hw = w;
            reset = 0x0;
        } vtrans[10:10];
        field {
            name = "tx_buf_empty";
            desc = "Buffer empty.";
            sw = r; hw = w;
            reset = 0x1;
        } tx_buf_empty[9:9];
        field {
            name = "tx_fifo_afull";
            desc = "Bus FIFO almost full.";
            sw = r; hw = w;
            reset = 0x0;
        } tx_fifo_afull[8:8];
        field {
            name = "reserved";
            desc = "Reserved.";
            sw = r; hw = w;
            reset = 0x0;
        } reserved_7_3[7:3];
        field {
            name = "cur_state";
            desc = "State machine state of dmar.";
            sw = r; hw = w;
            reset = 0x0;
        } cur_state[2:0];
    } TX_DMAR_STATUS_0 @ 0x2010;
    reg {
        name = "TX_DMAR_STATUS";
        desc = "TX_DMAR_STATUS is the transmit DMAW status register. TX_DMAR_STATUS (offset 0x2010+0x100xm (m = 0~1), total reset 0x0000_0200; PROVEN: Hi3535 data sheet, PDF page 1201, section 12.1.6).";
        field {
            name = "reserved";
            desc = "Reserved.";
            sw = r; hw = w;
            reset = 0x0;
        } reserved_31_30[31:30];
        field {
            name = "tx_fifo_raddr";
            desc = "Read pointer of the bus FIFO.";
            sw = r; hw = w;
            reset = 0x0;
        } tx_fifo_raddr[29:24];
        field {
            name = "reserved";
            desc = "Reserved.";
            sw = r; hw = w;
            reset = 0x0;
        } reserved_23_22[23:22];
        field {
            name = "tx_fifo_waddr";
            desc = "Write pointer of the bus fifo.";
            sw = r; hw = w;
            reset = 0x0;
        } tx_fifo_waddr[21:16];
        field {
            name = "reserved";
            desc = "Reserved.";
            sw = r; hw = w;
            reset = 0x0;
        } reserved_15_15[15:15];
        field {
            name = "tx_fifo_full";
            desc = "bus fifo full.";
            sw = r; hw = w;
            reset = 0x0;
        } tx_fifo_full[14:14];
        field {
            name = "state_clr_end";
            desc = "Status clear completed.";
            sw = r; hw = w;
            reset = 0x0;
        } state_clr_end[13:13];
        field {
            name = "trans_finish_ind";
            desc = "One burst transfer completed.
- 0: Not completed;
- 1: Completed.";
            sw = r; hw = w;
            reset = 0x0;
        } trans_finish_ind[12:12];
        field {
            name = "vcmdready";
            desc = "Transfer command complete.
- 0: Not complete;
- 1: Complete.";
            sw = r; hw = w;
            reset = 0x0;
        } vcmdready[11:11];
        field {
            name = "vtrans";
            desc = "Transfer command start.";
            sw = r; hw = w;
            reset = 0x0;
        } vtrans[10:10];
        field {
            name = "tx_buf_empty";
            desc = "Buffer empty.";
            sw = r; hw = w;
            reset = 0x1;
        } tx_buf_empty[9:9];
        field {
            name = "tx_fifo_afull";
            desc = "Bus FIFO almost full.";
            sw = r; hw = w;
            reset = 0x0;
        } tx_fifo_afull[8:8];
        field {
            name = "reserved";
            desc = "Reserved.";
            sw = r; hw = w;
            reset = 0x0;
        } reserved_7_3[7:3];
        field {
            name = "cur_state";
            desc = "State machine state of dmar.";
            sw = r; hw = w;
            reset = 0x0;
        } cur_state[2:0];
    } TX_DMAR_STATUS_1 @ 0x2110;
    reg {
        name = "TX_WS_CNT";
        desc = "TX_WS_CNT is the WS loop count status register of the transmit processing channel. TX_WS_CNT (offset 0x2020+0x100xm (m = 0~1), total reset 0x0000_0000; PROVEN: Hi3535 data sheet, PDF page 1202, section 12.1.6).";
        field {
            name = "reserved";
            desc = "Reserved.";
            sw = r; hw = w;
            reset = 0x0;
        } reserved_31_24[31:24];
        field {
            name = "ws_count";
            desc = "FSCLK cycle count register. Count unit: FSCLK.";
            sw = r; hw = w;
            reset = 0x0;
        } ws_count[23:0];
    } TX_WS_CNT_0 @ 0x2020;
    reg {
        name = "TX_WS_CNT";
        desc = "TX_WS_CNT is the WS loop count status register of the transmit processing channel. TX_WS_CNT (offset 0x2020+0x100xm (m = 0~1), total reset 0x0000_0000; PROVEN: Hi3535 data sheet, PDF page 1202, section 12.1.6).";
        field {
            name = "reserved";
            desc = "Reserved.";
            sw = r; hw = w;
            reset = 0x0;
        } reserved_31_24[31:24];
        field {
            name = "ws_count";
            desc = "FSCLK cycle count register. Count unit: FSCLK.";
            sw = r; hw = w;
            reset = 0x0;
        } ws_count[23:0];
    } TX_WS_CNT_1 @ 0x2120;
    reg {
        name = "TX_BCLK_CNT";
        desc = "TX_BCLK_CNT is the BCLK loop count status register of the transmit processing channel. TX_BCLK_CNT (offset 0x2024+0x100xm (m = 0~1), total reset 0x0000_0000; PROVEN: Hi3535 data sheet, PDF page 1203, section 12.1.6).";
        field {
            name = "reserved";
            desc = "Reserved.";
            sw = r; hw = w;
            reset = 0x0;
        } reserved_31_24[31:24];
        field {
            name = "bclk_count";
            desc = "BCLK cycle count register. Count unit: BCLK.";
            sw = r; hw = w;
            reset = 0x0;
        } bclk_count[23:0];
    } TX_BCLK_CNT_0 @ 0x2024;
    reg {
        name = "TX_BCLK_CNT";
        desc = "TX_BCLK_CNT is the BCLK loop count status register of the transmit processing channel. TX_BCLK_CNT (offset 0x2024+0x100xm (m = 0~1), total reset 0x0000_0000; PROVEN: Hi3535 data sheet, PDF page 1203, section 12.1.6).";
        field {
            name = "reserved";
            desc = "Reserved.";
            sw = r; hw = w;
            reset = 0x0;
        } reserved_31_24[31:24];
        field {
            name = "bclk_count";
            desc = "BCLK cycle count register. Count unit: BCLK.";
            sw = r; hw = w;
            reset = 0x0;
        } bclk_count[23:0];
    } TX_BCLK_CNT_1 @ 0x2124;
    reg {
        name = "TX_BUFF_SADDR";
        desc = "TX_BUFF_SADDR is the DDR buffer start address register of the transmit channel. TX_BUFF_SADDR (offset 0x2080+0x100xm (m = 0~1), total reset 0x0000_0000; PROVEN: Hi3535 data sheet, PDF page 1203, section 12.1.6).";
        field {
            name = "tx_buff_saddr";
            desc = "DDR buffer start address of the transmit channel, in bytes. Note: The DDR buffer start address must be aligned to 128 x 2 bits.";
            sw = rw; hw = r;
            reset = 0x0;
        } tx_buff_saddr[31:0];
    } TX_BUFF_SADDR_0 @ 0x2080;
    reg {
        name = "TX_BUFF_SADDR";
        desc = "TX_BUFF_SADDR is the DDR buffer start address register of the transmit channel. TX_BUFF_SADDR (offset 0x2080+0x100xm (m = 0~1), total reset 0x0000_0000; PROVEN: Hi3535 data sheet, PDF page 1203, section 12.1.6).";
        field {
            name = "tx_buff_saddr";
            desc = "DDR buffer start address of the transmit channel, in bytes. Note: The DDR buffer start address must be aligned to 128 x 2 bits.";
            sw = rw; hw = r;
            reset = 0x0;
        } tx_buff_saddr[31:0];
    } TX_BUFF_SADDR_1 @ 0x2180;
    reg {
        name = "TX_BUFF_SIZE";
        desc = "TX_BUFF_SIZE is the DDR buffer size register of the transmit channel. TX_BUFF_SIZE (offset 0x2084+0x100xm (m = 0~1), total reset 0x0000_0000; PROVEN: Hi3535 data sheet, PDF page 1204, section 12.1.6).";
        field {
            name = "reserved";
            desc = "Reserved.";
            sw = rw; hw = r;
            reset = 0x0;
        } reserved_31_24[31:24];
        field {
            name = "tx_buff_size";
            desc = "DDR buffer size of the transmit channel, in bytes. Note: tx_buff_size must be an integer multiple of 32 bytes.";
            sw = rw; hw = r;
            reset = 0x0;
        } tx_buff_size[23:0];
    } TX_BUFF_SIZE_0 @ 0x2084;
    reg {
        name = "TX_BUFF_SIZE";
        desc = "TX_BUFF_SIZE is the DDR buffer size register of the transmit channel. TX_BUFF_SIZE (offset 0x2084+0x100xm (m = 0~1), total reset 0x0000_0000; PROVEN: Hi3535 data sheet, PDF page 1204, section 12.1.6).";
        field {
            name = "reserved";
            desc = "Reserved.";
            sw = rw; hw = r;
            reset = 0x0;
        } reserved_31_24[31:24];
        field {
            name = "tx_buff_size";
            desc = "DDR buffer size of the transmit channel, in bytes. Note: tx_buff_size must be an integer multiple of 32 bytes.";
            sw = rw; hw = r;
            reset = 0x0;
        } tx_buff_size[23:0];
    } TX_BUFF_SIZE_1 @ 0x2184;
    reg {
        name = "TX_BUFF_WPTR";
        desc = "TX_BUFF_WPTR is the DDR buffer write address register of the transmit channel. TX_BUFF_WPTR (offset 0x2088+0x100xm (m = 0~1), total reset 0x0000_0000; PROVEN: Hi3535 data sheet, PDF page 1204, section 12.1.6).";
        field {
            name = "reserved";
            desc = "Reserved.";
            sw = rw; hw = r;
            reset = 0x0;
        } reserved_31_24[31:24];
        field {
            name = "tx_buff_wptr";
            desc = "DDR buffer write address of the transmit channel. Note 1: The write address in the transmit direction is maintained by software and is an offset relative to the DDR buffer start address. Note 2: Software must ensure that the free space of TX_BUF is not less than 32 bytes. Note 3: Software operates in bytes; the hardware internally operates with 32-byte alignment.";
            sw = rw; hw = r;
            reset = 0x0;
        } tx_buff_wptr[23:0];
    } TX_BUFF_WPTR_0 @ 0x2088;
    reg {
        name = "TX_BUFF_WPTR";
        desc = "TX_BUFF_WPTR is the DDR buffer write address register of the transmit channel. TX_BUFF_WPTR (offset 0x2088+0x100xm (m = 0~1), total reset 0x0000_0000; PROVEN: Hi3535 data sheet, PDF page 1204, section 12.1.6).";
        field {
            name = "reserved";
            desc = "Reserved.";
            sw = rw; hw = r;
            reset = 0x0;
        } reserved_31_24[31:24];
        field {
            name = "tx_buff_wptr";
            desc = "DDR buffer write address of the transmit channel. Note 1: The write address in the transmit direction is maintained by software and is an offset relative to the DDR buffer start address. Note 2: Software must ensure that the free space of TX_BUF is not less than 32 bytes. Note 3: Software operates in bytes; the hardware internally operates with 32-byte alignment.";
            sw = rw; hw = r;
            reset = 0x0;
        } tx_buff_wptr[23:0];
    } TX_BUFF_WPTR_1 @ 0x2188;
    reg {
        name = "TX_BUFF_RPTR";
        desc = "TX_BUFF_RPTR is the DDR buffer read address register of the transmit channel. TX_BUFF_RPTR (offset 0x208C+0x100xm (m = 0~1), total reset 0x0000_0000; PROVEN: Hi3535 data sheet, PDF page 1205, section 12.1.6).";
        field {
            name = "reserved";
            desc = "Reserved.";
            sw = rw; hw = r;
            reset = 0x0;
        } reserved_31_24[31:24];
        field {
            name = "tx_buff_rptr";
            desc = "DDR buffer read address of the transmit channel. Note: the read address in the transmit direction is maintained by logic and is an offset relative to the DDR buffer start address. Note: it must be aligned to 128 x 2 bits.";
            sw = rw; hw = r;
            reset = 0x0;
        } tx_buff_rptr[23:0];
    } TX_BUFF_RPTR_0 @ 0x208c;
    reg {
        name = "TX_BUFF_RPTR";
        desc = "TX_BUFF_RPTR is the DDR buffer read address register of the transmit channel. TX_BUFF_RPTR (offset 0x208C+0x100xm (m = 0~1), total reset 0x0000_0000; PROVEN: Hi3535 data sheet, PDF page 1205, section 12.1.6).";
        field {
            name = "reserved";
            desc = "Reserved.";
            sw = rw; hw = r;
            reset = 0x0;
        } reserved_31_24[31:24];
        field {
            name = "tx_buff_rptr";
            desc = "DDR buffer read address of the transmit channel. Note: the read address in the transmit direction is maintained by logic and is an offset relative to the DDR buffer start address. Note: it must be aligned to 128 x 2 bits.";
            sw = rw; hw = r;
            reset = 0x0;
        } tx_buff_rptr[23:0];
    } TX_BUFF_RPTR_1 @ 0x218c;
    reg {
        name = "TX_BUFF_ALEMPTY_TH";
        desc = "TX_BUFF_ALEMPTY_TH is the DDR buffer almost-empty watermark register of the transmit channel. TX_BUFF_ALEMPTY_TH (offset 0x2090+0x100xm (m = 0~1), total reset 0x0000_0000; PROVEN: Hi3535 data sheet, PDF page 1205, section 12.1.6).";
        field {
            name = "reserved";
            desc = "Reserved.";
            sw = rw; hw = r;
            reset = 0x0;
        } reserved_31_24[31:24];
        field {
            name = "tx_buff_alempty_th";
            desc = "Almost-empty watermark of the DDR buffer of the transmit channel, in bytes. When the readable space in the DDR buffer is less than the almost-empty watermark, an almost-empty raw interrupt is generated. Note: If the tx_alempty_int interrupt is used, tx_buff_alempty_th must be configured as an integer multiple of 16 bytes and must be greater than or equal to 0x20.";
            sw = rw; hw = r;
            reset = 0x0;
        } tx_buff_alempty_th[23:0];
    } TX_BUFF_ALEMPTY_TH_0 @ 0x2090;
    reg {
        name = "TX_BUFF_ALEMPTY_TH";
        desc = "TX_BUFF_ALEMPTY_TH is the DDR buffer almost-empty watermark register of the transmit channel. TX_BUFF_ALEMPTY_TH (offset 0x2090+0x100xm (m = 0~1), total reset 0x0000_0000; PROVEN: Hi3535 data sheet, PDF page 1205, section 12.1.6).";
        field {
            name = "reserved";
            desc = "Reserved.";
            sw = rw; hw = r;
            reset = 0x0;
        } reserved_31_24[31:24];
        field {
            name = "tx_buff_alempty_th";
            desc = "Almost-empty watermark of the DDR buffer of the transmit channel, in bytes. When the readable space in the DDR buffer is less than the almost-empty watermark, an almost-empty raw interrupt is generated. Note: If the tx_alempty_int interrupt is used, tx_buff_alempty_th must be configured as an integer multiple of 16 bytes and must be greater than or equal to 0x20.";
            sw = rw; hw = r;
            reset = 0x0;
        } tx_buff_alempty_th[23:0];
    } TX_BUFF_ALEMPTY_TH_1 @ 0x2190;
    reg {
        name = "TX_TRANS_SIZE";
        desc = "TX_TRANS_SIZE is the data transfer length register of the transmit channel. TX_TRANS_SIZE (offset 0x2094+0x100xm (m = 0~1), total reset 0x0000_0000; PROVEN: Hi3535 data sheet, PDF page 1206, section 12.1.6).";
        field {
            name = "reserved";
            desc = "Reserved.";
            sw = rw; hw = r;
            reset = 0x0;
        } reserved_31_24[31:24];
        field {
            name = "tx_trans_size";
            desc = "Transmit channel: when audio data of length tx_trans_size (in bytes) has been sent, a transfer done interrupt is generated.";
            sw = rw; hw = r;
            reset = 0x0;
        } tx_trans_size[23:0];
    } TX_TRANS_SIZE_0 @ 0x2094;
    reg {
        name = "TX_TRANS_SIZE";
        desc = "TX_TRANS_SIZE is the data transfer length register of the transmit channel. TX_TRANS_SIZE (offset 0x2094+0x100xm (m = 0~1), total reset 0x0000_0000; PROVEN: Hi3535 data sheet, PDF page 1206, section 12.1.6).";
        field {
            name = "reserved";
            desc = "Reserved.";
            sw = rw; hw = r;
            reset = 0x0;
        } reserved_31_24[31:24];
        field {
            name = "tx_trans_size";
            desc = "Transmit channel: when audio data of length tx_trans_size (in bytes) has been sent, a transfer done interrupt is generated.";
            sw = rw; hw = r;
            reset = 0x0;
        } tx_trans_size[23:0];
    } TX_TRANS_SIZE_1 @ 0x2194;
    reg {
        name = "TX_RPTR_TMP";
        desc = "TX_RPTR_TMP is the register that saves the read address of the transmit channel when the transfer completion interrupt is reported. TX_RPTR_TMP (offset 0x2098+0x100xm (m = 0~1), total reset 0x0000_0000; PROVEN: Hi3535 data sheet, PDF page 1206, section 12.1.6).";
        field {
            name = "reserved";
            desc = "Reserved.";
            sw = r; hw = w;
            reset = 0x0;
        } reserved_31_24[31:24];
        field {
            name = "tx_rptr_tmp";
            desc = "Holds the read address of the transmit channel, in bytes, when the transfer complete interrupt is reported.";
            sw = r; hw = w;
            reset = 0x0;
        } tx_rptr_tmp[23:0];
    } TX_RPTR_TMP_0 @ 0x2098;
    reg {
        name = "TX_RPTR_TMP";
        desc = "TX_RPTR_TMP is the register that saves the read address of the transmit channel when the transfer completion interrupt is reported. TX_RPTR_TMP (offset 0x2098+0x100xm (m = 0~1), total reset 0x0000_0000; PROVEN: Hi3535 data sheet, PDF page 1206, section 12.1.6).";
        field {
            name = "reserved";
            desc = "Reserved.";
            sw = r; hw = w;
            reset = 0x0;
        } reserved_31_24[31:24];
        field {
            name = "tx_rptr_tmp";
            desc = "Holds the read address of the transmit channel, in bytes, when the transfer complete interrupt is reported.";
            sw = r; hw = w;
            reset = 0x0;
        } tx_rptr_tmp[23:0];
    } TX_RPTR_TMP_1 @ 0x2198;
    reg {
        name = "TX_INT_ENA";
        desc = "TX_INT_ENA is the interrupt enable register of the transmit channel. TX_INT_ENA (offset 0x20A0+0x100xm (m = 0~1), total reset 0x0000_0000; PROVEN: Hi3535 data sheet, PDF page 1207, section 12.1.6).";
        field {
            name = "reserved";
            desc = "Reserved.";
            sw = rw; hw = r;
            reset = 0x0;
        } reserved_31_8[31:8];
        field {
            name = "tx_dat_break_int_ena";
            desc = "Interface data stream interruption interrupt enable of the transmit channel.
- 0: No raw interrupt;
- 1: Raw interrupt present.";
            sw = rw; hw = r;
            reset = 0x0;
        } tx_dat_break_int_ena[7:7];
        field {
            name = "tx_mfade_int_ena";
            desc = "Mute fade-in/fade-out completion interrupt enable of the transmit channel.
- 0: Disable;
- 1: Enable.";
            sw = rw; hw = r;
            reset = 0x0;
        } tx_mfade_int_ena[6:6];
        field {
            name = "tx_stop_int_ena";
            desc = "Stop interrupt enable of the transmit channel.
- 0: Disable.
- 1: Enable.";
            sw = rw; hw = r;
            reset = 0x0;
        } tx_stop_int_ena[5:5];
        field {
            name = "tx_ififo_empty_int_ena";
            desc = "Interface FIFO underflow interrupt enable of the transmit channel.
- 0: Disable;
- 1: Enable.";
            sw = rw; hw = r;
            reset = 0x0;
        } tx_ififo_empty_int_ena[4:4];
        field {
            name = "tx_bfifo_empty_int_ena";
            desc = "Bus FIFO underflow interrupt enable of the transmit channel.
- 0: Disable.
- 1: Enable.";
            sw = rw; hw = r;
            reset = 0x0;
        } tx_bfifo_empty_int_ena[3:3];
        field {
            name = "tx_alempty_int_ena";
            desc = "DDR buffer almost-empty interrupt enable of the transmit channel.
- 0: Disable;
- 1: Enable.";
            sw = rw; hw = r;
            reset = 0x0;
        } tx_alempty_int_ena[2:2];
        field {
            name = "tx_empty_int_ena";
            desc = "DDR buffer empty interrupt enable of the transmit channel.
- 0: Disable;
- 1: Enable.";
            sw = rw; hw = r;
            reset = 0x0;
        } tx_empty_int_ena[1:1];
        field {
            name = "tx_trans_int_ena";
            desc = "Transfer completion interrupt enable of the transmit channel.
- 0: Disable;
- 1: Enable.";
            sw = rw; hw = r;
            reset = 0x0;
        } tx_trans_int_ena[0:0];
    } TX_INT_ENA_0 @ 0x20a0;
    reg {
        name = "TX_INT_ENA";
        desc = "TX_INT_ENA is the interrupt enable register of the transmit channel. TX_INT_ENA (offset 0x20A0+0x100xm (m = 0~1), total reset 0x0000_0000; PROVEN: Hi3535 data sheet, PDF page 1207, section 12.1.6).";
        field {
            name = "reserved";
            desc = "Reserved.";
            sw = rw; hw = r;
            reset = 0x0;
        } reserved_31_8[31:8];
        field {
            name = "tx_dat_break_int_ena";
            desc = "Interface data stream interruption interrupt enable of the transmit channel.
- 0: No raw interrupt;
- 1: Raw interrupt present.";
            sw = rw; hw = r;
            reset = 0x0;
        } tx_dat_break_int_ena[7:7];
        field {
            name = "tx_mfade_int_ena";
            desc = "Mute fade-in/fade-out completion interrupt enable of the transmit channel.
- 0: Disable;
- 1: Enable.";
            sw = rw; hw = r;
            reset = 0x0;
        } tx_mfade_int_ena[6:6];
        field {
            name = "tx_stop_int_ena";
            desc = "Stop interrupt enable of the transmit channel.
- 0: Disable.
- 1: Enable.";
            sw = rw; hw = r;
            reset = 0x0;
        } tx_stop_int_ena[5:5];
        field {
            name = "tx_ififo_empty_int_ena";
            desc = "Interface FIFO underflow interrupt enable of the transmit channel.
- 0: Disable;
- 1: Enable.";
            sw = rw; hw = r;
            reset = 0x0;
        } tx_ififo_empty_int_ena[4:4];
        field {
            name = "tx_bfifo_empty_int_ena";
            desc = "Bus FIFO underflow interrupt enable of the transmit channel.
- 0: Disable.
- 1: Enable.";
            sw = rw; hw = r;
            reset = 0x0;
        } tx_bfifo_empty_int_ena[3:3];
        field {
            name = "tx_alempty_int_ena";
            desc = "DDR buffer almost-empty interrupt enable of the transmit channel.
- 0: Disable;
- 1: Enable.";
            sw = rw; hw = r;
            reset = 0x0;
        } tx_alempty_int_ena[2:2];
        field {
            name = "tx_empty_int_ena";
            desc = "DDR buffer empty interrupt enable of the transmit channel.
- 0: Disable;
- 1: Enable.";
            sw = rw; hw = r;
            reset = 0x0;
        } tx_empty_int_ena[1:1];
        field {
            name = "tx_trans_int_ena";
            desc = "Transfer completion interrupt enable of the transmit channel.
- 0: Disable;
- 1: Enable.";
            sw = rw; hw = r;
            reset = 0x0;
        } tx_trans_int_ena[0:0];
    } TX_INT_ENA_1 @ 0x21a0;
    reg {
        name = "TX_INT_RAW";
        desc = "TX_INT_RAW is the raw interrupt register of the transmit channel. TX_INT_RAW (offset 0x20A4+0x100xm (m = 0~1), total reset 0x0000_0000; PROVEN: Hi3535 data sheet, PDF page 1208, section 12.1.6).";
        field {
            name = "reserved";
            desc = "Reserved.";
            sw = r; hw = w;
            reset = 0x0;
        } reserved_31_8[31:8];
        field {
            name = "tx_dat_break_int_raw";
            desc = "Raw interrupt for interface data stream interruption of the transmit channel.
- 0: No raw interrupt.
- 1: Raw interrupt present.";
            sw = r; hw = w;
            reset = 0x0;
        } tx_dat_break_int_raw[7:7];
        field {
            name = "tx_mfade_int_raw";
            desc = "Raw interrupt of the transmit channel mute fade-in/fade-out complete.
- 0: No raw interrupt;
- 1: Raw interrupt present.";
            sw = r; hw = w;
            reset = 0x0;
        } tx_mfade_int_raw[6:6];
        field {
            name = "tx_stop_int_raw";
            desc = "Stop raw interrupt of the transmit channel.
- 0: No raw interrupt;
- 1: Raw interrupt present.";
            sw = r; hw = w;
            reset = 0x0;
        } tx_stop_int_raw[5:5];
        field {
            name = "tx_ififo_empty_int_raw";
            desc = "Interface fifo underflow raw interrupt of the transmit channel.
- 0: No raw interrupt;
- 1: Raw interrupt present.";
            sw = r; hw = w;
            reset = 0x0;
        } tx_ififo_empty_int_raw[4:4];
        field {
            name = "tx_bfifo_empty_int_raw";
            desc = "Raw interrupt of the transmit channel bus fifo underflow.
- 0: No raw interrupt;
- 1: Raw interrupt present.";
            sw = r; hw = w;
            reset = 0x0;
        } tx_bfifo_empty_int_raw[3:3];
        field {
            name = "tx_alempty_int_raw";
            desc = "DDR buffer almost-empty raw interrupt of the transmit channel.
- 0: No raw interrupt;
- 1: Raw interrupt present.";
            sw = r; hw = w;
            reset = 0x0;
        } tx_alempty_int_raw[2:2];
        field {
            name = "tx_empty_int_raw";
            desc = "DDR buffer empty raw interrupt of the transmit channel.
- 0: No raw interrupt;
- 1: Raw interrupt present.";
            sw = r; hw = w;
            reset = 0x0;
        } tx_empty_int_raw[1:1];
        field {
            name = "tx_trans_int_raw";
            desc = "Transfer completion raw interrupt of the transmit channel.
- 0: No raw interrupt.
- 1: Raw interrupt present.";
            sw = r; hw = w;
            reset = 0x0;
        } tx_trans_int_raw[0:0];
    } TX_INT_RAW_0 @ 0x20a4;
    reg {
        name = "TX_INT_RAW";
        desc = "TX_INT_RAW is the raw interrupt register of the transmit channel. TX_INT_RAW (offset 0x20A4+0x100xm (m = 0~1), total reset 0x0000_0000; PROVEN: Hi3535 data sheet, PDF page 1208, section 12.1.6).";
        field {
            name = "reserved";
            desc = "Reserved.";
            sw = r; hw = w;
            reset = 0x0;
        } reserved_31_8[31:8];
        field {
            name = "tx_dat_break_int_raw";
            desc = "Raw interrupt for interface data stream interruption of the transmit channel.
- 0: No raw interrupt.
- 1: Raw interrupt present.";
            sw = r; hw = w;
            reset = 0x0;
        } tx_dat_break_int_raw[7:7];
        field {
            name = "tx_mfade_int_raw";
            desc = "Raw interrupt of the transmit channel mute fade-in/fade-out complete.
- 0: No raw interrupt;
- 1: Raw interrupt present.";
            sw = r; hw = w;
            reset = 0x0;
        } tx_mfade_int_raw[6:6];
        field {
            name = "tx_stop_int_raw";
            desc = "Stop raw interrupt of the transmit channel.
- 0: No raw interrupt;
- 1: Raw interrupt present.";
            sw = r; hw = w;
            reset = 0x0;
        } tx_stop_int_raw[5:5];
        field {
            name = "tx_ififo_empty_int_raw";
            desc = "Interface fifo underflow raw interrupt of the transmit channel.
- 0: No raw interrupt;
- 1: Raw interrupt present.";
            sw = r; hw = w;
            reset = 0x0;
        } tx_ififo_empty_int_raw[4:4];
        field {
            name = "tx_bfifo_empty_int_raw";
            desc = "Raw interrupt of the transmit channel bus fifo underflow.
- 0: No raw interrupt;
- 1: Raw interrupt present.";
            sw = r; hw = w;
            reset = 0x0;
        } tx_bfifo_empty_int_raw[3:3];
        field {
            name = "tx_alempty_int_raw";
            desc = "DDR buffer almost-empty raw interrupt of the transmit channel.
- 0: No raw interrupt;
- 1: Raw interrupt present.";
            sw = r; hw = w;
            reset = 0x0;
        } tx_alempty_int_raw[2:2];
        field {
            name = "tx_empty_int_raw";
            desc = "DDR buffer empty raw interrupt of the transmit channel.
- 0: No raw interrupt;
- 1: Raw interrupt present.";
            sw = r; hw = w;
            reset = 0x0;
        } tx_empty_int_raw[1:1];
        field {
            name = "tx_trans_int_raw";
            desc = "Transfer completion raw interrupt of the transmit channel.
- 0: No raw interrupt.
- 1: Raw interrupt present.";
            sw = r; hw = w;
            reset = 0x0;
        } tx_trans_int_raw[0:0];
    } TX_INT_RAW_1 @ 0x21a4;
    reg {
        name = "TX_INT_STATUS";
        desc = "TX_INT_STATUS is the interrupt status register of the transmit channel. TX_INT_STATUS (offset 0x20A8+0x100xm (m = 0~1), total reset 0x0000_0000; PROVEN: Hi3535 data sheet, PDF page 1209, section 12.1.6).";
        field {
            name = "reserved";
            desc = "Reserved.";
            sw = r; hw = w;
            reset = 0x0;
        } reserved_31_8[31:8];
        field {
            name = "tx_dat_break_int_status";
            desc = "Interrupt status of the transmit channel interface data underrun.
- 0: No interrupt status;
- 1: Interrupt status present.";
            sw = r; hw = w;
            reset = 0x0;
        } tx_dat_break_int_status[7:7];
        field {
            name = "tx_mfade_int_status";
            desc = "Mute fade-in/fade-out complete interrupt status of the transmit channel.
- 0: No interrupt status;
- 1: Interrupt status present.";
            sw = r; hw = w;
            reset = 0x0;
        } tx_mfade_int_status[6:6];
        field {
            name = "tx_stop_int_status";
            desc = "Stop interrupt status of the transmit channel.
- 0: No interrupt status;
- 1: Interrupt status present.";
            sw = r; hw = w;
            reset = 0x0;
        } tx_stop_int_status[5:5];
        field {
            name = "tx_ififo_empty_int_status";
            desc = "Interface FIFO underflow interrupt status of the transmit channel.
- 0: No interrupt status.
- 1: Interrupt status present.";
            sw = r; hw = w;
            reset = 0x0;
        } tx_ififo_empty_int_status[4:4];
        field {
            name = "tx_bfifo_empty_int_status";
            desc = "Bus fifo underflow interrupt status of the transmit channel.
- 0: No interrupt status;
- 1: Interrupt status present.";
            sw = r; hw = w;
            reset = 0x0;
        } tx_bfifo_empty_int_status[3:3];
        field {
            name = "tx_alempty_int_status";
            desc = "DDR buffer almost-empty interrupt status of the transmit channel.
- 0: No interrupt status;
- 1: Interrupt status present.";
            sw = r; hw = w;
            reset = 0x0;
        } tx_alempty_int_status[2:2];
        field {
            name = "tx_empty_int_status";
            desc = "DDR buffer empty interrupt status of the transmit channel.
- 0: No interrupt status;
- 1: Interrupt status present.";
            sw = r; hw = w;
            reset = 0x0;
        } tx_empty_int_status[1:1];
        field {
            name = "tx_trans_int_status";
            desc = "Transfer completion interrupt status of the transmit channel.
- 0: No interrupt status;
- 1: Interrupt status present.";
            sw = r; hw = w;
            reset = 0x0;
        } tx_trans_int_status[0:0];
    } TX_INT_STATUS_0 @ 0x20a8;
    reg {
        name = "TX_INT_STATUS";
        desc = "TX_INT_STATUS is the interrupt status register of the transmit channel. TX_INT_STATUS (offset 0x20A8+0x100xm (m = 0~1), total reset 0x0000_0000; PROVEN: Hi3535 data sheet, PDF page 1209, section 12.1.6).";
        field {
            name = "reserved";
            desc = "Reserved.";
            sw = r; hw = w;
            reset = 0x0;
        } reserved_31_8[31:8];
        field {
            name = "tx_dat_break_int_status";
            desc = "Interrupt status of the transmit channel interface data underrun.
- 0: No interrupt status;
- 1: Interrupt status present.";
            sw = r; hw = w;
            reset = 0x0;
        } tx_dat_break_int_status[7:7];
        field {
            name = "tx_mfade_int_status";
            desc = "Mute fade-in/fade-out complete interrupt status of the transmit channel.
- 0: No interrupt status;
- 1: Interrupt status present.";
            sw = r; hw = w;
            reset = 0x0;
        } tx_mfade_int_status[6:6];
        field {
            name = "tx_stop_int_status";
            desc = "Stop interrupt status of the transmit channel.
- 0: No interrupt status;
- 1: Interrupt status present.";
            sw = r; hw = w;
            reset = 0x0;
        } tx_stop_int_status[5:5];
        field {
            name = "tx_ififo_empty_int_status";
            desc = "Interface FIFO underflow interrupt status of the transmit channel.
- 0: No interrupt status.
- 1: Interrupt status present.";
            sw = r; hw = w;
            reset = 0x0;
        } tx_ififo_empty_int_status[4:4];
        field {
            name = "tx_bfifo_empty_int_status";
            desc = "Bus fifo underflow interrupt status of the transmit channel.
- 0: No interrupt status;
- 1: Interrupt status present.";
            sw = r; hw = w;
            reset = 0x0;
        } tx_bfifo_empty_int_status[3:3];
        field {
            name = "tx_alempty_int_status";
            desc = "DDR buffer almost-empty interrupt status of the transmit channel.
- 0: No interrupt status;
- 1: Interrupt status present.";
            sw = r; hw = w;
            reset = 0x0;
        } tx_alempty_int_status[2:2];
        field {
            name = "tx_empty_int_status";
            desc = "DDR buffer empty interrupt status of the transmit channel.
- 0: No interrupt status;
- 1: Interrupt status present.";
            sw = r; hw = w;
            reset = 0x0;
        } tx_empty_int_status[1:1];
        field {
            name = "tx_trans_int_status";
            desc = "Transfer completion interrupt status of the transmit channel.
- 0: No interrupt status;
- 1: Interrupt status present.";
            sw = r; hw = w;
            reset = 0x0;
        } tx_trans_int_status[0:0];
    } TX_INT_STATUS_1 @ 0x21a8;
    reg {
        name = "TX_INT_CLR";
        desc = "TX_INT_CLR is the interrupt clear register of the transmit channel. TX_INT_CLR (offset 0x20AC+0x100xm (m = 0~1), total reset 0x0000_0000; PROVEN: Hi3535 data sheet, PDF page 1211, section 12.1.6).";
        field {
            name = "reserved";
            desc = "Reserved.";
            sw = r; hw = w;
            reset = 0x0;
        } reserved_31_8[31:8];
        field {
            name = "tx_dat_break_int_clear";
            desc = "Interface data stream break interrupt clear of the transmit channel.
- 0: No raw interrupt;
- 1: Raw interrupt present. (data sheet access type WC)";
            sw = rw; hw = r; onwrite = woclr;
            reset = 0x0;
        } tx_dat_break_int_clear[7:7];
        field {
            name = "tx_mfade_int_clear";
            desc = "Mute fade-in/fade-out completion interrupt clear of the transmit channel.
- 0: Do not clear;
- 1: Clear the stop interrupt. (data sheet access type WC)";
            sw = rw; hw = r; onwrite = woclr;
            reset = 0x0;
        } tx_mfade_int_clear[6:6];
        field {
            name = "tx_stop_int_clear";
            desc = "Stop interrupt clear of the transmit channel.
- 0: Do not clear;
- 1: Clear the stop interrupt. (data sheet access type WC)";
            sw = rw; hw = r; onwrite = woclr;
            reset = 0x0;
        } tx_stop_int_clear[5:5];
        field {
            name = "tx_ififo_empty_int_clear";
            desc = "Interface FIFO underflow interrupt clear of the transmit channel.
- 0: Do not clear.
- 1: Clear the FIFO underflow interrupt. (data sheet access type WC)";
            sw = rw; hw = r; onwrite = woclr;
            reset = 0x0;
        } tx_ififo_empty_int_clear[4:4];
        field {
            name = "tx_bfifo_empty_int_clear";
            desc = "Bus fifo underflow interrupt clear of the transmit channel.
- 0: Do not clear;
- 1: Clear the fifo underflow interrupt. (data sheet access type WC)";
            sw = rw; hw = r; onwrite = woclr;
            reset = 0x0;
        } tx_bfifo_empty_int_clear[3:3];
        field {
            name = "tx_alempty_int_clear";
            desc = "Transmit channel DDR buffer almost-empty interrupt clear.
- 0: Do not clear;
- 1: Clear the DDR buffer almost-empty interrupt. (data sheet access type WC)";
            sw = rw; hw = r; onwrite = woclr;
            reset = 0x0;
        } tx_alempty_int_clear[2:2];
        field {
            name = "tx_empty_int_clear";
            desc = "DDR buffer empty interrupt clear of the transmit channel.
- 0: Do not clear;
- 1: Clear the DDR buffer empty interrupt. (data sheet access type WC)";
            sw = rw; hw = r; onwrite = woclr;
            reset = 0x0;
        } tx_empty_int_clear[1:1];
        field {
            name = "tx_trans_int_clear";
            desc = "Transfer complete interrupt clear of the transmit channel.
- 0: Do not clear;
- 1: Clear the transfer complete interrupt. (data sheet access type WC)";
            sw = rw; hw = r; onwrite = woclr;
            reset = 0x0;
        } tx_trans_int_clear[0:0];
    } TX_INT_CLR_0 @ 0x20ac;
    reg {
        name = "TX_INT_CLR";
        desc = "TX_INT_CLR is the interrupt clear register of the transmit channel. TX_INT_CLR (offset 0x20AC+0x100xm (m = 0~1), total reset 0x0000_0000; PROVEN: Hi3535 data sheet, PDF page 1211, section 12.1.6).";
        field {
            name = "reserved";
            desc = "Reserved.";
            sw = r; hw = w;
            reset = 0x0;
        } reserved_31_8[31:8];
        field {
            name = "tx_dat_break_int_clear";
            desc = "Interface data stream break interrupt clear of the transmit channel.
- 0: No raw interrupt;
- 1: Raw interrupt present. (data sheet access type WC)";
            sw = rw; hw = r; onwrite = woclr;
            reset = 0x0;
        } tx_dat_break_int_clear[7:7];
        field {
            name = "tx_mfade_int_clear";
            desc = "Mute fade-in/fade-out completion interrupt clear of the transmit channel.
- 0: Do not clear;
- 1: Clear the stop interrupt. (data sheet access type WC)";
            sw = rw; hw = r; onwrite = woclr;
            reset = 0x0;
        } tx_mfade_int_clear[6:6];
        field {
            name = "tx_stop_int_clear";
            desc = "Stop interrupt clear of the transmit channel.
- 0: Do not clear;
- 1: Clear the stop interrupt. (data sheet access type WC)";
            sw = rw; hw = r; onwrite = woclr;
            reset = 0x0;
        } tx_stop_int_clear[5:5];
        field {
            name = "tx_ififo_empty_int_clear";
            desc = "Interface FIFO underflow interrupt clear of the transmit channel.
- 0: Do not clear.
- 1: Clear the FIFO underflow interrupt. (data sheet access type WC)";
            sw = rw; hw = r; onwrite = woclr;
            reset = 0x0;
        } tx_ififo_empty_int_clear[4:4];
        field {
            name = "tx_bfifo_empty_int_clear";
            desc = "Bus fifo underflow interrupt clear of the transmit channel.
- 0: Do not clear;
- 1: Clear the fifo underflow interrupt. (data sheet access type WC)";
            sw = rw; hw = r; onwrite = woclr;
            reset = 0x0;
        } tx_bfifo_empty_int_clear[3:3];
        field {
            name = "tx_alempty_int_clear";
            desc = "Transmit channel DDR buffer almost-empty interrupt clear.
- 0: Do not clear;
- 1: Clear the DDR buffer almost-empty interrupt. (data sheet access type WC)";
            sw = rw; hw = r; onwrite = woclr;
            reset = 0x0;
        } tx_alempty_int_clear[2:2];
        field {
            name = "tx_empty_int_clear";
            desc = "DDR buffer empty interrupt clear of the transmit channel.
- 0: Do not clear;
- 1: Clear the DDR buffer empty interrupt. (data sheet access type WC)";
            sw = rw; hw = r; onwrite = woclr;
            reset = 0x0;
        } tx_empty_int_clear[1:1];
        field {
            name = "tx_trans_int_clear";
            desc = "Transfer complete interrupt clear of the transmit channel.
- 0: Do not clear;
- 1: Clear the transfer complete interrupt. (data sheet access type WC)";
            sw = rw; hw = r; onwrite = woclr;
            reset = 0x0;
        } tx_trans_int_clear[0:0];
    } TX_INT_CLR_1 @ 0x21ac;
};

`endif
