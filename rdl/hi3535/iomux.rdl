`ifndef EHI3535_IOMUX_RDL
`define EHI3535_IOMUX_RDL
regfile eHI3535_IOMUX {
    name = "Pin multiplexing registers (muxctrl_reg)";
    desc = "Pin multiplexing registers (muxctrl_reg). 102 registers extracted programmatically from the Hi3535 H.264 codec processor (Hi3535 user guide) data sheet (Issue 00B08, 2014-02-25); chapter 2.3.2, table 2-33. Field names, bit ranges, access types and reset values are taken from the register tables; reset values are the data sheet total reset values split onto the fields (per-field values where the table has them). Label: PROVEN. Hardware not verified here (no board).";
    reg {
        name = "muxctrl_reg0";
        desc = "VGA_HS pin multiplexing control register. muxctrl_reg0 (offset 0x000, total reset 0x00000000; PROVEN: Hi3535 data sheet, PDF page 87, section 2.3.2).";
        field {
            name = "muxctrl_reg0";
            desc = "Pin multiplexing of VGA_HS.
- 0: VGA_HS;
- 1: GPIO6_6.";
            sw = rw; hw = r;
            reset = 0x0;
        } muxctrl_reg0[0:0];
    } muxctrl_reg0 @ 0x0;
    reg {
        name = "muxctrl_reg1";
        desc = "VGA_VS pin multiplexing control register. muxctrl_reg1 (offset 0x004, total reset 0x00000000; PROVEN: Hi3535 data sheet, PDF page 88, section 2.3.2).";
        field {
            name = "muxctrl_reg1";
            desc = "Pin multiplexing of VGA_VS.
- 0: VGA_VS;
- 1: GPIO6_7.";
            sw = rw; hw = r;
            reset = 0x0;
        } muxctrl_reg1[0:0];
    } muxctrl_reg1 @ 0x4;
    reg {
        name = "muxctrl_reg2";
        desc = "RGMII0_RXDV pin multiplexing control register. muxctrl_reg2 (offset 0x008, total reset 0x00000000; PROVEN: Hi3535 data sheet, PDF page 88, section 2.3.2).";
        field {
            name = "muxctrl_reg2";
            desc = "Pin multiplexing of RGMII0_RXDV.
- 0: RGMII0_RXDV;
- 1: GPIO8_7.";
            sw = rw; hw = r;
            reset = 0x0;
        } muxctrl_reg2[0:0];
    } muxctrl_reg2 @ 0x8;
    reg {
        name = "muxctrl_reg3";
        desc = "RGMII0_RXD0 pin multiplexing control register. muxctrl_reg3 (offset 0x00C, total reset 0x00000000; PROVEN: Hi3535 data sheet, PDF page 89, section 2.3.2).";
        field {
            name = "muxctrl_reg3";
            desc = "Pin multiplexing of RGMII0_RXD0.
- 0: RGMII0_RXD0;
- 1: GPIO9_0.";
            sw = rw; hw = r;
            reset = 0x0;
        } muxctrl_reg3[0:0];
    } muxctrl_reg3 @ 0xc;
    reg {
        name = "muxctrl_reg4";
        desc = "RGMII0_RXD1 pin multiplexing control register. muxctrl_reg4 (offset 0x010, total reset 0x00000000; PROVEN: Hi3535 data sheet, PDF page 89, section 2.3.2).";
        field {
            name = "muxctrl_reg4";
            desc = "Pin multiplexing of RGMII0_RXD1.
- 0: RGMII0_RXD1;
- 1: GPIO9_1.";
            sw = rw; hw = r;
            reset = 0x0;
        } muxctrl_reg4[0:0];
    } muxctrl_reg4 @ 0x10;
    reg {
        name = "muxctrl_reg5";
        desc = "RGMII0_RXD2 pin multiplexing control register. muxctrl_reg5 (offset 0x014, total reset 0x00000000; PROVEN: Hi3535 data sheet, PDF page 90, section 2.3.2).";
        field {
            name = "muxctrl_reg5";
            desc = "Pin multiplexing of the RGMII0_RXD2 pin.
- 0: RGMII0_RXD2.
- 1: GPIO9_2.";
            sw = rw; hw = r;
            reset = 0x0;
        } muxctrl_reg5[0:0];
    } muxctrl_reg5 @ 0x14;
    reg {
        name = "muxctrl_reg6";
        desc = "RGMII0_RXD3 pin multiplexing control register. muxctrl_reg6 (offset 0x018, total reset 0x00000000; PROVEN: Hi3535 data sheet, PDF page 90, section 2.3.2).";
        field {
            name = "muxctrl_reg6";
            desc = "Pin multiplexing of RGMII0_RXD3.
- 0: RGMII0_RXD3;
- 1: GPIO9_3.";
            sw = rw; hw = r;
            reset = 0x0;
        } muxctrl_reg6[0:0];
    } muxctrl_reg6 @ 0x18;
    reg {
        name = "muxctrl_reg7";
        desc = "RGMII0_TXD0 pin multiplexing control register. muxctrl_reg7 (offset 0x01C, total reset 0x00000000; PROVEN: Hi3535 data sheet, PDF page 91, section 2.3.2).";
        field {
            name = "muxctrl_reg7";
            desc = "Pin multiplexing of the RGMII0_TXD0 pin.
- 0: RGMII0_TXD0.
- 1: GPIO9_4.";
            sw = rw; hw = r;
            reset = 0x0;
        } muxctrl_reg7[0:0];
    } muxctrl_reg7 @ 0x1c;
    reg {
        name = "muxctrl_reg8";
        desc = "RGMII0_TXD1 pin multiplexing control register. muxctrl_reg8 (offset 0x020, total reset 0x00000000; PROVEN: Hi3535 data sheet, PDF page 91, section 2.3.2).";
        field {
            name = "muxctrl_reg8";
            desc = "Specific multiplexing of the RGMII0_TXD1 pin.
- 0: RGMII0_TXD1;
- 1: GPIO9_5.";
            sw = rw; hw = r;
            reset = 0x0;
        } muxctrl_reg8[0:0];
    } muxctrl_reg8 @ 0x20;
    reg {
        name = "muxctrl_reg9";
        desc = "RGMII0_TXD2 pin multiplexing control register. muxctrl_reg9 (offset 0x024, total reset 0x00000000; PROVEN: Hi3535 data sheet, PDF page 92, section 2.3.2).";
        field {
            name = "muxctrl_reg9";
            desc = "Pin multiplexing of the RGMII0_TXD2 pin.
- 0: RGMII0_TXD2.
- 1: GPIO9_6.";
            sw = rw; hw = r;
            reset = 0x0;
        } muxctrl_reg9[0:0];
    } muxctrl_reg9 @ 0x24;
    reg {
        name = "muxctrl_reg10";
        desc = "RGMII0_TXD3 pin multiplexing control register. muxctrl_reg10 (offset 0x028, total reset 0x00000000; PROVEN: Hi3535 data sheet, PDF page 92, section 2.3.2).";
        field {
            name = "muxctrl_reg10";
            desc = "Pin multiplexing of RGMII0_TXD3.
- 0: RGMII0_TXD3;
- 1: GPIO9_7.";
            sw = rw; hw = r;
            reset = 0x0;
        } muxctrl_reg10[0:0];
    } muxctrl_reg10 @ 0x28;
    reg {
        name = "muxctrl_reg11";
        desc = "RGMII0_RXCK pin multiplexing control register. muxctrl_reg11 (offset 0x02C, total reset 0x00000000; PROVEN: Hi3535 data sheet, PDF page 93, section 2.3.2).";
        field {
            name = "muxctrl_reg11";
            desc = "Pin multiplexing of the RGMII0_RXCK pin.
- 0: RGMII0_RXCK.
- 1: GPIO8_0.";
            sw = rw; hw = r;
            reset = 0x0;
        } muxctrl_reg11[0:0];
    } muxctrl_reg11 @ 0x2c;
    reg {
        name = "muxctrl_reg12";
        desc = "RGMII0_TXEN pin multiplexing control register. muxctrl_reg12 (offset 0x030, total reset 0x00000000; PROVEN: Hi3535 data sheet, PDF page 93, section 2.3.2).";
        field {
            name = "muxctrl_reg12";
            desc = "Pin multiplexing of RGMII0_TXEN.
- 0: RGMII0_TXEN;
- 1: GPIO8_1.";
            sw = rw; hw = r;
            reset = 0x0;
        } muxctrl_reg12[0:0];
    } muxctrl_reg12 @ 0x30;
    reg {
        name = "muxctrl_reg13";
        desc = "RGMII0_TXCK pin multiplexing control register. muxctrl_reg13 (offset 0x034, total reset 0x00000000; PROVEN: Hi3535 data sheet, PDF page 94, section 2.3.2).";
        field {
            name = "muxctrl_reg13";
            desc = "Pin multiplexing of RGMII0_TXCK.
- 0: RGMII0_TXCK;
- 1: GPIO8_2.";
            sw = rw; hw = r;
            reset = 0x0;
        } muxctrl_reg13[0:0];
    } muxctrl_reg13 @ 0x34;
    reg {
        name = "muxctrl_reg14";
        desc = "RGMII0_TXCKOUT pin multiplexing control register. muxctrl_reg14 (offset 0x038, total reset 0x00000000; PROVEN: Hi3535 data sheet, PDF page 94, section 2.3.2).";
        field {
            name = "muxctrl_reg14";
            desc = "Pin multiplexing of RGMII0_TXCKOUT.
- 00: RGMII0_TXCKOUT;
- 01: GPIO8_3;
- 10: RMII0_CLK;
Other values: reserved.";
            sw = rw; hw = r;
            reset = 0x0;
        } muxctrl_reg14[1:0];
    } muxctrl_reg14 @ 0x38;
    reg {
        name = "muxctrl_reg15";
        desc = "RGMII0_CRS pin multiplexing control register. muxctrl_reg15 (offset 0x03C, total reset 0x00000000; PROVEN: Hi3535 data sheet, PDF page 95, section 2.3.2).";
        field {
            name = "muxctrl_reg15";
            desc = "Pin multiplexing of RGMII0_CRS.
- 0: RGMII0_CRS;
- 1: GPIO8_4.";
            sw = rw; hw = r;
            reset = 0x0;
        } muxctrl_reg15[0:0];
    } muxctrl_reg15 @ 0x3c;
    reg {
        name = "muxctrl_reg16";
        desc = "RGMII0_COL pin multiplexing control register. muxctrl_reg16 (offset 0x040, total reset 0x00000000; PROVEN: Hi3535 data sheet, PDF page 95, section 2.3.2).";
        field {
            name = "muxctrl_reg16";
            desc = "Pin multiplexing of the RGMII0_COL pin.
- 0: RGMII0_COL.
- 1: GPIO8_5.";
            sw = rw; hw = r;
            reset = 0x0;
        } muxctrl_reg16[0:0];
    } muxctrl_reg16 @ 0x40;
    reg {
        name = "muxctrl_reg17";
        desc = "RGMII0_RXER pin multiplexing control register. muxctrl_reg17 (offset 0x044, total reset 0x00000000; PROVEN: Hi3535 data sheet, PDF page 96, section 2.3.2).";
        field {
            name = "muxctrl_reg17";
            desc = "Pin multiplexing of the RGMII0_RXER pin.
- 0: RGMII0_RXER.
- 1: GPIO8_6.";
            sw = rw; hw = r;
            reset = 0x0;
        } muxctrl_reg17[0:0];
    } muxctrl_reg17 @ 0x44;
    reg {
        name = "muxctrl_reg18";
        desc = "RGMII1_RXDV pin multiplexing control register. muxctrl_reg18 (offset 0x048, total reset 0x00000000; PROVEN: Hi3535 data sheet, PDF page 96, section 2.3.2).";
        field {
            name = "muxctrl_reg18";
            desc = "Specific multiplexing of the RGMII1_RXDV pin.
- 0: RGMII1_RXDV.
- 1: GPIO10_7.";
            sw = rw; hw = r;
            reset = 0x0;
        } muxctrl_reg18[0:0];
    } muxctrl_reg18 @ 0x48;
    reg {
        name = "muxctrl_reg19";
        desc = "RGMII1_RXD0 pin multiplexing control register. muxctrl_reg19 (offset 0x04C, total reset 0x00000000; PROVEN: Hi3535 data sheet, PDF page 97, section 2.3.2).";
        field {
            name = "muxctrl_reg19";
            desc = "Specific multiplexing of the RGMII1_RXD0 pin.
- 00: RGMII1_RXD0.
- 01: GPIO2_0.
- 10: DDRPHY_DEBUG_OUT4. Others: Reserved.";
            sw = rw; hw = r;
            reset = 0x0;
        } muxctrl_reg19[1:0];
    } muxctrl_reg19 @ 0x4c;
    reg {
        name = "muxctrl_reg20";
        desc = "RGMII1_RXD1 pin multiplexing control register. muxctrl_reg20 (offset 0x050, total reset 0x00000000; PROVEN: Hi3535 data sheet, PDF page 97, section 2.3.2).";
        field {
            name = "muxctrl_reg20";
            desc = "Pin multiplexing of RGMII1_RXD1.
- 00: RGMII1_RXD1;
- 01: GPIO2_1;
- 10: DDRPHY_DEBUG_OUT5; Others: Reserved.";
            sw = rw; hw = r;
            reset = 0x0;
        } muxctrl_reg20[1:0];
    } muxctrl_reg20 @ 0x50;
    reg {
        name = "muxctrl_reg21";
        desc = "RGMII1_RXD2 pin multiplexing control register. muxctrl_reg21 (offset 0x054, total reset 0x00000000; PROVEN: Hi3535 data sheet, PDF page 98, section 2.3.2).";
        field {
            name = "muxctrl_reg21";
            desc = "Pin multiplexing of RGMII1_RXD2.
- 00: RGMII1_RXD2;
- 01: GPIO2_2;
- 10: DDRPHY_DEBUG_OUT6;
Other values: reserved.";
            sw = rw; hw = r;
            reset = 0x0;
        } muxctrl_reg21[1:0];
    } muxctrl_reg21 @ 0x54;
    reg {
        name = "muxctrl_reg22";
        desc = "RGMII1_RXD3 pin multiplexing control register. muxctrl_reg22 (offset 0x058, total reset 0x00000000; PROVEN: Hi3535 data sheet, PDF page 98, section 2.3.2).";
        field {
            name = "muxctrl_reg22";
            desc = "Pin multiplexing of the RGMII1_RXD3 pin.
- 0: RGMII1_RXD3.
- 1: GPIO2_3.";
            sw = rw; hw = r;
            reset = 0x0;
        } muxctrl_reg22[0:0];
    } muxctrl_reg22 @ 0x58;
    reg {
        name = "muxctrl_reg23";
        desc = "RGMII1_TXD0 pin multiplexing control register. muxctrl_reg23 (offset 0x05C, total reset 0x00000000; PROVEN: Hi3535 data sheet, PDF page 99, section 2.3.2).";
        field {
            name = "muxctrl_reg23";
            desc = "Pin multiplexing of RGMII1_TXD0.
- 000: RGMII1_TXD0;
- 001: GPIO2_4;
- 010: CLK_TEST_OUT0;
- 011: CLK_TEST_OUT1;
- 100: CLK_TEST_OUT2;
- 101: CLK_TEST_OUT3;
- 110: CLK_TEST_OUT4;
- 111: RTC_TEST_CLK.";
            sw = rw; hw = r;
            reset = 0x0;
        } muxctrl_reg23[2:0];
    } muxctrl_reg23 @ 0x5c;
    reg {
        name = "muxctrl_reg24";
        desc = "RGMII1_TXD1 pin multiplexing control register. muxctrl_reg24 (offset 0x060, total reset 0x00000000; PROVEN: Hi3535 data sheet, PDF page 99, section 2.3.2).";
        field {
            name = "muxctrl_reg24";
            desc = "Pin multiplexing of RGMII1_TXD1.
- 000: RGMII1_TXD1;
- 001: GPIO2_5;
- 010: PLL_TEST_OUT0;
- 011: PLL_TEST_OUT1;
- 100: PLL_TEST_OUT2;";
            sw = rw; hw = r;
            reset = 0x0;
        } muxctrl_reg24[2:0];
    } muxctrl_reg24 @ 0x60;
    reg {
        name = "muxctrl_reg25";
        desc = "RGMII1_TXD2 pin multiplexing control register. muxctrl_reg25 (offset 0x064, total reset 0x00000000; PROVEN: Hi3535 data sheet, PDF page 100, section 2.3.2).";
        field {
            name = "muxctrl_reg25";
            desc = "Pin multiplexing of the RGMII1_TXD2 pin.
- 00: RGMII1_TXD2.
- 01: GPIO2_6.
- 10: DDRPHY_DEBUG_OUT0. Others: Reserved.";
            sw = rw; hw = r;
            reset = 0x0;
        } muxctrl_reg25[1:0];
    } muxctrl_reg25 @ 0x64;
    reg {
        name = "muxctrl_reg26";
        desc = "RGMII1_TXD3 pin multiplexing control register. muxctrl_reg26 (offset 0x068, total reset 0x00000000; PROVEN: Hi3535 data sheet, PDF page 100, section 2.3.2).";
        field {
            name = "muxctrl_reg26";
            desc = "Specific multiplexing of the RGMII1_TXD3 pin.
- 00: RGMII1_TXD3;";
            sw = rw; hw = r;
            reset = 0x0;
        } muxctrl_reg26[1:0];
    } muxctrl_reg26 @ 0x68;
    reg {
        name = "muxctrl_reg27";
        desc = "RGMII1_RXCK pin multiplexing control register. muxctrl_reg27 (offset 0x06C, total reset 0x00000000; PROVEN: Hi3535 data sheet, PDF page 101, section 2.3.2).";
        field {
            name = "muxctrl_reg27";
            desc = "Specific multiplexing of the RGMII1_RXCK pin.
- 0: RGMII1_RXCK;
- 1: GPIO10_0.";
            sw = rw; hw = r;
            reset = 0x0;
        } muxctrl_reg27[0:0];
    } muxctrl_reg27 @ 0x6c;
    reg {
        name = "muxctrl_reg28";
        desc = "RGMII1_TXEN pin multiplexing control register. muxctrl_reg28 (offset 0x070, total reset 0x00000000; PROVEN: Hi3535 data sheet, PDF page 101, section 2.3.2).";
        field {
            name = "muxctrl_reg28";
            desc = "Pin multiplexing of RGMII1_TXEN.
- 0: RGMII1_TXEN;
- 1: GPIO10_1.";
            sw = rw; hw = r;
            reset = 0x0;
        } muxctrl_reg28[0:0];
    } muxctrl_reg28 @ 0x70;
    reg {
        name = "muxctrl_reg29";
        desc = "RGMII1_TXCK pin multiplexing control register. muxctrl_reg29 (offset 0x074, total reset 0x00000000; PROVEN: Hi3535 data sheet, PDF page 102, section 2.3.2).";
        field {
            name = "muxctrl_reg29";
            desc = "Pin multiplexing of the RGMII1_TXCK pin.
- 00: RGMII1_TXCK.
- 01: GPIO10_2.
- 10: DDRPHY_DEBUG_OUT2. Others: Reserved.";
            sw = rw; hw = r;
            reset = 0x0;
        } muxctrl_reg29[1:0];
    } muxctrl_reg29 @ 0x74;
    reg {
        name = "muxctrl_reg30";
        desc = "RGMII1_TXCKOUT pin multiplexing control register. muxctrl_reg30 (offset 0x078, total reset 0x00000000; PROVEN: Hi3535 data sheet, PDF page 102, section 2.3.2).";
        field {
            name = "muxctrl_reg30";
            desc = "Specific multiplexing of the RGMII1_TXCKOUT pin.
- 00: RGMII1_TXCKOUT.
- 01: GPIO10_3.
- 10: RMII1_CLK.
- 11: DDRPHY_DEBUG_OUT3.";
            sw = rw; hw = r;
            reset = 0x0;
        } muxctrl_reg30[1:0];
    } muxctrl_reg30 @ 0x78;
    reg {
        name = "muxctrl_reg31";
        desc = "RGMII1_CRS pin multiplexing control register. muxctrl_reg31 (offset 0x07C, total reset 0x00000000; PROVEN: Hi3535 data sheet, PDF page 103, section 2.3.2).";
        field {
            name = "muxctrl_reg31";
            desc = "Pin multiplexing of RGMII1_CRS.
- 0: RGMII1_CRS;
- 1: GPIO10_4.";
            sw = rw; hw = r;
            reset = 0x0;
        } muxctrl_reg31[0:0];
    } muxctrl_reg31 @ 0x7c;
    reg {
        name = "muxctrl_reg32";
        desc = "RGMII1_COL pin multiplexing control register. muxctrl_reg32 (offset 0x080, total reset 0x00000000; PROVEN: Hi3535 data sheet, PDF page 103, section 2.3.2).";
        field {
            name = "muxctrl_reg32";
            desc = "Pin multiplexing of RGMII1_COL.
- 0: RGMII1_COL;
- 1: GPIO10_5.";
            sw = rw; hw = r;
            reset = 0x0;
        } muxctrl_reg32[0:0];
    } muxctrl_reg32 @ 0x80;
    reg {
        name = "muxctrl_reg33";
        desc = "RGMII1_RXER pin multiplexing control register. muxctrl_reg33 (offset 0x084, total reset 0x00000000; PROVEN: Hi3535 data sheet, PDF page 104, section 2.3.2).";
        field {
            name = "muxctrl_reg33";
            desc = "Pin multiplexing of RGMII1_RXER.
- 0: RGMII1_RXER;
- 1: GPIO10_6.";
            sw = rw; hw = r;
            reset = 0x0;
        } muxctrl_reg33[0:0];
    } muxctrl_reg33 @ 0x84;
    reg {
        name = "muxctrl_reg34";
        desc = "MDCK pin multiplexing control register. muxctrl_reg34 (offset 0x088, total reset 0x00000000; PROVEN: Hi3535 data sheet, PDF page 104, section 2.3.2).";
        field {
            name = "muxctrl_reg34";
            desc = "Pin multiplexing of MDCK.
- 00: MDCK;
- 10: BOOTROM_SEL;
Others: Reserved.";
            sw = rw; hw = r;
            reset = 0x0;
        } muxctrl_reg34[1:0];
    } muxctrl_reg34 @ 0x88;
    reg {
        name = "muxctrl_reg35";
        desc = "MDIO pin multiplexing control register. muxctrl_reg35 (offset 0x08C, total reset 0x00000000; PROVEN: Hi3535 data sheet, PDF page 105, section 2.3.2).";
        field {
            name = "muxctrl_reg35";
            desc = "Specific multiplexing of the MDIO pin.
- 0: MDIO.
- 1: GPIO11_3.";
            sw = rw; hw = r;
            reset = 0x0;
        } muxctrl_reg35[0:0];
    } muxctrl_reg35 @ 0x8c;
    reg {
        name = "muxctrl_reg36";
        desc = "IR_IN pin multiplexing control register. muxctrl_reg36 (offset 0x090, total reset 0x00000000; PROVEN: Hi3535 data sheet, PDF page 105, section 2.3.2).";
        field {
            name = "muxctrl_reg36";
            desc = "Pin multiplexing of IR_IN.
- 0: GPIO11_7;
- 1: IR_IN.";
            sw = rw; hw = r;
            reset = 0x0;
        } muxctrl_reg36[0:0];
    } muxctrl_reg36 @ 0x90;
    reg {
        name = "muxctrl_reg37";
        desc = "SFC_DIO pin multiplexing control register. muxctrl_reg37 (offset 0x094, total reset 0x00000000; PROVEN: Hi3535 data sheet, PDF page 106, section 2.3.2).";
        field {
            name = "muxctrl_reg37";
            desc = "Pin multiplexing of SFC_DIO.
- 0: SFC_DIO;
- 1: GPIO4_0.";
            sw = rw; hw = r;
            reset = 0x0;
        } muxctrl_reg37[0:0];
    } muxctrl_reg37 @ 0x94;
    reg {
        name = "muxctrl_reg38";
        desc = "SFC_WP_IO2 pin multiplexing control register. muxctrl_reg38 (offset 0x098, total reset 0x00000000; PROVEN: Hi3535 data sheet, PDF page 106, section 2.3.2).";
        field {
            name = "muxctrl_reg38";
            desc = "Pin multiplexing of SFC_WP_IO2.
- 0: SFC_WP_IO2;
- 1: GPIO4_1.";
            sw = rw; hw = r;
            reset = 0x0;
        } muxctrl_reg38[0:0];
    } muxctrl_reg38 @ 0x98;
    reg {
        name = "muxctrl_reg39";
        desc = "SFC_DOI pin multiplexing control register. muxctrl_reg39 (offset 0x09C, total reset 0x00000000; PROVEN: Hi3535 data sheet, PDF page 107, section 2.3.2).";
        field {
            name = "muxctrl_reg39";
            desc = "Specific multiplexing of the SFC_DOI pin.
- 0: SFC_DOI.
- 1: GPIO4_2.";
            sw = rw; hw = r;
            reset = 0x0;
        } muxctrl_reg39[0:0];
    } muxctrl_reg39 @ 0x9c;
    reg {
        name = "muxctrl_reg40";
        desc = "SFC_HOLD_IO3 pin multiplexing control register. muxctrl_reg40 (offset 0x0A0, total reset 0x00000000; PROVEN: Hi3535 data sheet, PDF page 107, section 2.3.2).";
        field {
            name = "muxctrl_reg40";
            desc = "Pin multiplexing of SFC_HOLD_IO3.
- 0: SFC_HOLD_IO3;
- 1: GPIO4_3.";
            sw = rw; hw = r;
            reset = 0x0;
        } muxctrl_reg40[0:0];
    } muxctrl_reg40 @ 0xa0;
    reg {
        name = "muxctrl_reg41";
        desc = "SFC_CS0N pin multiplexing control register. muxctrl_reg41 (offset 0x0A4, total reset 0x00000000; PROVEN: Hi3535 data sheet, PDF page 108, section 2.3.2).";
        field {
            name = "muxctrl_reg41";
            desc = "Specific multiplexing of the SFC_CS0N pin.
- 0: SFC_CS0N.
- 1: GPIO4_4.";
            sw = rw; hw = r;
            reset = 0x0;
        } muxctrl_reg41[0:0];
    } muxctrl_reg41 @ 0xa4;
    reg {
        name = "muxctrl_reg42";
        desc = "SFC_CS1N pin multiplexing control register. muxctrl_reg42 (offset 0x0A8, total reset 0x00000000; PROVEN: Hi3535 data sheet, PDF page 108, section 2.3.2).";
        field {
            name = "muxctrl_reg42";
            desc = "Pin multiplexing of SFC_CS1N.
- 0: SFC_CS1N;
- 1: GPIO4_5.";
            sw = rw; hw = r;
            reset = 0x0;
        } muxctrl_reg42[0:0];
    } muxctrl_reg42 @ 0xa8;
    reg {
        name = "muxctrl_reg43";
        desc = "NF_DQ0 pin multiplexing control register. muxctrl_reg43 (offset 0x0AC, total reset 0x00000000; PROVEN: Hi3535 data sheet, PDF page 109, section 2.3.2).";
        field {
            name = "muxctrl_reg43";
            desc = "Specific multiplexing of the NF_DQ0 pin.
- 0: NF_DQ0;
- 1: GPIO3_0.";
            sw = rw; hw = r;
            reset = 0x0;
        } muxctrl_reg43[0:0];
    } muxctrl_reg43 @ 0xac;
    reg {
        name = "muxctrl_reg44";
        desc = "NF_DQ1 pin multiplexing control register. muxctrl_reg44 (offset 0x0B0, total reset 0x00000000; PROVEN: Hi3535 data sheet, PDF page 109, section 2.3.2).";
        field {
            name = "muxctrl_reg44";
            desc = "Pin multiplexing of NF_DQ1.
- 0: NF_DQ1;
- 1: GPIO3_1.";
            sw = rw; hw = r;
            reset = 0x0;
        } muxctrl_reg44[0:0];
    } muxctrl_reg44 @ 0xb0;
    reg {
        name = "muxctrl_reg45";
        desc = "NF_DQ2 pin multiplexing control register. muxctrl_reg45 (offset 0x0B4, total reset 0x00000000; PROVEN: Hi3535 data sheet, PDF page 110, section 2.3.2).";
        field {
            name = "muxctrl_reg45";
            desc = "Specific multiplexing of the NF_DQ2 pin.
- 0: NF_DQ2;
- 1: GPIO3_2.";
            sw = rw; hw = r;
            reset = 0x0;
        } muxctrl_reg45[0:0];
    } muxctrl_reg45 @ 0xb4;
    reg {
        name = "muxctrl_reg46";
        desc = "NF_DQ3 pin multiplexing control register. muxctrl_reg46 (offset 0x0B8, total reset 0x00000000; PROVEN: Hi3535 data sheet, PDF page 110, section 2.3.2).";
        field {
            name = "muxctrl_reg46";
            desc = "Pin multiplexing of the NF_DQ3 pin.
- 0: NF_DQ3.
- 1: GPIO3_3.";
            sw = rw; hw = r;
            reset = 0x0;
        } muxctrl_reg46[0:0];
    } muxctrl_reg46 @ 0xb8;
    reg {
        name = "muxctrl_reg47";
        desc = "NF_DQ4 pin multiplexing control register. muxctrl_reg47 (offset 0x0BC, total reset 0x00000000; PROVEN: Hi3535 data sheet, PDF page 111, section 2.3.2).";
        field {
            name = "muxctrl_reg47";
            desc = "Specific multiplexing of the NF_DQ4 pin.
- 0: NF_DQ4.
- 1: GPIO3_4.";
            sw = rw; hw = r;
            reset = 0x0;
        } muxctrl_reg47[0:0];
    } muxctrl_reg47 @ 0xbc;
    reg {
        name = "muxctrl_reg48";
        desc = "NF_DQ5 pin multiplexing control register. muxctrl_reg48 (offset 0x0C0, total reset 0x00000000; PROVEN: Hi3535 data sheet, PDF page 111, section 2.3.2).";
        field {
            name = "muxctrl_reg48";
            desc = "Specific multiplexing of the NF_DQ5 pin.
- 0: NF_DQ5;
- 1: GPIO3_5.";
            sw = rw; hw = r;
            reset = 0x0;
        } muxctrl_reg48[0:0];
    } muxctrl_reg48 @ 0xc0;
    reg {
        name = "muxctrl_reg49";
        desc = "NF_DQ6 pin multiplexing control register. muxctrl_reg49 (offset 0x0C4, total reset 0x00000000; PROVEN: Hi3535 data sheet, PDF page 112, section 2.3.2).";
        field {
            name = "muxctrl_reg49";
            desc = "Pin multiplexing of the NF_DQ6 pin.
- 0: NF_DQ6.
- 1: GPIO3_6.";
            sw = rw; hw = r;
            reset = 0x0;
        } muxctrl_reg49[0:0];
    } muxctrl_reg49 @ 0xc4;
    reg {
        name = "muxctrl_reg50";
        desc = "NF_DQ7 pin multiplexing control register. muxctrl_reg50 (offset 0x0C8, total reset 0x00000000; PROVEN: Hi3535 data sheet, PDF page 112, section 2.3.2).";
        field {
            name = "muxctrl_reg50";
            desc = "Pin multiplexing of NF_DQ7.
- 0: NF_DQ7;
- 1: GPIO3_7.";
            sw = rw; hw = r;
            reset = 0x0;
        } muxctrl_reg50[0:0];
    } muxctrl_reg50 @ 0xc8;
    reg {
        name = "muxctrl_reg51";
        desc = "NF_CSN0 pin multiplexing control register. muxctrl_reg51 (offset 0x0CC, total reset 0x00000000; PROVEN: Hi3535 data sheet, PDF page 113, section 2.3.2).";
        field {
            name = "muxctrl_reg51";
            desc = "Pin multiplexing of the NF_CSN0 pin.
- 0: NF_CSN0.
- 1: GPIO12_5.";
            sw = rw; hw = r;
            reset = 0x0;
        } muxctrl_reg51[0:0];
    } muxctrl_reg51 @ 0xcc;
    reg {
        name = "muxctrl_reg52";
        desc = "NF_CSN1 pin multiplexing control register. muxctrl_reg52 (offset 0x0D0, total reset 0x00000000; PROVEN: Hi3535 data sheet, PDF page 113, section 2.3.2).";
        field {
            name = "muxctrl_reg52";
            desc = "Pin multiplexing of NF_CSN1.
- 0: NF_CSN1;
- 1: GPIO12_6.";
            sw = rw; hw = r;
            reset = 0x0;
        } muxctrl_reg52[0:0];
    } muxctrl_reg52 @ 0xd0;
    reg {
        name = "muxctrl_reg53";
        desc = "NF_RDY0 pin multiplexing control register. muxctrl_reg53 (offset 0x0D4, total reset 0x00000000; PROVEN: Hi3535 data sheet, PDF page 114, section 2.3.2).";
        field {
            name = "muxctrl_reg53";
            desc = "Specific multiplexing of the NF_RDY0 pin.
- 0: NF_RDY0;
- 1: Reserved.";
            sw = rw; hw = r;
            reset = 0x0;
        } muxctrl_reg53[0:0];
    } muxctrl_reg53 @ 0xd4;
    reg {
        name = "muxctrl_reg54";
        desc = "NF_RDY1 pin multiplexing control register. muxctrl_reg54 (offset 0x0D8, total reset 0x00000000; PROVEN: Hi3535 data sheet, PDF page 114, section 2.3.2).";
        field {
            name = "muxctrl_reg54";
            desc = "Pin multiplexing of the NF_RDY1 pin.
- 0: NF_RDY1.
- 1: Reserved.";
            sw = rw; hw = r;
            reset = 0x0;
        } muxctrl_reg54[0:0];
    } muxctrl_reg54 @ 0xd8;
    reg {
        name = "muxctrl_reg55";
        desc = "USB2_OVRCUR0 pin multiplexing control register. muxctrl_reg55 (offset 0x0DC, total reset 0x00000000; PROVEN: Hi3535 data sheet, PDF page 115, section 2.3.2).";
        field {
            name = "muxctrl_reg55";
            desc = "Pin multiplexing of the USB2_OVRCUR0 pin.
- 0: GPIO5_0.
- 1: USB2_OVRCUR0.";
            sw = rw; hw = r;
            reset = 0x0;
        } muxctrl_reg55[0:0];
    } muxctrl_reg55 @ 0xdc;
    reg {
        name = "muxctrl_reg56";
        desc = "USB2_PWREN0 pin multiplexing control register. muxctrl_reg56 (offset 0x0E0, total reset 0x00000000; PROVEN: Hi3535 data sheet, PDF page 115, section 2.3.2).";
        field {
            name = "muxctrl_reg56";
            desc = "Pin multiplexing of USB2_PWREN0.
- 0: GPIO5_1;
- 1: USB2_PWREN0.";
            sw = rw; hw = r;
            reset = 0x0;
        } muxctrl_reg56[0:0];
    } muxctrl_reg56 @ 0xe0;
    reg {
        name = "muxctrl_reg57";
        desc = "USB2_OVRCUR1 pin multiplexing control register. muxctrl_reg57 (offset 0x0E4, total reset 0x00000000; PROVEN: Hi3535 data sheet, PDF page 116, section 2.3.2).";
        field {
            name = "muxctrl_reg57";
            desc = "Pin multiplexing of USB2_OVRCUR1.
- 0: GPIO5_2;
- 1: USB2_OVRCUR1.";
            sw = rw; hw = r;
            reset = 0x0;
        } muxctrl_reg57[0:0];
    } muxctrl_reg57 @ 0xe4;
    reg {
        name = "muxctrl_reg58";
        desc = "USB2_PWREN1 pin multiplexing control register. muxctrl_reg58 (offset 0x0E8, total reset 0x00000000; PROVEN: Hi3535 data sheet, PDF page 116, section 2.3.2).";
        field {
            name = "muxctrl_reg58";
            desc = "Specific multiplexing of the USB2_PWREN1 pin.
- 0: GPIO5_3;
- 1: USB2_PWREN1.";
            sw = rw; hw = r;
            reset = 0x0;
        } muxctrl_reg58[0:0];
    } muxctrl_reg58 @ 0xe8;
    reg {
        name = "muxctrl_reg59";
        desc = "USB3_OVRCUR pin multiplexing control register. muxctrl_reg59 (offset 0x0EC, total reset 0x00000000; PROVEN: Hi3535 data sheet, PDF page 117, section 2.3.2).";
        field {
            name = "muxctrl_reg59";
            desc = "Pin multiplexing of USB3_OVRCUR.
- 0: GPIO5_4;
- 1: USB3_OVRCUR.";
            sw = rw; hw = r;
            reset = 0x0;
        } muxctrl_reg59[0:0];
    } muxctrl_reg59 @ 0xec;
    reg {
        name = "muxctrl_reg60";
        desc = "USB3_PWREN pin multiplexing control register. muxctrl_reg60 (offset 0x0F0, total reset 0x00000000; PROVEN: Hi3535 data sheet, PDF page 117, section 2.3.2).";
        field {
            name = "muxctrl_reg60";
            desc = "Specific multiplexing of the USB3_PWREN pin.
- 0: GPIO5_5;
- 1: USB3_PWREN.";
            sw = rw; hw = r;
            reset = 0x0;
        } muxctrl_reg60[0:0];
    } muxctrl_reg60 @ 0xf0;
    reg {
        name = "muxctrl_reg61";
        desc = "HDMI_HOTPLUG pin multiplexing control register. muxctrl_reg61 (offset 0x0F4, total reset 0x00000000; PROVEN: Hi3535 data sheet, PDF page 118, section 2.3.2).";
        field {
            name = "muxctrl_reg61";
            desc = "Pin multiplexing of the HDMI_HOTPLUG pin.
- 0: GPIO6_0.
- 1: HDMI_HOTPLUG.";
            sw = rw; hw = r;
            reset = 0x0;
        } muxctrl_reg61[0:0];
    } muxctrl_reg61 @ 0xf4;
    reg {
        name = "muxctrl_reg62";
        desc = "HDMI_CEC pin multiplexing control register. muxctrl_reg62 (offset 0x0F8, total reset 0x00000000; PROVEN: Hi3535 data sheet, PDF page 118, section 2.3.2).";
        field {
            name = "muxctrl_reg62";
            desc = "Specific multiplexing of the HDMI_CEC pin.
- 0: GPIO6_1;
- 1: HDMI_CEC.";
            sw = rw; hw = r;
            reset = 0x0;
        } muxctrl_reg62[0:0];
    } muxctrl_reg62 @ 0xf8;
    reg {
        name = "muxctrl_reg63";
        desc = "HDMI_SDA pin multiplexing control register. muxctrl_reg63 (offset 0x0FC, total reset 0x00000000; PROVEN: Hi3535 data sheet, PDF page 119, section 2.3.2).";
        field {
            name = "muxctrl_reg63";
            desc = "Pin multiplexing of the HDMI_SDA pin.
- 0: GPIO6_2.
- 1: HDMI_SDA.";
            sw = rw; hw = r;
            reset = 0x0;
        } muxctrl_reg63[0:0];
    } muxctrl_reg63 @ 0xfc;
    reg {
        name = "muxctrl_reg64";
        desc = "HDMI_SCL pin multiplexing control register. muxctrl_reg64 (offset 0x100, total reset 0x00000000; PROVEN: Hi3535 data sheet, PDF page 119, section 2.3.2).";
        field {
            name = "muxctrl_reg64";
            desc = "Pin multiplexing of HDMI_SCL.
- 0: GPIO6_3;
- 1: HDMI_SCL.";
            sw = rw; hw = r;
            reset = 0x0;
        } muxctrl_reg64[0:0];
    } muxctrl_reg64 @ 0x100;
    reg {
        name = "muxctrl_reg65";
        desc = "UART0_RTSN pin multiplexing control register. muxctrl_reg65 (offset 0x104, total reset 0x00000000; PROVEN: Hi3535 data sheet, PDF page 120, section 2.3.2).";
        field {
            name = "muxctrl_reg65";
            desc = "Pin multiplexing of UART0_RTSN.
- 0: UART0_RTSN;
- 1: GPIO6_4.";
            sw = rw; hw = r;
            reset = 0x0;
        } muxctrl_reg65[0:0];
    } muxctrl_reg65 @ 0x104;
    reg {
        name = "muxctrl_reg66";
        desc = "UART0_CTSN pin multiplexing control register. muxctrl_reg66 (offset 0x108, total reset 0x00000000; PROVEN: Hi3535 data sheet, PDF page 120, section 2.3.2).";
        field {
            name = "muxctrl_reg66";
            desc = "Specific multiplexing of the UART0_CTSN pin.
- 0: UART0_CTSN;
- 1: GPIO6_5.";
            sw = rw; hw = r;
            reset = 0x0;
        } muxctrl_reg66[0:0];
    } muxctrl_reg66 @ 0x108;
    reg {
        name = "muxctrl_reg67";
        desc = "UART1_RTSN pin multiplexing control register. muxctrl_reg67 (offset 0x10C, total reset 0x00000000; PROVEN: Hi3535 data sheet, PDF page 121, section 2.3.2).";
        field {
            name = "muxctrl_reg67";
            desc = "Pin multiplexing of UART1_RTSN.
- 0: GPIO7_0;
- 1: UART1_RTSN.";
            sw = rw; hw = r;
            reset = 0x0;
        } muxctrl_reg67[0:0];
    } muxctrl_reg67 @ 0x10c;
    reg {
        name = "muxctrl_reg68";
        desc = "UART1_RXD pin multiplexing control register. muxctrl_reg68 (offset 0x110, total reset 0x00000000; PROVEN: Hi3535 data sheet, PDF page 121, section 2.3.2).";
        field {
            name = "muxctrl_reg68";
            desc = "Pin multiplexing of UART1_RXD.
- 0: GPIO7_1;
- 1: UART1_RXD.";
            sw = rw; hw = r;
            reset = 0x0;
        } muxctrl_reg68[0:0];
    } muxctrl_reg68 @ 0x110;
    reg {
        name = "muxctrl_reg69";
        desc = "UART1_CTSN pin multiplexing control register. muxctrl_reg69 (offset 0x114, total reset 0x00000000; PROVEN: Hi3535 data sheet, PDF page 122, section 2.3.2).";
        field {
            name = "muxctrl_reg69";
            desc = "Pin multiplexing of UART1_CTSN.
- 0: GPIO7_2;
- 1: UART1_CTSN.";
            sw = rw; hw = r;
            reset = 0x0;
        } muxctrl_reg69[0:0];
    } muxctrl_reg69 @ 0x114;
    reg {
        name = "muxctrl_reg70";
        desc = "UART1_TXD pin multiplexing control register. muxctrl_reg70 (offset 0x118, total reset 0x00000000; PROVEN: Hi3535 data sheet, PDF page 122, section 2.3.2).";
        field {
            name = "muxctrl_reg70";
            desc = "Pin multiplexing of UART1_TXD.
- 0: GPIO7_3;
- 1: UART1_TXD.";
            sw = rw; hw = r;
            reset = 0x0;
        } muxctrl_reg70[0:0];
    } muxctrl_reg70 @ 0x118;
    reg {
        name = "muxctrl_reg71";
        desc = "UART2_RXD pin multiplexing control register. muxctrl_reg71 (offset 0x11C, total reset 0x00000000; PROVEN: Hi3535 data sheet, PDF page 123, section 2.3.2).";
        field {
            name = "muxctrl_reg71";
            desc = "Specific multiplexing of the UART2_RXD pin.
- 0: GPIO7_4;
- 1: UART2_RXD.";
            sw = rw; hw = r;
            reset = 0x0;
        } muxctrl_reg71[0:0];
    } muxctrl_reg71 @ 0x11c;
    reg {
        name = "muxctrl_reg72";
        desc = "UART2_TXD pin multiplexing control register. muxctrl_reg72 (offset 0x120, total reset 0x00000000; PROVEN: Hi3535 data sheet, PDF page 123, section 2.3.2).";
        field {
            name = "muxctrl_reg72";
            desc = "Pin multiplexing of the UART2_TXD pin.
- 0: GPIO7_5.
- 1: UART2_TXD.";
            sw = rw; hw = r;
            reset = 0x0;
        } muxctrl_reg72[0:0];
    } muxctrl_reg72 @ 0x120;
    reg {
        name = "muxctrl_reg73";
        desc = "UART3_RXD pin multiplexing control register. muxctrl_reg73 (offset 0x124, total reset 0x00000000; PROVEN: Hi3535 data sheet, PDF page 124, section 2.3.2).";
        field {
            name = "muxctrl_reg73";
            desc = "Specific multiplexing of the UART3_RXD pin.
- 0: GPIO7_6.
- 1: UART3_RXD.";
            sw = rw; hw = r;
            reset = 0x0;
        } muxctrl_reg73[0:0];
    } muxctrl_reg73 @ 0x124;
    reg {
        name = "muxctrl_reg74";
        desc = "UART3_TXD pin multiplexing control register. muxctrl_reg74 (offset 0x128, total reset 0x00000000; PROVEN: Hi3535 data sheet, PDF page 124, section 2.3.2).";
        field {
            name = "muxctrl_reg74";
            desc = "Pin multiplexing of UART3_TXD.
- 0: GPIO7_7;
- 1: UART3_TXD.";
            sw = rw; hw = r;
            reset = 0x0;
        } muxctrl_reg74[0:0];
    } muxctrl_reg74 @ 0x128;
    reg {
        name = "muxctrl_reg75";
        desc = "SATA_LED_N0 pin multiplexing control register. muxctrl_reg75 (offset 0x12C, total reset 0x00000000; PROVEN: Hi3535 data sheet, PDF page 125, section 2.3.2).";
        field {
            name = "muxctrl_reg75";
            desc = "Specific multiplexing of the SATA_LED_N0 pin.
- 0: GPIO11_4;
- 1: SATA_LED_N0.";
            sw = rw; hw = r;
            reset = 0x0;
        } muxctrl_reg75[0:0];
    } muxctrl_reg75 @ 0x12c;
    reg {
        name = "muxctrl_reg76";
        desc = "SATA_LED_N1 pin multiplexing control register. muxctrl_reg76 (offset 0x130, total reset 0x00000000; PROVEN: Hi3535 data sheet, PDF page 125, section 2.3.2).";
        field {
            name = "muxctrl_reg76";
            desc = "Pin multiplexing of SATA_LED_N1.
- 0: GPIO11_5;
- 1: SATA_LED_N1.";
            sw = rw; hw = r;
            reset = 0x0;
        } muxctrl_reg76[0:0];
    } muxctrl_reg76 @ 0x130;
    reg {
        name = "muxctrl_reg77";
        desc = "SATA_LED_N2 pin multiplexing control register. muxctrl_reg77 (offset 0x134, total reset 0x00000000; PROVEN: Hi3535 data sheet, PDF page 126, section 2.3.2).";
        field {
            name = "muxctrl_reg77";
            desc = "Pin multiplexing of the SATA_LED_N2 pin.
- 0: GPIO11_6.
- 1: SATA_LED_N2.";
            sw = rw; hw = r;
            reset = 0x0;
        } muxctrl_reg77[0:0];
    } muxctrl_reg77 @ 0x134;
    reg {
        name = "muxctrl_reg78";
        desc = "I2C_SDA pin multiplexing control register. muxctrl_reg78 (offset 0x138, total reset 0x00000000; PROVEN: Hi3535 data sheet, PDF page 126, section 2.3.2).";
        field {
            name = "muxctrl_reg78";
            desc = "Specific multiplexing of the I2C_SDA pin.
- 0: GPIO5_6.
- 1: I2C_SDA.";
            sw = rw; hw = r;
            reset = 0x0;
        } muxctrl_reg78[0:0];
    } muxctrl_reg78 @ 0x138;
    reg {
        name = "muxctrl_reg79";
        desc = "I2C_SCL pin multiplexing control register. muxctrl_reg79 (offset 0x13C, total reset 0x00000000; PROVEN: Hi3535 data sheet, PDF page 127, section 2.3.2).";
        field {
            name = "muxctrl_reg79";
            desc = "Pin multiplexing of I2C_SCL.
- 0: GPIO5_7;
- 1: I2C_SCL.";
            sw = rw; hw = r;
            reset = 0x0;
        } muxctrl_reg79[0:0];
    } muxctrl_reg79 @ 0x13c;
    reg {
        name = "muxctrl_reg80";
        desc = "PWM_SVB0 pin multiplexing control register. muxctrl_reg80 (offset 0x140, total reset 0x00000000; PROVEN: Hi3535 data sheet, PDF page 127, section 2.3.2).";
        field {
            name = "muxctrl_reg80";
            desc = "Specific multiplexing of the PWM_SVB0 pin.
- 0: PWM_SVB0.
- 1: GPIO11_0.";
            sw = rw; hw = r;
            reset = 0x0;
        } muxctrl_reg80[0:0];
    } muxctrl_reg80 @ 0x140;
    reg {
        name = "muxctrl_reg81";
        desc = "PWM_SVB1 pin multiplexing control register. muxctrl_reg81 (offset 0x144, total reset 0x00000000; PROVEN: Hi3535 data sheet, PDF page 128, section 2.3.2).";
        field {
            name = "muxctrl_reg81";
            desc = "Pin multiplexing of PWM_SVB1.
- 0: PWM_SVB1;
- 1: GPIO11_1.";
            sw = rw; hw = r;
            reset = 0x0;
        } muxctrl_reg81[0:0];
    } muxctrl_reg81 @ 0x144;
    reg {
        name = "muxctrl_reg82";
        desc = "GPIO0_5 pin multiplexing control register. muxctrl_reg82 (offset 0x148, total reset 0x00000000; PROVEN: Hi3535 data sheet, PDF page 128, section 2.3.2).";
        field {
            name = "muxctrl_reg82";
            desc = "Pin multiplexing of GPIO0_5.
- 0: GPIO0_5;
- 1: TEMPER_DQ.";
            sw = rw; hw = r;
            reset = 0x0;
        } muxctrl_reg82[0:0];
    } muxctrl_reg82 @ 0x148;
    reg {
        name = "muxctrl_reg83";
        desc = "GPIO0_6 pin multiplexing control register. muxctrl_reg83 (offset 0x14C, total reset 0x00000000; PROVEN: Hi3535 data sheet, PDF page 129, section 2.3.2).";
        field {
            name = "muxctrl_reg83";
            desc = "Pin multiplexing of GPIO0_6.
- 0: GPIO0_6;
- 1: EPHY0_CLK.";
            sw = rw; hw = r;
            reset = 0x0;
        } muxctrl_reg83[0:0];
    } muxctrl_reg83 @ 0x14c;
    reg {
        name = "muxctrl_reg84";
        desc = "GPIO0_7 pin multiplexing control register. muxctrl_reg84 (offset 0x150, total reset 0x00000000; PROVEN: Hi3535 data sheet, PDF page 129, section 2.3.2).";
        field {
            name = "muxctrl_reg84";
            desc = "Specific multiplexing of the GPIO0_7 pin.
- 0: GPIO0_7;
- 1: EPHY1_CLK.";
            sw = rw; hw = r;
            reset = 0x0;
        } muxctrl_reg84[0:0];
    } muxctrl_reg84 @ 0x150;
    reg {
        name = "muxctrl_reg85";
        desc = "VOU1120_DATA0 pin multiplexing control register. muxctrl_reg85 (offset 0x154, total reset 0x00000000; PROVEN: Hi3535 data sheet, PDF page 130, section 2.3.2).";
        field {
            name = "muxctrl_reg85";
            desc = "Pin multiplexing of VOU1120_DATA0.
- 00: GPIO13_0;
- 01: VOU1120_DATA0; Others: Reserved.";
            sw = rw; hw = r;
            reset = 0x0;
        } muxctrl_reg85[1:0];
    } muxctrl_reg85 @ 0x154;
    reg {
        name = "muxctrl_reg86";
        desc = "VOU1120_DATA1 pin multiplexing control register. muxctrl_reg86 (offset 0x158, total reset 0x00000000; PROVEN: Hi3535 data sheet, PDF page 130, section 2.3.2).";
        field {
            name = "muxctrl_reg86";
            desc = "Pin multiplexing of the VOU1120_DATA1 pin.
- 00: GPIO13_1.
- 01: VOU1120_DATA1. Others: Reserved.";
            sw = rw; hw = r;
            reset = 0x0;
        } muxctrl_reg86[1:0];
    } muxctrl_reg86 @ 0x158;
    reg {
        name = "muxctrl_reg87";
        desc = "VOU1120_DATA2 pin multiplexing control register. muxctrl_reg87 (offset 0x15C, total reset 0x00000000; PROVEN: Hi3535 data sheet, PDF page 131, section 2.3.2).";
        field {
            name = "muxctrl_reg87";
            desc = "Specific multiplexing of the VOU1120_DATA2 pin.
- 00: GPIO13_2.
- 01: VOU1120_DATA2.
- 10: AIO_SD_RX. Others: Reserved.";
            sw = rw; hw = r;
            reset = 0x0;
        } muxctrl_reg87[1:0];
    } muxctrl_reg87 @ 0x15c;
    reg {
        name = "muxctrl_reg88";
        desc = "VOU1120_DATA3 pin multiplexing control register. muxctrl_reg88 (offset 0x160, total reset 0x00000000; PROVEN: Hi3535 data sheet, PDF page 131, section 2.3.2).";
        field {
            name = "muxctrl_reg88";
            desc = "Pin multiplexing of VOU1120_DATA3.
- 00: GPIO13_3;
- 01: VOU1120_DATA3;
- 10: AIO_SD_TX;
Other values: reserved.";
            sw = rw; hw = r;
            reset = 0x0;
        } muxctrl_reg88[1:0];
    } muxctrl_reg88 @ 0x160;
    reg {
        name = "muxctrl_reg89";
        desc = "VOU1120_DATA4 pin multiplexing control register. muxctrl_reg89 (offset 0x164, total reset 0x00000000; PROVEN: Hi3535 data sheet, PDF page 132, section 2.3.2).";
        field {
            name = "muxctrl_reg89";
            desc = "Specific multiplexing of the VOU1120_DATA4 pin.
- 00: GPIO13_4;
- 01: VOU1120_DATA4;
- 10: AIO_WS_TX; Others: Reserved.";
            sw = rw; hw = r;
            reset = 0x0;
        } muxctrl_reg89[1:0];
    } muxctrl_reg89 @ 0x164;
    reg {
        name = "muxctrl_reg90";
        desc = "VOU1120_DATA5 pin multiplexing control register. muxctrl_reg90 (offset 0x168, total reset 0x00000000; PROVEN: Hi3535 data sheet, PDF page 132, section 2.3.2).";
        field {
            name = "muxctrl_reg90";
            desc = "Pin multiplexing of the VOU1120_DATA5 pin.
- 00: GPIO13_5.
- 01: VOU1120_DATA5.
- 10: AIO_BCLK_TX. Others: Reserved.";
            sw = rw; hw = r;
            reset = 0x0;
        } muxctrl_reg90[1:0];
    } muxctrl_reg90 @ 0x168;
    reg {
        name = "muxctrl_reg91";
        desc = "VOU1120_DATA6 pin multiplexing control register. muxctrl_reg91 (offset 0x16C, total reset 0x00000000; PROVEN: Hi3535 data sheet, PDF page 133, section 2.3.2).";
        field {
            name = "muxctrl_reg91";
            desc = "Pin multiplexing of VOU1120_DATA6.
- 00: GPIO13_6;
- 01: VOU1120_DATA6;
- 10: AIO_WS_RX; Others: Reserved.";
            sw = rw; hw = r;
            reset = 0x0;
        } muxctrl_reg91[1:0];
    } muxctrl_reg91 @ 0x16c;
    reg {
        name = "muxctrl_reg92";
        desc = "VOU1120_DATA7 pin multiplexing control register. muxctrl_reg92 (offset 0x170, total reset 0x00000000; PROVEN: Hi3535 data sheet, PDF page 133, section 2.3.2).";
        field {
            name = "muxctrl_reg92";
            desc = "Specific multiplexing of the VOU1120_DATA7 pin.
- 00: Reserved.
- 01: VOU1120_DATA7.
- 10: AIO_MCLK.
- 11: BOOT_SEL0.";
            sw = rw; hw = r;
            reset = 0x0;
        } muxctrl_reg92[1:0];
    } muxctrl_reg92 @ 0x170;
    reg {
        name = "muxctrl_reg93";
        desc = "VOU1120_DATA8 pin multiplexing control register. muxctrl_reg93 (offset 0x174, total reset 0x00000000; PROVEN: Hi3535 data sheet, PDF page 134, section 2.3.2).";
        field {
            name = "muxctrl_reg93";
            desc = "Pin multiplexing of VOU1120_DATA8.
- 00: GPIO14_0;
- 01: VOU1120_DATA8;
Other values: reserved.";
            sw = rw; hw = r;
            reset = 0x0;
        } muxctrl_reg93[1:0];
    } muxctrl_reg93 @ 0x174;
    reg {
        name = "muxctrl_reg94";
        desc = "VOU1120_DATA9 pin multiplexing control register. muxctrl_reg94 (offset 0x178, total reset 0x00000000; PROVEN: Hi3535 data sheet, PDF page 134, section 2.3.2).";
        field {
            name = "muxctrl_reg94";
            desc = "Pin multiplexing of VOU1120_DATA9.
- 00: GPIO14_1;
- 01: VOU1120_DATA9;
Others: Reserved.";
            sw = rw; hw = r;
            reset = 0x0;
        } muxctrl_reg94[1:0];
    } muxctrl_reg94 @ 0x178;
    reg {
        name = "muxctrl_reg95";
        desc = "VOU1120_DATA10 pin multiplexing control register. muxctrl_reg95 (offset 0x17C, total reset 0x00000000; PROVEN: Hi3535 data sheet, PDF page 135, section 2.3.2).";
        field {
            name = "muxctrl_reg95";
            desc = "Pin multiplexing of VOU1120_DATA10.
- 01: VOU1120_DATA10;
- 10: BOOT_SEL1; Others: Reserved.";
            sw = rw; hw = r;
            reset = 0x0;
        } muxctrl_reg95[1:0];
    } muxctrl_reg95 @ 0x17c;
    reg {
        name = "muxctrl_reg96";
        desc = "VOU1120_DATA11 pin multiplexing control register. muxctrl_reg96 (offset 0x180, total reset 0x00000000; PROVEN: Hi3535 data sheet, PDF page 135, section 2.3.2).";
        field {
            name = "muxctrl_reg96";
            desc = "Pin multiplexing of VOU1120_DATA11.
- 00: GPIO14_3;
- 01: VOU1120_DATA11;
Other values: reserved.";
            sw = rw; hw = r;
            reset = 0x0;
        } muxctrl_reg96[1:0];
    } muxctrl_reg96 @ 0x180;
    reg {
        name = "muxctrl_reg97";
        desc = "VOU1120_DATA12 pin multiplexing control register. muxctrl_reg97 (offset 0x184, total reset 0x00000000; PROVEN: Hi3535 data sheet, PDF page 136, section 2.3.2).";
        field {
            name = "muxctrl_reg97";
            desc = "Pin multiplexing of VOU1120_DATA12.
- 00: GPIO14_4;
- 01: VOU1120_DATA12;
Others: Reserved.";
            sw = rw; hw = r;
            reset = 0x0;
        } muxctrl_reg97[1:0];
    } muxctrl_reg97 @ 0x184;
    reg {
        name = "muxctrl_reg98";
        desc = "VOU1120_DATA13 pin multiplexing control register. muxctrl_reg98 (offset 0x188, total reset 0x00000000; PROVEN: Hi3535 data sheet, PDF page 136, section 2.3.2).";
        field {
            name = "muxctrl_reg98";
            desc = "Specific multiplexing of the VOU1120_DATA13 pin.
- 00: GPIO14_5.
- 01: VOU1120_DATA13.
- 10: AIO_BCLK_RX. Others: Reserved.";
            sw = rw; hw = r;
            reset = 0x0;
        } muxctrl_reg98[1:0];
    } muxctrl_reg98 @ 0x188;
    reg {
        name = "muxctrl_reg99";
        desc = "VOU1120_DATA14 pin multiplexing control register. muxctrl_reg99 (offset 0x18C, total reset 0x00000000; PROVEN: Hi3535 data sheet, PDF page 137, section 2.3.2).";
        field {
            name = "muxctrl_reg99";
            desc = "Specific multiplexing of the VOU1120_DATA14 pin.
- 00: GPIO14_6;
- 01: VOU1120_DATA14; Others: Reserved.";
            sw = rw; hw = r;
            reset = 0x0;
        } muxctrl_reg99[1:0];
    } muxctrl_reg99 @ 0x18c;
    reg {
        name = "muxctrl_reg100";
        desc = "VOU1120_DATA15 pin multiplexing control register. muxctrl_reg100 (offset 0x190, total reset 0x00000000; PROVEN: Hi3535 data sheet, PDF page 137, section 2.3.2).";
        field {
            name = "muxctrl_reg100";
            desc = "Pin multiplexing of VOU1120_DATA15.
- 00: GPIO14_7;
- 01: VOU1120_DATA15; Others: Reserved.";
            sw = rw; hw = r;
            reset = 0x0;
        } muxctrl_reg100[1:0];
    } muxctrl_reg100 @ 0x190;
    reg {
        name = "muxctrl_reg101";
        desc = "VOU1120_CLK pin multiplexing control register. muxctrl_reg101 (offset 0x194, total reset 0x00000000; PROVEN: Hi3535 data sheet, PDF page 138, section 2.3.2).";
        field {
            name = "muxctrl_reg101";
            desc = "Pin multiplexing of the VOU1120_CLK pin.
- 00: GPIO12_7.
- 01: VOU1120_CLK. Others: Reserved.";
            sw = rw; hw = r;
            reset = 0x0;
        } muxctrl_reg101[1:0];
    } muxctrl_reg101 @ 0x194;
};

`endif
