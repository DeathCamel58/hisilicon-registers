`ifndef EHI3535_CRG_RDL
`define EHI3535_CRG_RDL
regfile eHI3535_CRG {
    name = "Clock and reset generator (CRG)";
    desc = "Clock and reset generator (CRG). 53 registers extracted programmatically from the Hi3535 H.264 codec processor (Hi3535 user guide) data sheet (Issue 00B08, 2014-02-25); chapter 3.2.7, table 3-24. Field names, bit ranges, access types and reset values are taken from the register tables; reset values are the data sheet total reset values split onto the fields (per-field values where the table has them). Label: PROVEN. Hardware not verified here (no board).";
    reg {
        name = "PERI_CRG0";
        desc = "PERI_CRG0 is APLL configuration register 0. PERI_CRG0 (offset 0x0000, total reset 0x1200_0000; PROVEN: Hi3535 data sheet, PDF page 331, section 3.2.7).";
        field {
            name = "reserved";
            desc = "Reserved.";
            sw = r; hw = w;
            reset = 0x0;
        } reserved_31_31[31:31];
        field {
            name = "apll_postdiv2";
            desc = "APLL second-stage output divider factor.";
            sw = rw; hw = r;
            reset = 0x1;
        } apll_postdiv2[30:28];
        field {
            name = "reserved";
            desc = "Reserved.";
            sw = r; hw = w;
            reset = 0x0;
        } reserved_27_27[27:27];
        field {
            name = "apll_postdiv1";
            desc = "APLL first-stage output divider factor.";
            sw = rw; hw = r;
            reset = 0x2;
        } apll_postdiv1[26:24];
        field {
            name = "apll_frac";
            desc = "APLL fractional divider.";
            sw = rw; hw = r;
            reset = 0x0;
        } apll_frac[23:0];
    } PERI_CRG0 @ 0x0;
    reg {
        name = "PERI_CRG1";
        desc = "PERI_CRG1 is APLL configuration register 1. PERI_CRG1 (offset 0x0004, total reset 0x0100_3064; PROVEN: Hi3535 data sheet, PDF page 331, section 3.2.7).";
        field {
            name = "reserved";
            desc = "Reserved.";
            sw = r; hw = w;
            reset = 0x0;
        } reserved_31_27[31:27];
        field {
            name = "apll_bypass";
            desc = "APLL clock divider bypass control.
- 0: Not bypassed.
- 1: Bypassed.";
            sw = rw; hw = r;
            reset = 0x0;
        } apll_bypass[26:26];
        field {
            name = "apll_dacpd";
            desc = "APLL test signal control.
- 0: Normal operation;
- 1: Power-down state.";
            sw = rw; hw = r;
            reset = 0x0;
        } apll_dacpd[25:25];
        field {
            name = "apll_dsmpd";
            desc = "APLL fractional divider control.
- 0: Fractional mode;
- 1: Integer mode.";
            sw = rw; hw = r;
            reset = 0x1;
        } apll_dsmpd[24:24];
        field {
            name = "apll_pd";
            desc = "APLL power-down control.
- 0: Normal operation;
- 1: Power-down state.";
            sw = rw; hw = r;
            reset = 0x0;
        } apll_pd[23:23];
        field {
            name = "apll_foutvcopd";
            desc = "APLL VCO output power-down control.
- 0: Normal clock output.
- 1: No clock output.";
            sw = rw; hw = r;
            reset = 0x0;
        } apll_foutvcopd[22:22];
        field {
            name = "apll_postdivpd";
            desc = "APLL POSTDIV output power-down control.
- 0: Normal clock output;
- 1: No clock output.";
            sw = rw; hw = r;
            reset = 0x0;
        } apll_postdivpd[21:21];
        field {
            name = "apll_fout4phasepd";
            desc = "APLL FOUT output power-down control.
- 0: Normal clock output.
- 1: No clock output.";
            sw = rw; hw = r;
            reset = 0x0;
        } apll_fout4phasepd[20:20];
        field {
            name = "reserved";
            desc = "Reserved.";
            sw = r; hw = w;
            reset = 0x0;
        } reserved_19_18[19:18];
        field {
            name = "apll_refdiv";
            desc = "APLL reference clock divider.";
            sw = rw; hw = r;
            reset = 0x3;
        } apll_refdiv[17:12];
        field {
            name = "apll_fbdiv";
            desc = "APLL integer multiplier.";
            sw = rw; hw = r;
            reset = 0x64;
        } apll_fbdiv[11:0];
    } PERI_CRG1 @ 0x4;
    reg {
        name = "PERI_CRG2";
        desc = "PERI_CRG2 is BPLL configuration register 0. PERI_CRG2 (offset 0x0008, total reset 0x1300_0000; PROVEN: Hi3535 data sheet, PDF page 333, section 3.2.7).";
        field {
            name = "reserved";
            desc = "Reserved.";
            sw = r; hw = w;
            reset = 0x0;
        } reserved_31_31[31:31];
        field {
            name = "bpll_postdiv2";
            desc = "BPLL second-stage output divider factor.";
            sw = rw; hw = r;
            reset = 0x1;
        } bpll_postdiv2[30:28];
        field {
            name = "reserved";
            desc = "Reserved.";
            sw = r; hw = w;
            reset = 0x0;
        } reserved_27_27[27:27];
        field {
            name = "bpll_postdiv1";
            desc = "BPLL first-stage output divider factor.";
            sw = rw; hw = r;
            reset = 0x3;
        } bpll_postdiv1[26:24];
        field {
            name = "bpll_frac";
            desc = "BPLL fractional divider.";
            sw = rw; hw = r;
            reset = 0x0;
        } bpll_frac[23:0];
    } PERI_CRG2 @ 0x8;
    reg {
        name = "PERI_CRG3";
        desc = "PERI_CRG3 is BPLL configuration register 1. PERI_CRG3 (offset 0x000C, total reset 0x0100_1032; PROVEN: Hi3535 data sheet, PDF page 333, section 3.2.7).";
        field {
            name = "reserved";
            desc = "Reserved.";
            sw = r; hw = w;
            reset = 0x0;
        } reserved_31_27[31:27];
        field {
            name = "bpll_bypass";
            desc = "BPLL clock divider bypass control.
- 0: Not bypassed;
- 1: Bypassed.";
            sw = rw; hw = r;
            reset = 0x0;
        } bpll_bypass[26:26];
        field {
            name = "bpll_dacpd";
            desc = "BPLL test signal control.
- 0: Normal operation;
- 1: Power-down state.";
            sw = rw; hw = r;
            reset = 0x0;
        } bpll_dacpd[25:25];
        field {
            name = "bpll_dsmpd";
            desc = "BPLL fractional divider control.
- 0: Fractional mode;
- 1: Integer mode.";
            sw = rw; hw = r;
            reset = 0x1;
        } bpll_dsmpd[24:24];
        field {
            name = "bpll_pd";
            desc = "BPLL power-down control.
- 0: Normal operating state.
- 1: Power-down state.";
            sw = rw; hw = r;
            reset = 0x0;
        } bpll_pd[23:23];
        field {
            name = "bpll_foutvcopd";
            desc = "BPLL VCO output power-down control.
- 0: Normal clock output;
- 1: No clock output.";
            sw = rw; hw = r;
            reset = 0x0;
        } bpll_foutvcopd[22:22];
        field {
            name = "bpll_postdivpd";
            desc = "BPLL POSTDIV output power-down control.
- 0: Normal clock output;
- 1: No clock output.";
            sw = rw; hw = r;
            reset = 0x0;
        } bpll_postdivpd[21:21];
        field {
            name = "bpll_fout4phasepd";
            desc = "BPLL FOUT output power-down control.
- 0: Normal clock output;
- 1: No clock output.";
            sw = rw; hw = r;
            reset = 0x0;
        } bpll_fout4phasepd[20:20];
        field {
            name = "reserved";
            desc = "Reserved.";
            sw = r; hw = w;
            reset = 0x0;
        } reserved_19_18[19:18];
        field {
            name = "bpll_refdiv";
            desc = "BPLL reference clock divider.";
            sw = rw; hw = r;
            reset = 0x1;
        } bpll_refdiv[17:12];
        field {
            name = "bpll_fbdiv";
            desc = "BPLL integer multiplication factor.";
            sw = rw; hw = r;
            reset = 0x32;
        } bpll_fbdiv[11:0];
    } PERI_CRG3 @ 0xc;
    reg {
        name = "PERI_CRG4";
        desc = "PERI_CRG4 is VPLL0 configuration register 0. PERI_CRG4 (offset 0x0010, total reset 0x2200_0000; PROVEN: Hi3535 data sheet, PDF page 335, section 3.2.7).";
        field {
            name = "reserved";
            desc = "Reserved.";
            sw = r; hw = w;
            reset = 0x0;
        } reserved_31_31[31:31];
        field {
            name = "vpll0_postdiv2";
            desc = "VPLL0 second-stage output divider factor.";
            sw = rw; hw = r;
            reset = 0x2;
        } vpll0_postdiv2[30:28];
        field {
            name = "reserved";
            desc = "Reserved.";
            sw = r; hw = w;
            reset = 0x0;
        } reserved_27_27[27:27];
        field {
            name = "vpll0_postdiv1";
            desc = "VPLL0 first-stage output divider factor.";
            sw = rw; hw = r;
            reset = 0x2;
        } vpll0_postdiv1[26:24];
        field {
            name = "vpll0_frac";
            desc = "VPLL0 fractional divider.";
            sw = rw; hw = r;
            reset = 0x0;
        } vpll0_frac[23:0];
    } PERI_CRG4 @ 0x10;
    reg {
        name = "PERI_CRG5";
        desc = "PERI_CRG5 is VPLL0 configuration register 1. PERI_CRG5 (offset 0x0014, total reset 0x0100_2063; PROVEN: Hi3535 data sheet, PDF page 335, section 3.2.7).";
        field {
            name = "reserved";
            desc = "Reserved.";
            sw = r; hw = w;
            reset = 0x0;
        } reserved_31_27[31:27];
        field {
            name = "vpll0_bypass";
            desc = "VPLL0 clock divider bypass control.
- 0: Not bypassed.
- 1: Bypassed.";
            sw = rw; hw = r;
            reset = 0x0;
        } vpll0_bypass[26:26];
        field {
            name = "vpll0_dacpd";
            desc = "VPLL0 test signal control.
- 0: Normal operating state.
- 1: Power-down state.";
            sw = rw; hw = r;
            reset = 0x0;
        } vpll0_dacpd[25:25];
        field {
            name = "vpll0_dsmpd";
            desc = "VPLL0 fractional divider control.
- 0: Fractional mode;
- 1: Integer mode.";
            sw = rw; hw = r;
            reset = 0x1;
        } vpll0_dsmpd[24:24];
        field {
            name = "vpll0_pd";
            desc = "VPLL0 Power Down control.
- 0: Normal operation;
- 1: Power down.";
            sw = rw; hw = r;
            reset = 0x0;
        } vpll0_pd[23:23];
        field {
            name = "vpll0_foutvcopd";
            desc = "VPLL0 VCO output Power Down control.
- 0: Normal clock output;
- 1: No clock output.";
            sw = rw; hw = r;
            reset = 0x0;
        } vpll0_foutvcopd[22:22];
        field {
            name = "vpll0_postdivpd";
            desc = "VPLL0 POSTDIV output power-down control.
- 0: Normal clock output.
- 1: No clock output.";
            sw = rw; hw = r;
            reset = 0x0;
        } vpll0_postdivpd[21:21];
        field {
            name = "vpll0_fout4phasepd";
            desc = "VPLL0 FOUT output Power Down control.
- 0: Normal clock output.
- 1: No clock output.";
            sw = rw; hw = r;
            reset = 0x0;
        } vpll0_fout4phasepd[20:20];
        field {
            name = "reserved";
            desc = "Reserved.";
            sw = r; hw = w;
            reset = 0x0;
        } reserved_19_18[19:18];
        field {
            name = "vpll0_refdiv";
            desc = "VPLL0 reference clock divider.";
            sw = rw; hw = r;
            reset = 0x2;
        } vpll0_refdiv[17:12];
        field {
            name = "vpll0_fbdiv";
            desc = "VPLL0 integer multiplier.";
            sw = rw; hw = r;
            reset = 0x63;
        } vpll0_fbdiv[11:0];
    } PERI_CRG5 @ 0x14;
    reg {
        name = "PERI_CRG6";
        desc = "PERI_CRG6 is VPLL1 configuration register 0. PERI_CRG6 (offset 0x0018, total reset 0x2200_0000; PROVEN: Hi3535 data sheet, PDF page 337, section 3.2.7).";
        field {
            name = "reserved";
            desc = "Reserved.";
            sw = r; hw = w;
            reset = 0x0;
        } reserved_31_31[31:31];
        field {
            name = "vpll1_postdiv2";
            desc = "VPLL1 second-stage output divider factor.";
            sw = rw; hw = r;
            reset = 0x2;
        } vpll1_postdiv2[30:28];
        field {
            name = "reserved";
            desc = "Reserved.";
            sw = r; hw = w;
            reset = 0x0;
        } reserved_27_27[27:27];
        field {
            name = "vpll1_postdiv1";
            desc = "VPLL1 first-stage output divider factor.";
            sw = rw; hw = r;
            reset = 0x2;
        } vpll1_postdiv1[26:24];
        field {
            name = "vpll1_frac";
            desc = "VPLL1 fractional divider.";
            sw = rw; hw = r;
            reset = 0x0;
        } vpll1_frac[23:0];
    } PERI_CRG6 @ 0x18;
    reg {
        name = "PERI_CRG7";
        desc = "PERI_CRG7 is VPLL1 configuration register 1. PERI_CRG7 (offset 0x001C, total reset 0x0100_2063; PROVEN: Hi3535 data sheet, PDF page 337, section 3.2.7).";
        field {
            name = "reserved";
            desc = "Reserved.";
            sw = r; hw = w;
            reset = 0x0;
        } reserved_31_27[31:27];
        field {
            name = "vpll1_bypass";
            desc = "VPLL1 clock divider bypass control.
- 0: Not bypassed;
- 1: Bypassed.";
            sw = rw; hw = r;
            reset = 0x0;
        } vpll1_bypass[26:26];
        field {
            name = "vpll1_dacpd";
            desc = "VPLL1 test signal control.
- 0: Normal operation;
- 1: Power-down state.";
            sw = rw; hw = r;
            reset = 0x0;
        } vpll1_dacpd[25:25];
        field {
            name = "vpll1_dsmpd";
            desc = "VPLL1 fractional divider control.
- 0: Fractional mode;
- 1: Integer mode.";
            sw = rw; hw = r;
            reset = 0x1;
        } vpll1_dsmpd[24:24];
        field {
            name = "vpll1_pd";
            desc = "VPLL1 Power Down control.
- 0: Normal operation;
- 1: Power down.";
            sw = rw; hw = r;
            reset = 0x0;
        } vpll1_pd[23:23];
        field {
            name = "vpll1_foutvcopd";
            desc = "VPLL1 VCO output Power Down control.
- 0: Normal clock output.
- 1: No clock output.";
            sw = rw; hw = r;
            reset = 0x0;
        } vpll1_foutvcopd[22:22];
        field {
            name = "vpll1_postdivpd";
            desc = "VPLL1 POSTDIV output Power Down control.
- 0: Normal clock output;
- 1: No clock output.";
            sw = rw; hw = r;
            reset = 0x0;
        } vpll1_postdivpd[21:21];
        field {
            name = "vpll1_fout4phasepd";
            desc = "VPLL1 FOUT output power-down control.
- 0: Normal clock output;
- 1: No clock output.";
            sw = rw; hw = r;
            reset = 0x0;
        } vpll1_fout4phasepd[20:20];
        field {
            name = "reserved";
            desc = "Reserved.";
            sw = r; hw = w;
            reset = 0x0;
        } reserved_19_18[19:18];
        field {
            name = "vpll1_refdiv";
            desc = "VPLL1 reference clock divider factor.";
            sw = rw; hw = r;
            reset = 0x2;
        } vpll1_refdiv[17:12];
        field {
            name = "vpll1_fbdiv";
            desc = "VPLL1 integer multiplication factor.";
            sw = rw; hw = r;
            reset = 0x63;
        } vpll1_fbdiv[11:0];
    } PERI_CRG7 @ 0x1c;
    reg {
        name = "PERI_CRG8";
        desc = "PERI_CRG8 is EPLL configuration register 0. PERI_CRG8 (offset 0x0020, total reset 0x1300_0000; PROVEN: Hi3535 data sheet, PDF page 339, section 3.2.7).";
        field {
            name = "reserved";
            desc = "Reserved.";
            sw = r; hw = w;
            reset = 0x0;
        } reserved_31_31[31:31];
        field {
            name = "epll_postdiv2";
            desc = "EPLL second-stage output divider factor.";
            sw = rw; hw = r;
            reset = 0x1;
        } epll_postdiv2[30:28];
        field {
            name = "reserved";
            desc = "Reserved.";
            sw = r; hw = w;
            reset = 0x0;
        } reserved_27_27[27:27];
        field {
            name = "epll_postdiv1";
            desc = "EPLL first-stage output divider factor.";
            sw = rw; hw = r;
            reset = 0x3;
        } epll_postdiv1[26:24];
        field {
            name = "epll_frac";
            desc = "EPLL fractional divider.";
            sw = rw; hw = r;
            reset = 0x0;
        } epll_frac[23:0];
    } PERI_CRG8 @ 0x20;
    reg {
        name = "PERI_CRG9";
        desc = "PERI_CRG9 is EPLL configuration register 1. PERI_CRG9 (offset 0x0024, total reset 0x0100_207D; PROVEN: Hi3535 data sheet, PDF page 339, section 3.2.7).";
        field {
            name = "reserved";
            desc = "Reserved.";
            sw = r; hw = w;
            reset = 0x0;
        } reserved_31_27[31:27];
        field {
            name = "epll_bypass";
            desc = "EPLL clock divider bypass control.
- 0: Not bypassed;
- 1: Bypassed.";
            sw = rw; hw = r;
            reset = 0x0;
        } epll_bypass[26:26];
        field {
            name = "epll_dacpd";
            desc = "EPLL test signal control.
- 0: Normal operating state.
- 1: Power-down state.";
            sw = rw; hw = r;
            reset = 0x0;
        } epll_dacpd[25:25];
        field {
            name = "epll_dsmpd";
            desc = "EPLL fractional divider control.
- 0: Fractional mode;
- 1: Integer mode.";
            sw = rw; hw = r;
            reset = 0x1;
        } epll_dsmpd[24:24];
        field {
            name = "epll_pd";
            desc = "EPLL power-down control.
- 0: Normal operating state.
- 1: Power-down state.";
            sw = rw; hw = r;
            reset = 0x0;
        } epll_pd[23:23];
        field {
            name = "epll_foutvcopd";
            desc = "EPLLVCO output power down control.
- 0: Normal clock output;
- 1: No clock output.";
            sw = rw; hw = r;
            reset = 0x0;
        } epll_foutvcopd[22:22];
        field {
            name = "epll_postdivpd";
            desc = "EPLL POSTDIV output power down control.
- 0: Normal clock output;
- 1: No clock output.";
            sw = rw; hw = r;
            reset = 0x0;
        } epll_postdivpd[21:21];
        field {
            name = "epll_fout4phasepd";
            desc = "EPLLFOUT output power-down control.
- 0: Normal clock output.
- 1: No clock output.";
            sw = rw; hw = r;
            reset = 0x0;
        } epll_fout4phasepd[20:20];
        field {
            name = "reserved";
            desc = "Reserved.";
            sw = r; hw = w;
            reset = 0x0;
        } reserved_19_18[19:18];
        field {
            name = "epll_refdiv";
            desc = "EPLL reference clock divider.";
            sw = rw; hw = r;
            reset = 0x2;
        } epll_refdiv[17:12];
        field {
            name = "epll_fbdiv";
            desc = "EPLL integer multiplication factor.";
            sw = rw; hw = r;
            reset = 0x7d;
        } epll_fbdiv[11:0];
    } PERI_CRG9 @ 0x24;
    reg {
        name = "PERI_CRG10";
        desc = "PERI_CRG10 is the A9 frequency mode and reset configuration register. PERI_CRG10 (offset 0x0028, total reset 0x0003_0011; PROVEN: Hi3535 data sheet, PDF page 341, section 3.2.7).";
        field {
            name = "reserved";
            desc = "Reserved.";
            sw = r; hw = w;
            reset = 0x0;
        } reserved_31_26[31:26];
        field {
            name = "a9clk_loaden";
            desc = "A9 CPU clock divider configuration enable. Each time the skip configuration is changed, perform these three steps: 1. Write the new skip value; 2. Write 0 to loaden; 3. Write 1 to loaden.";
            sw = rw; hw = r;
            reset = 0x0;
        } a9clk_loaden[25:25];
        field {
            name = "a9clk_skipcfg";
            desc = "A9 CPU clock divider configuration. N: N out of every 32 CPU clock beats are gated off.";
            sw = rw; hw = r;
            reset = 0x0;
        } a9clk_skipcfg[24:20];
        field {
            name = "reserved";
            desc = "Reserved.";
            sw = r; hw = w;
            reset = 0x0;
        } reserved_19_18[19:18];
        field {
            name = "a9_pclkdbg_cken";
            desc = "PCLKDBG clock gate configuration register.
- 0: Clock off.
- 1: Clock on.";
            sw = rw; hw = r;
            reset = 0x1;
        } a9_pclkdbg_cken[17:17];
        field {
            name = "a9_peri_cken";
            desc = "PERI clock gate configuration register.
- 0: Turn the clock off.
- 1: Turn the clock on.";
            sw = rw; hw = r;
            reset = 0x1;
        } a9_peri_cken[16:16];
        field {
            name = "reserved";
            desc = "Reserved.";
            sw = r; hw = w;
            reset = 0x0;
        } reserved_15_15[15:15];
        field {
            name = "l2_clkoff_sys";
            desc = "Clock shutdown request of L2.
- 0: On.
- 1: Shut down.";
            sw = rw; hw = r;
            reset = 0x0;
        } l2_clkoff_sys[14:14];
        field {
            name = "cpu_clkoff_sys_1";
            desc = "Clock shutdown request of CPU1.
- 0: On;
- 1: Off.";
            sw = rw; hw = r;
            reset = 0x0;
        } cpu_clkoff_sys_1[13:13];
        field {
            name = "cpu_clkoff_sys_0";
            desc = "Clock gating request for CPU0.
- 0: On;
- 1: Off.";
            sw = rw; hw = r;
            reset = 0x0;
        } cpu_clkoff_sys_0[12:12];
        field {
            name = "reserved";
            desc = "Reserved.";
            sw = r; hw = w;
            reset = 0x0;
        } reserved_11_11[11:11];
        field {
            name = "cs_srst_req";
            desc = "Soft reset request for CS.
- 0: Deassert reset;
- 1: Reset.";
            sw = rw; hw = r;
            reset = 0x0;
        } cs_srst_req[10:10];
        field {
            name = "cluster_scu_srst_req";
            desc = "Soft reset request of the SCU.
- 0: Deassert reset;
- 1: Reset.";
            sw = rw; hw = r;
            reset = 0x0;
        } cluster_scu_srst_req[9:9];
        field {
            name = "cluster_peri_srst_req";
            desc = "Soft reset request of PERI.
- 0: Deassert reset;
- 1: Reset.";
            sw = rw; hw = r;
            reset = 0x0;
        } cluster_peri_srst_req[8:8];
        field {
            name = "reserved";
            desc = "Reserved.";
            sw = r; hw = w;
            reset = 0x0;
        } reserved_7_7[7:7];
        field {
            name = "sc_wd_srst_req_1";
            desc = "WDG1 soft reset request.
- 0: Release reset;
- 1: Reset.";
            sw = rw; hw = r;
            reset = 0x0;
        } sc_wd_srst_req_1[6:6];
        field {
            name = "cluster_dbg_srst_req_1";
            desc = "Soft reset request of the DBG1 module.
- 0: Release reset;
- 1: Reset.";
            sw = rw; hw = r;
            reset = 0x0;
        } cluster_dbg_srst_req_1[5:5];
        field {
            name = "arm_srst_req_1";
            desc = "Soft reset request for CPU1.
- 0: Deassert reset;
- 1: Reset.";
            sw = rw; hw = r;
            reset = 0x1;
        } arm_srst_req_1[4:4];
        field {
            name = "reserved";
            desc = "Reserved.";
            sw = r; hw = w;
            reset = 0x0;
        } reserved_3_3[3:3];
        field {
            name = "sc_wd_srst_req_0";
            desc = "Soft reset request of WDG0.
- 0: Release reset.
- 1: Reset.";
            sw = rw; hw = r;
            reset = 0x0;
        } sc_wd_srst_req_0[2:2];
        field {
            name = "cluster_dbg_srst_req_0";
            desc = "Soft reset request of the DBG0 module.
- 0: Release reset.
- 1: Reset.";
            sw = rw; hw = r;
            reset = 0x0;
        } cluster_dbg_srst_req_0[1:1];
        field {
            name = "arm_srst_req_0";
            desc = "Soft reset request of CPU0, valid only in slave boot mode.
- 0: Release reset.
- 1: Reset.";
            sw = rw; hw = r;
            reset = 0x1;
        } arm_srst_req_0[0:0];
    } PERI_CRG10 @ 0x28;
    reg {
        name = "PERI_CRG11";
        desc = "PERI_CRG11 is the system bus clock frequency configuration register. PERI_CRG11 (offset 0x002C, total reset 0x0000_0000; PROVEN: Hi3535 data sheet, PDF page 343, section 3.2.7).";
        field {
            name = "reserved";
            desc = "Reserved.";
            sw = r; hw = w;
            reset = 0x0;
        } reserved_31_6[31:6];
        field {
            name = "busclk_loaden";
            desc = "MDA_AXI clock divider configuration enable. Each time the skip configuration is changed, do the following three steps: 1. Write the new skip configuration value. 2. Write 0 to loaden. 3. Write 1 to loaden.";
            sw = rw; hw = r;
            reset = 0x0;
        } busclk_loaden[5:5];
        field {
            name = "busclk_skipcfg";
            desc = "MDA_AXI clock divider configuration. N: N clock cycles are turned off out of every 32 CPU clock cycles.";
            sw = rw; hw = r;
            reset = 0x0;
        } busclk_skipcfg[4:0];
    } PERI_CRG11 @ 0x2c;
    reg {
        name = "PERI_CRG12";
        desc = "PERI_CRG12 is the SOC clock selection register. PERI_CRG12 (offset 0x0030, total reset 0x0000_0000; PROVEN: Hi3535 data sheet, PDF page 344, section 3.2.7).";
        field {
            name = "reserved";
            desc = "Reserved.";
            sw = r; hw = w;
            reset = 0x0;
        } reserved_31_13[31:13];
        field {
            name = "mem_adjust_bypass";
            desc = "A9 high-speed memory speed-control mode.
- 0: Non-bypass mode.
- 1: Bypass mode.";
            sw = rw; hw = r;
            reset = 0x0;
        } mem_adjust_bypass[12:12];
        field {
            name = "reserved";
            desc = "Reserved.";
            sw = r; hw = w;
            reset = 0x0;
        } reserved_11_9[11:9];
        field {
            name = "cpu_sc_sel";
            desc = "CPU clock select.
- 0: APLL_FOUTPOSTDIV.
- 1: Select 750M.";
            sw = rw; hw = r;
            reset = 0x0;
        } cpu_sc_sel[8:8];
        field {
            name = "reserved";
            desc = "Reserved.";
            sw = r; hw = w;
            reset = 0x0;
        } reserved_7_6[7:6];
        field {
            name = "ddr_sc_sel";
            desc = "DDR clock select (can be configured only in Slow mode).
- 00: 400M.
- 01: 324M.
- 10: 300M.
- 11: Select the APLL FOUT1PH0 clock.";
            sw = rw; hw = r;
            reset = 0x0;
        } ddr_sc_sel[5:4];
        field {
            name = "reserved";
            desc = "Reserved.";
            sw = r; hw = w;
            reset = 0x0;
        } reserved_3_3[3:3];
        field {
            name = "bus_sc_sel";
            desc = "Can be configured only in Slow mode. [2]: hpaxi clock select.
- 0: 324M.
- 1: 250M. [1]: mdaaxi clock select.
- 0: 324M.
- 1: 250M. [0]: sysaxi clock select.
- 0: 250M.
- 1: 200M.";
            sw = rw; hw = r;
            reset = 0x0;
        } bus_sc_sel[2:0];
    } PERI_CRG12 @ 0x30;
    reg {
        name = "PERI_CRG13";
        desc = "PERI_CRG13 is the VOU clock and reset control register. PERI_CRG13 (offset 0x0034, total reset 0x0000_0002; PROVEN: Hi3535 data sheet, PDF page 345, section 3.2.7).";
        field {
            name = "reserved";
            desc = "Reserved.";
            sw = r; hw = w;
            reset = 0x0;
        } reserved_31_23[31:23];
        field {
            name = "vo_hd0_clkdiv";
            desc = "VO HD0 clock divider configuration.
- 0: DIV1;
- 1: DIV2.";
            sw = rw; hw = r;
            reset = 0x0;
        } vo_hd0_clkdiv[22:22];
        field {
            name = "vo_hd1_clkdiv";
            desc = "VO HD1 clock divider configuration.
- 0: DIV1;
- 1: DIV2.";
            sw = rw; hw = r;
            reset = 0x0;
        } vo_hd1_clkdiv[21:21];
        field {
            name = "bt1120_cken";
            desc = "BT.1120 output clock gating configuration register.
- 0: Clock off;
- 1: Clock on.";
            sw = rw; hw = r;
            reset = 0x0;
        } bt1120_cken[20:20];
        field {
            name = "bt1120_cksel";
            desc = "BT.1120 output clock source select.
- 0: VPLL0 clock (that is, the DHD0 clock; the same below).
- 1: VPLL1 clock (that is, the DHD1 clock; the same below).";
            sw = rw; hw = r;
            reset = 0x0;
        } bt1120_cksel[19:19];
        field {
            name = "hd_dac_cksel";
            desc = "HD DAC clock source select.
- 0: VPLL0 clock;
- 1: VPLL1 clock.";
            sw = rw; hw = r;
            reset = 0x0;
        } hd_dac_cksel[18:18];
        field {
            name = "reserved";
            desc = "Reserved.";
            sw = r; hw = w;
            reset = 0x0;
        } reserved_17_16[17:16];
        field {
            name = "vdp_cksel";
            desc = "VDP operating clock source selection.
- 00: 250M clock;
- 01: 200M clock;
- 10: Reserved;
- 11: 100M clock.";
            sw = rw; hw = r;
            reset = 0x0;
        } vdp_cksel[15:14];
        field {
            name = "vo_sd_clkdiv";
            desc = "VO SD clock divider configuration.
- 0: DIV4;
- 1: DIV2.";
            sw = rw; hw = r;
            reset = 0x0;
        } vo_sd_clkdiv[13:13];
        field {
            name = "vou_cken";
            desc = "VOU operating clock gating configuration register.
- 0: Clock off;
- 1: Clock on.";
            sw = rw; hw = r;
            reset = 0x0;
        } vou_cken[12:12];
        field {
            name = "vou_sd_cken";
            desc = "VOU SD DATE clock gate configuration register.
- 0: Clock off.
- 1: Clock on.";
            sw = rw; hw = r;
            reset = 0x0;
        } vou_sd_cken[11:11];
        field {
            name = "vou_hd1_cken";
            desc = "VOU HD1 clock gate configuration register.
- 0: Turn the clock off.
- 1: Turn the clock on.";
            sw = rw; hw = r;
            reset = 0x0;
        } vou_hd1_cken[10:10];
        field {
            name = "vou_hd0_cken";
            desc = "VOU HD0 clock gate configuration register.
- 0: Clock off;
- 1: Clock on.";
            sw = rw; hw = r;
            reset = 0x0;
        } vou_hd0_cken[9:9];
        field {
            name = "vou_hcken";
            desc = "VOU bus clock gate configuration register.
- 0: Turn off the clock;
- 1: Turn on the clock.";
            sw = rw; hw = r;
            reset = 0x0;
        } vou_hcken[8:8];
        field {
            name = "sddac_cken";
            desc = "SD DAC clock gate configuration register.
- 0: Turn the clock off.
- 1: Turn the clock on.";
            sw = rw; hw = r;
            reset = 0x0;
        } sddac_cken[7:7];
        field {
            name = "hddac_cken";
            desc = "HD DAC clock gating configuration register.
- 0: Clock off;
- 1: Clock on.";
            sw = rw; hw = r;
            reset = 0x0;
        } hddac_cken[6:6];
        field {
            name = "sd_dac_pctrl";
            desc = "SD DAC clock phase control.
- 0: Forward clock;
- 1: Inverted clock.";
            sw = rw; hw = r;
            reset = 0x0;
        } sd_dac_pctrl[5:5];
        field {
            name = "hd_dac_pctrl";
            desc = "HD DAC clock phase control.
- 0: Normal clock.
- 1: Inverted clock.";
            sw = rw; hw = r;
            reset = 0x0;
        } hd_dac_pctrl[4:4];
        field {
            name = "reserved";
            desc = "Reserved.";
            sw = r; hw = w;
            reset = 0x0;
        } reserved_3_2[3:2];
        field {
            name = "vohd_out_pctrl";
            desc = "VOU BT.1120 output accompanying clock phase control.
- 0: Normal clock;
- 1: Inverted clock.";
            sw = rw; hw = r;
            reset = 0x1;
        } vohd_out_pctrl[1:1];
        field {
            name = "vo_srst_req";
            desc = "VDP reset request.
- 0: Deassert reset;
- 1: Reset.";
            sw = rw; hw = r;
            reset = 0x0;
        } vo_srst_req[0:0];
    } PERI_CRG13 @ 0x34;
    reg {
        name = "PERI_CRG14";
        desc = "PERI_CRG14 is the PWM clock and reset control register. PERI_CRG14 (offset 0x0038, total reset 0x0000_0000; PROVEN: Hi3535 data sheet, PDF page 347, section 3.2.7).";
        field {
            name = "reserved";
            desc = "Reserved.";
            sw = r; hw = w;
            reset = 0x0;
        } reserved_31_3[31:3];
        field {
            name = "pwm_cksel";
            desc = "PWM clock selection.
- 0: 3M;
- 1: 24M.";
            sw = rw; hw = r;
            reset = 0x0;
        } pwm_cksel[2:2];
        field {
            name = "pwm_cken";
            desc = "PWM clock gate configuration.
- 0: Turn the clock off.
- 1: Turn the clock on.";
            sw = rw; hw = r;
            reset = 0x0;
        } pwm_cken[1:1];
        field {
            name = "pwm_srst_req";
            desc = "Soft reset request for PWM.
- 0: Deassert reset;
- 1: Reset.";
            sw = rw; hw = r;
            reset = 0x0;
        } pwm_srst_req[0:0];
    } PERI_CRG14 @ 0x38;
    reg {
        name = "PERI_CRG15";
        desc = "PERI_CRG15 is the HDMI clock and reset control register. PERI_CRG15 (offset 0x003C, total reset 0x0000_0003; PROVEN: Hi3535 data sheet, PDF page 348, section 3.2.7).";
        field {
            name = "reserved";
            desc = "Reserved";
            sw = r; hw = w;
            reset = 0x0;
        } reserved_31_12[31:12];
        field {
            name = "hdmi_pix_cksel";
            desc = "HDMI PIX CLK clock source select.
- 0: VPLL0 clock.
- 1: VPLL1 clock.";
            sw = rw; hw = r;
            reset = 0x0;
        } hdmi_pix_cksel[11:11];
        field {
            name = "hdmi_cec_clk_sel";
            desc = "HDMI CEC CLK clock gate selection.
- 0: XTAL div12 clock;
- 1: PLL divided 2.04M clock.";
            sw = rw; hw = r;
            reset = 0x0;
        } hdmi_cec_clk_sel[10:10];
        field {
            name = "hdmi_asclk_sel";
            desc = "HDMI ASCLK clock select.
- 0: HDMI PHY clock.
- 1: PLL clock.";
            sw = rw; hw = r;
            reset = 0x0;
        } hdmi_asclk_sel[9:9];
        field {
            name = "hdmi_osclk_sel";
            desc = "HDMI OSCLK clock select.
- 0: HDMI PHY clock;
- 1: PLL clock.";
            sw = rw; hw = r;
            reset = 0x0;
        } hdmi_osclk_sel[8:8];
        field {
            name = "hdmi_mhl_cken";
            desc = "HDMI MHL clock gating configuration.
- 0: Turn off the clock;
- 1: Turn on the clock.";
            sw = rw; hw = r;
            reset = 0x0;
        } hdmi_mhl_cken[7:7];
        field {
            name = "hdmi_cec_cken";
            desc = "HDMI CEC_CLK clock gate configuration.
- 0: Clock off;
- 1: Clock on.";
            sw = rw; hw = r;
            reset = 0x0;
        } hdmi_cec_cken[6:6];
        field {
            name = "hdmi_os_cken";
            desc = "HDMI OSCLK clock gate configuration.
- 0: Clock off.
- 1: Clock on.";
            sw = rw; hw = r;
            reset = 0x0;
        } hdmi_os_cken[5:5];
        field {
            name = "hdmi_as_cken";
            desc = "HDMI ASCLK clock gate configuration.
- 0: Clock off.
- 1: Clock on.";
            sw = rw; hw = r;
            reset = 0x0;
        } hdmi_as_cken[4:4];
        field {
            name = "hdmi_id_cken";
            desc = "HDMI pixel clock gate configuration.
- 0: Clock off;
- 1: Clock on.";
            sw = rw; hw = r;
            reset = 0x0;
        } hdmi_id_cken[3:3];
        field {
            name = "hdmi_bus_cken";
            desc = "HDMI bus clock gating configuration.
- 0: Clock off;
- 1: Clock on.";
            sw = rw; hw = r;
            reset = 0x0;
        } hdmi_bus_cken[2:2];
        field {
            name = "hdmi_hrst_req";
            desc = "Soft reset request of the HDMI bus side.
- 0: Release reset;
- 1: Reset.";
            sw = rw; hw = r;
            reset = 0x1;
        } hdmi_hrst_req[1:1];
        field {
            name = "hdmi_srst_req";
            desc = "Soft reset request of HDMI.
- 0: Release reset.
- 1: Reset.";
            sw = rw; hw = r;
            reset = 0x1;
        } hdmi_srst_req[0:0];
    } PERI_CRG15 @ 0x3c;
    reg {
        name = "PERI_CRG16";
        desc = "PERI_CRG16 is the VEDU clock and soft reset control register. PERI_CRG16 (offset 0x0040, total reset 0x0000_0007; PROVEN: Hi3535 data sheet, PDF page 350, section 3.2.7).";
        field {
            name = "reserved";
            desc = "Reserved.";
            sw = r; hw = w;
            reset = 0x0;
        } reserved_31_10[31:10];
        field {
            name = "veduclk_loaden";
            desc = "VEDU clock divider configuration enable. Each time the skip configuration is changed, follow these three steps: 1. Write the new skip configuration value. 2. Write loaden as 0. 3. Write loaden as 1.";
            sw = rw; hw = r;
            reset = 0x0;
        } veduclk_loaden[9:9];
        field {
            name = "veduclk_skipcfg";
            desc = "VEDU clock divider configuration. N: N clock beats are turned off out of every 32 beats of the VEDU clock.";
            sw = rw; hw = r;
            reset = 0x0;
        } veduclk_skipcfg[8:4];
        field {
            name = "reserved";
            desc = "Reserved.";
            sw = r; hw = w;
            reset = 0x0;
        } reserved_3_3[3:3];
        field {
            name = "sed_cken";
            desc = "SED clock gate configuration.
- 0: Turn the clock off.
- 1: Turn the clock on.";
            sw = rw; hw = r;
            reset = 0x1;
        } sed_cken[2:2];
        field {
            name = "vedu_cken";
            desc = "VEDU clock gate configuration.
- 0: Turn off the clock;
- 1: Turn on the clock.";
            sw = rw; hw = r;
            reset = 0x1;
        } vedu_cken[1:1];
        field {
            name = "vedu_srst_req";
            desc = "Soft reset request for VEDU.
- 0: Deassert reset;
- 1: Reset.";
            sw = rw; hw = r;
            reset = 0x1;
        } vedu_srst_req[0:0];
    } PERI_CRG16 @ 0x40;
    reg {
        name = "PERI_CRG18";
        desc = "PERI_CRG18 is the VPSS clock and soft reset control register. PERI_CRG18 (offset 0x0048, total reset 0x0000_0003; PROVEN: Hi3535 data sheet, PDF page 351, section 3.2.7).";
        field {
            name = "reserved";
            desc = "Reserved.";
            sw = r; hw = w;
            reset = 0x0;
        } reserved_31_10[31:10];
        field {
            name = "vpsclk_loaden";
            desc = "VPSS clock divider configuration enable. Each time the skip configuration is changed, do the following three steps: 1. Write the new skip configuration value. 2. Write 0 to loaden. 3. Write 1 to loaden.";
            sw = rw; hw = r;
            reset = 0x0;
        } vpsclk_loaden[9:9];
        field {
            name = "vpsclk_skipcfg";
            desc = "VPSS clock divider configuration. N: N out of every 32 VPS clock beats are gated off.";
            sw = rw; hw = r;
            reset = 0x0;
        } vpsclk_skipcfg[8:4];
        field {
            name = "reserved";
            desc = "Reserved.";
            sw = r; hw = w;
            reset = 0x0;
        } reserved_3_2[3:2];
        field {
            name = "vps_cken";
            desc = "VPSS clock gate configuration.
- 0: Turn the clock off.
- 1: Turn the clock on.";
            sw = rw; hw = r;
            reset = 0x1;
        } vps_cken[1:1];
        field {
            name = "vps_srst_req";
            desc = "Soft reset request of VPSS.
- 0: Release reset;
- 1: Reset.";
            sw = rw; hw = r;
            reset = 0x1;
        } vps_srst_req[0:0];
    } PERI_CRG18 @ 0x48;
    reg {
        name = "PERI_CRG20";
        desc = "PERI_CRG20 is the VDH0 clock and soft reset control register. PERI_CRG20 (offset 0x0050, total reset 0x0000_000F; PROVEN: Hi3535 data sheet, PDF page 352, section 3.2.7).";
        field {
            name = "reserved";
            desc = "Reserved.";
            sw = r; hw = w;
            reset = 0x0;
        } reserved_31_10[31:10];
        field {
            name = "vdh0clk_loaden";
            desc = "VDH0 clock divider configuration enable. Each time the skip configuration is changed, follow these three steps: 1. Write the new skip configuration value. 2. Write loaden as 0. 3. Write loaden as 1.";
            sw = rw; hw = r;
            reset = 0x0;
        } vdh0clk_loaden[9:9];
        field {
            name = "vdh0clk_skipcfg";
            desc = "VDH0 clock divider configuration. N: N out of every 32 VDH clock beats are gated off.";
            sw = rw; hw = r;
            reset = 0x0;
        } vdh0clk_skipcfg[8:4];
        field {
            name = "vdh0_cken";
            desc = "VDH0 clock gating configuration.
- 0: Clock off;
- 1: Clock on.";
            sw = rw; hw = r;
            reset = 0x1;
        } vdh0_cken[3:3];
        field {
            name = "vdh0_scd_srst_req";
            desc = "Soft reset request for VDH0 SCD.
- 0: Deassert reset;
- 1: Reset.";
            sw = rw; hw = r;
            reset = 0x1;
        } vdh0_scd_srst_req[2:2];
        field {
            name = "vdh0_mfd_srst_req";
            desc = "Soft reset request of VDH0 MFD.
- 0: Deassert reset.
- 1: Reset.";
            sw = rw; hw = r;
            reset = 0x1;
        } vdh0_mfd_srst_req[1:1];
        field {
            name = "vdh0_all_srst_req";
            desc = "Soft reset request of VDH0.
- 0: Release reset;
- 1: Reset.";
            sw = rw; hw = r;
            reset = 0x1;
        } vdh0_all_srst_req[0:0];
    } PERI_CRG20 @ 0x50;
    reg {
        name = "PERI_CRG21";
        desc = "PERI_CRG21 is the VDH1 clock and soft reset control register. PERI_CRG21 (offset 0x0054, total reset 0x0000_000F; PROVEN: Hi3535 data sheet, PDF page 353, section 3.2.7).";
        field {
            name = "reserved";
            desc = "Reserved.";
            sw = rw; hw = r;
            reset = 0x0;
        } reserved_31_10[31:10];
        field {
            name = "vdh1clk_loaden";
            desc = "VDH1 clock divider configuration enable. Each time the skip setting is changed, follow these three steps: 1. Write the new skip value; 2. Write loaden as 0; 3. Write loaden as 1.";
            sw = rw; hw = r;
            reset = 0x0;
        } vdh1clk_loaden[9:9];
        field {
            name = "vdh1clk_skipcfg";
            desc = "VDH1 clock divider configuration. N: N out of every 32 VDH clock beats are gated off.";
            sw = rw; hw = r;
            reset = 0x0;
        } vdh1clk_skipcfg[8:4];
        field {
            name = "vdh1_cken";
            desc = "VDH1 clock gate configuration.
- 0: Clock off;
- 1: Clock on.";
            sw = rw; hw = r;
            reset = 0x1;
        } vdh1_cken[3:3];
        field {
            name = "vdh1_scd_srst_req";
            desc = "Soft reset request for VDH1 SCD.
- 0: Deassert reset;
- 1: Reset.";
            sw = rw; hw = r;
            reset = 0x1;
        } vdh1_scd_srst_req[2:2];
        field {
            name = "vdh1_mfd_srst_req";
            desc = "Soft reset request of VDH1 MFD.
- 0: Release reset.
- 1: Reset.";
            sw = rw; hw = r;
            reset = 0x1;
        } vdh1_mfd_srst_req[1:1];
        field {
            name = "vdh1_all_srst_req";
            desc = "Soft reset request of VDH1.
- 0: Release reset.
- 1: Reset.";
            sw = rw; hw = r;
            reset = 0x1;
        } vdh1_all_srst_req[0:0];
    } PERI_CRG21 @ 0x54;
    reg {
        name = "PERI_CRG22";
        desc = "PERI_CRG22 is the TDE clock and soft reset control register. PERI_CRG22 (offset 0x0058, total reset 0x0000_0003; PROVEN: Hi3535 data sheet, PDF page 354, section 3.2.7).";
        field {
            name = "reserved";
            desc = "Reserved.";
            sw = r; hw = w;
            reset = 0x0;
        } reserved_31_10[31:10];
        field {
            name = "tdeclk_loaden";
            desc = "TDE clock divider configuration enable. Each time the skip setting is changed, follow these three steps: 1. Write the new skip value; 2. Write loaden as 0; 3. Write loaden as 1.";
            sw = rw; hw = r;
            reset = 0x0;
        } tdeclk_loaden[9:9];
        field {
            name = "tdeclk_skipcfg";
            desc = "TDE clock divider configuration. N: N clock beats are turned off in every 32 TDE clock beats.";
            sw = rw; hw = r;
            reset = 0x0;
        } tdeclk_skipcfg[8:4];
        field {
            name = "reserved";
            desc = "Reserved.";
            sw = r; hw = w;
            reset = 0x0;
        } reserved_3_2[3:2];
        field {
            name = "tde_cken";
            desc = "TDE clock gate configuration.
- 0: Clock off;
- 1: Clock on.";
            sw = rw; hw = r;
            reset = 0x1;
        } tde_cken[1:1];
        field {
            name = "tde_srst_req";
            desc = "Soft reset request of the TDE.
- 0: Release reset.
- 1: Reset.";
            sw = rw; hw = r;
            reset = 0x1;
        } tde_srst_req[0:0];
    } PERI_CRG22 @ 0x58;
    reg {
        name = "PERI_CRG23";
        desc = "PERI_CRG23 is the VGS clock and soft reset control register. PERI_CRG23 (offset 0x005C, total reset 0x0000_0003; PROVEN: Hi3535 data sheet, PDF page 355, section 3.2.7).";
        field {
            name = "reserved";
            desc = "Reserved.";
            sw = r; hw = w;
            reset = 0x0;
        } reserved_31_10[31:10];
        field {
            name = "vgsclk_loaden";
            desc = "VGS clock divider configuration enable. Each time the skip configuration is changed, follow these three steps: 1. Write the new skip configuration value. 2. Write loaden as 0. 3. Write loaden as 1.";
            sw = rw; hw = r;
            reset = 0x0;
        } vgsclk_loaden[9:9];
        field {
            name = "vgsclk_skipcfg";
            desc = "VGS clock divider configuration. N: N clock cycles are turned off out of every 32 VPS clock cycles.";
            sw = rw; hw = r;
            reset = 0x0;
        } vgsclk_skipcfg[8:4];
        field {
            name = "reserved";
            desc = "Reserved.";
            sw = r; hw = w;
            reset = 0x0;
        } reserved_3_2[3:2];
        field {
            name = "vgs_cken";
            desc = "VGS clock gate configuration.
- 0: Turn off the clock;
- 1: Turn on the clock.";
            sw = rw; hw = r;
            reset = 0x1;
        } vgs_cken[1:1];
        field {
            name = "vgs_srst_req";
            desc = "VGS soft reset request.
- 0: Release reset;
- 1: Reset.";
            sw = rw; hw = r;
            reset = 0x1;
        } vgs_srst_req[0:0];
    } PERI_CRG23 @ 0x5c;
    reg {
        name = "PERI_CRG24";
        desc = "PERI_CRG24 is the JPGE clock and soft reset control register. PERI_CRG24 (offset 0x0060, total reset 0x0000_0003; PROVEN: Hi3535 data sheet, PDF page 356, section 3.2.7).";
        field {
            name = "reserved";
            desc = "Reserved.";
            sw = r; hw = w;
            reset = 0x0;
        } reserved_31_10[31:10];
        field {
            name = "jpgeclk_loaden";
            desc = "JPGE clock divider configuration enable. Each time the skip configuration is changed, do the following three steps: 1. Write the new skip configuration value. 2. Write 0 to loaden. 3. Write 1 to loaden.";
            sw = rw; hw = r;
            reset = 0x0;
        } jpgeclk_loaden[9:9];
        field {
            name = "jpgeclk_skipcfg";
            desc = "JPGE clock divider configuration. N: N clock cycles are turned off out of every 32 JPGE clock cycles.";
            sw = rw; hw = r;
            reset = 0x0;
        } jpgeclk_skipcfg[8:4];
        field {
            name = "reserved";
            desc = "Reserved.";
            sw = r; hw = w;
            reset = 0x0;
        } reserved_3_2[3:2];
        field {
            name = "jpge_cken";
            desc = "JPGE clock gate configuration.
- 0: Turn off the clock;
- 1: Turn on the clock.";
            sw = rw; hw = r;
            reset = 0x1;
        } jpge_cken[1:1];
        field {
            name = "jpge_srst_req";
            desc = "JPGE soft reset request.
- 0: Release reset;
- 1: Reset.";
            sw = rw; hw = r;
            reset = 0x1;
        } jpge_srst_req[0:0];
    } PERI_CRG24 @ 0x60;
    reg {
        name = "PERI_CRG25";
        desc = "PERI_CRG25 is the JPGD clock and soft reset control register. PERI_CRG25 (offset 0x0064, total reset 0x0000_0003; PROVEN: Hi3535 data sheet, PDF page 357, section 3.2.7).";
        field {
            name = "reserved";
            desc = "Reserved.";
            sw = r; hw = w;
            reset = 0x0;
        } reserved_31_10[31:10];
        field {
            name = "jpgdclk_loaden";
            desc = "JPGD clock divider configuration enable. Each time the skip setting is changed, follow these three steps: 1. Write the new skip value; 2. Write loaden as 0; 3. Write loaden as 1.";
            sw = rw; hw = r;
            reset = 0x0;
        } jpgdclk_loaden[9:9];
        field {
            name = "jpgdclk_skipcfg";
            desc = "JPGD clock divider configuration. N: N clock cycles are gated off out of every 32 JPGD clock cycles.";
            sw = rw; hw = r;
            reset = 0x0;
        } jpgdclk_skipcfg[8:4];
        field {
            name = "reserved";
            desc = "Reserved.";
            sw = r; hw = w;
            reset = 0x0;
        } reserved_3_2[3:2];
        field {
            name = "jpgd_cken";
            desc = "JPGD clock gate configuration.
- 0: Clock off.
- 1: Clock on.";
            sw = rw; hw = r;
            reset = 0x1;
        } jpgd_cken[1:1];
        field {
            name = "jpgd_srst_req";
            desc = "Soft reset request of JPGD.
- 0: Deassert reset;
- 1: Reset.";
            sw = rw; hw = r;
            reset = 0x1;
        } jpgd_srst_req[0:0];
    } PERI_CRG25 @ 0x64;
    reg {
        name = "PERI_CRG26";
        desc = "PERI_CRG26 is the MDU clock and soft reset control register. PERI_CRG26 (offset 0x0068, total reset 0x0000_0003; PROVEN: Hi3535 data sheet, PDF page 358, section 3.2.7).";
        field {
            name = "reserved";
            desc = "Reserved.";
            sw = r; hw = w;
            reset = 0x0;
        } reserved_31_10[31:10];
        field {
            name = "mduclk_loaden";
            desc = "MDU clock divider configuration enable. Each time the skip configuration is changed, do the following three steps: 1. Write the new skip configuration value. 2. Write 0 to loaden. 3. Write 1 to loaden.";
            sw = rw; hw = r;
            reset = 0x0;
        } mduclk_loaden[9:9];
        field {
            name = "mduclk_skipcfg";
            desc = "MDU clock divider configuration. N: N out of every 32 MDU clock beats are gated off.";
            sw = rw; hw = r;
            reset = 0x0;
        } mduclk_skipcfg[8:4];
        field {
            name = "reserved";
            desc = "Reserved.";
            sw = r; hw = w;
            reset = 0x0;
        } reserved_3_2[3:2];
        field {
            name = "mdu_cken";
            desc = "MDU clock gate configuration.
- 0: Turn off the clock;
- 1: Turn on the clock.";
            sw = rw; hw = r;
            reset = 0x1;
        } mdu_cken[1:1];
        field {
            name = "mdu_srst_req";
            desc = "Soft reset request of the MDU.
- 0: Release reset;
- 1: Reset.";
            sw = rw; hw = r;
            reset = 0x1;
        } mdu_srst_req[0:0];
    } PERI_CRG26 @ 0x68;
    reg {
        name = "PERI_CRG27";
        desc = "PERI_CRG27 is the VAPU clock and soft reset control register. PERI_CRG27 (offset 0x006C, total reset 0x0000_0003; PROVEN: Hi3535 data sheet, PDF page 359, section 3.2.7).";
        field {
            name = "reserved";
            desc = "Reserved.";
            sw = r; hw = w;
            reset = 0x0;
        } reserved_31_10[31:10];
        field {
            name = "vapuclk_loaden";
            desc = "VAPU clock divider configuration enable. Each time the skip configuration is changed, perform the following three steps: 1. Write the new skip configuration value; 2. Write loaden to 0; 3. Write loaden to 1.";
            sw = rw; hw = r;
            reset = 0x0;
        } vapuclk_loaden[9:9];
        field {
            name = "vapuclk_skipcfg";
            desc = "VAPU clock divider configuration. N: N clock cycles are turned off out of every 32 VAPU clock cycles.";
            sw = rw; hw = r;
            reset = 0x0;
        } vapuclk_skipcfg[8:4];
        field {
            name = "reserved";
            desc = "Reserved.";
            sw = r; hw = w;
            reset = 0x0;
        } reserved_3_2[3:2];
        field {
            name = "vapu_cken";
            desc = "VAPU clock gating configuration.
- 0: Turn off the clock;
- 1: Turn on the clock.";
            sw = rw; hw = r;
            reset = 0x1;
        } vapu_cken[1:1];
        field {
            name = "vapu_srst_req";
            desc = "Soft reset request for VAPU.
- 0: Deassert reset;
- 1: Reset.";
            sw = rw; hw = r;
            reset = 0x1;
        } vapu_srst_req[0:0];
    } PERI_CRG27 @ 0x6c;
    reg {
        name = "PERI_CRG31";
        desc = "PERI_CRG31 is the clock and soft reset control register related to CIPHER. PERI_CRG31 (offset 0x007C, total reset 0x0000_0000; PROVEN: Hi3535 data sheet, PDF page 360, section 3.2.7).";
        field {
            name = "reserved";
            desc = "Reserved.";
            sw = r; hw = w;
            reset = 0x0;
        } reserved_31_2[31:2];
        field {
            name = "cipher_cken";
            desc = "CIPHER clock gate configuration.
- 0: Clock off;
- 1: Clock on.";
            sw = rw; hw = r;
            reset = 0x0;
        } cipher_cken[1:1];
        field {
            name = "cipher_srst_req";
            desc = "Soft reset request of the CIPHER.
- 0: Deassert reset.
- 1: Reset.";
            sw = rw; hw = r;
            reset = 0x0;
        } cipher_srst_req[0:0];
    } PERI_CRG31 @ 0x7c;
    reg {
        name = "PERI_CRG35";
        desc = "PERI_CRG35 is the AIO clock and reset control register. PERI_CRG35 (offset 0x008C, total reset 0x0000_0000; PROVEN: Hi3535 data sheet, PDF page 360, section 3.2.7).";
        field {
            name = "reserved";
            desc = "Reserved.";
            sw = r; hw = w;
            reset = 0x0;
        } reserved_31_4[31:4];
        field {
            name = "aio_cksel";
            desc = "AIO MCLK PLL source select.
- 00: 500M;
- 01: APLL_FOUTPOSTDIV;
- 1X: 1500M.";
            sw = rw; hw = r;
            reset = 0x0;
        } aio_cksel[3:2];
        field {
            name = "aio_hcken";
            desc = "AIO bus clock gating configuration.
- 0: Clock off;
- 1: Clock on.";
            sw = rw; hw = r;
            reset = 0x0;
        } aio_hcken[1:1];
        field {
            name = "aio_hrst_req";
            desc = "AIO bus-side soft reset request.
- 0: Release reset;
- 1: Reset.";
            sw = rw; hw = r;
            reset = 0x0;
        } aio_hrst_req[0:0];
    } PERI_CRG35 @ 0x8c;
    reg {
        name = "PERI_CRG43";
        desc = "PERI_CRG43 is the SATA&PCIE PHY related clock and reset control register. PERI_CRG43 (offset 0x00AC, total reset 0x0000_0050; PROVEN: Hi3535 data sheet, PDF page 361, section 3.2.7).";
        field {
            name = "reserved";
            desc = "Reserved.";
            sw = r; hw = w;
            reset = 0x0;
        } reserved_31_7[31:7];
        field {
            name = "cmb_phy_mode";
            desc = "CMB PHY operating mode.
- 0: SATA;
- 1: PCIE.";
            sw = rw; hw = r;
            reset = 0x1;
        } cmb_phy_mode[6:6];
        field {
            name = "cmb_phy_refclk_sel";
            desc = "CMB PHY refclk select.
- 0: 100M.
- 1: 24M.";
            sw = rw; hw = r;
            reset = 0x0;
        } cmb_phy_refclk_sel[5:5];
        field {
            name = "cmb_phy_ref_cken";
            desc = "CMB PHY refclk gate.
- 0: Off;
- 1: On.";
            sw = rw; hw = r;
            reset = 0x1;
        } cmb_phy_ref_cken[4:4];
        field {
            name = "sata_phy1_refclk_sel";
            desc = "SATA PHY1 refclk select.
- 0: 100M;
- 1: 24M.";
            sw = rw; hw = r;
            reset = 0x0;
        } sata_phy1_refclk_sel[3:3];
        field {
            name = "sata_phy1_ref_cken";
            desc = "SATA PHY1 refclk gate.
- 0: Off.
- 1: On.";
            sw = rw; hw = r;
            reset = 0x0;
        } sata_phy1_ref_cken[2:2];
        field {
            name = "sata_phy0_refclk_sel";
            desc = "SATA PHY0 refclk select.
- 0: 100M;
- 1: 24M.";
            sw = rw; hw = r;
            reset = 0x0;
        } sata_phy0_refclk_sel[1:1];
        field {
            name = "sata_phy0_ref_cken";
            desc = "SATA PHY0 refclk gate.
- 0: Off;
- 1: On.";
            sw = rw; hw = r;
            reset = 0x0;
        } sata_phy0_ref_cken[0:0];
    } PERI_CRG43 @ 0xac;
    reg {
        name = "PERI_CRG44";
        desc = "PERI_CRG44 is the PCIE-related clock and soft reset control register. PERI_CRG44 (offset 0x00B0, total reset 0x0000_07B0; PROVEN: Hi3535 data sheet, PDF page 362, section 3.2.7).";
        field {
            name = "reserved";
            desc = "Reserved.";
            sw = r; hw = w;
            reset = 0x0;
        } reserved_31_14[31:14];
        field {
            name = "pcie_cko_alive_srst_req";
            desc = "pciectrl cko_alive soft reset request.
- 0: No reset;
- 1: Reset.";
            sw = rw; hw = r;
            reset = 0x0;
        } pcie_cko_alive_srst_req[13:13];
        field {
            name = "pcie_bus_srst_req";
            desc = "PCIECTRL bus soft reset request.
- 0: No reset;
- 1: Reset.";
            sw = rw; hw = r;
            reset = 0x0;
        } pcie_bus_srst_req[12:12];
        field {
            name = "reserved";
            desc = "Reserved.";
            sw = r; hw = w;
            reset = 0x0;
        } reserved_11_11[11:11];
        field {
            name = "pcie_refclk_cken";
            desc = "PCIE refclk clock gating.
- 0: Off;
- 1: On.";
            sw = rw; hw = r;
            reset = 0x1;
        } pcie_refclk_cken[10:10];
        field {
            name = "pcie_mpll_dword_cken";
            desc = "PCIECTRL mpll_dword clock gating.
- 0: Off;
- 1: On.";
            sw = r; hw = w;
            reset = 0x1;
        } pcie_mpll_dword_cken[9:9];
        field {
            name = "pcie_cko_alive_cken";
            desc = "PCIECTRL cko_alive clock gate.
- 0: Off;
- 1: On.";
            sw = rw; hw = r;
            reset = 0x1;
        } pcie_cko_alive_cken[8:8];
        field {
            name = "pcie_aux_cken";
            desc = "PCIECTRL aux clock gating.
- 0: Off;
- 1: On.";
            sw = rw; hw = r;
            reset = 0x1;
        } pcie_aux_cken[7:7];
        field {
            name = "reserved";
            desc = "Reserved.";
            sw = r; hw = w;
            reset = 0x0;
        } reserved_6_6[6:6];
        field {
            name = "pcie_rx0_cken";
            desc = "PCIECTRL rx clock gate.
- 0: Off.
- 1: On.";
            sw = rw; hw = r;
            reset = 0x1;
        } pcie_rx0_cken[5:5];
        field {
            name = "pcie_bus_cken";
            desc = "PCIECTRL bus clock gating.
- 0: Off;
- 1: On.";
            sw = rw; hw = r;
            reset = 0x1;
        } pcie_bus_cken[4:4];
        field {
            name = "reserved";
            desc = "Reserved.";
            sw = r; hw = w;
            reset = 0x0;
        } reserved_3_0[3:0];
    } PERI_CRG44 @ 0xb0;
    reg {
        name = "PERI_CRG45";
        desc = "PERI_CRG45 is the SATA clock and reset control register. PERI_CRG45 (offset 0x00B4, total reset 0x0000_0000; PROVEN: Hi3535 data sheet, PDF page 364, section 3.2.7).";
        field {
            name = "reserved";
            desc = "Reserved.";
            sw = r; hw = w;
            reset = 0x0;
        } reserved_31_20[31:20];
        field {
            name = "sata_refclk2_cken";
            desc = "SATA ctrl Port 2 refclk clock gate.
- 0: Off.
- 1: On.";
            sw = rw; hw = r;
            reset = 0x0;
        } sata_refclk2_cken[19:19];
        field {
            name = "sata_mpll_dword2_cken";
            desc = "SATA ctrl Port 2 mpll_dword clock gate.
- 0: Off;
- 1: On.";
            sw = rw; hw = r;
            reset = 0x0;
        } sata_mpll_dword2_cken[18:18];
        field {
            name = "sata_refclk1_cken";
            desc = "SATA ctrl Port 1 refclk clock gating.
- 0: Off;
- 1: On.";
            sw = rw; hw = r;
            reset = 0x0;
        } sata_refclk1_cken[17:17];
        field {
            name = "sata_mpll_dword1_cken";
            desc = "SATA ctrl Port 1 mpll_dword clock gate.
- 0: Off.
- 1: On.";
            sw = rw; hw = r;
            reset = 0x0;
        } sata_mpll_dword1_cken[16:16];
        field {
            name = "reserved";
            desc = "Reserved.";
            sw = r; hw = w;
            reset = 0x0;
        } reserved_15_14[15:14];
        field {
            name = "sata_cko_alive_srst_req";
            desc = "SATA ctrl cko_alive soft reset request.
- 0: No reset;
- 1: Reset.";
            sw = rw; hw = r;
            reset = 0x0;
        } sata_cko_alive_srst_req[13:13];
        field {
            name = "sata_bus_srst_req";
            desc = "SATA ctrl bus soft reset request.
- 0: No reset;
- 1: Reset.";
            sw = rw; hw = r;
            reset = 0x0;
        } sata_bus_srst_req[12:12];
        field {
            name = "reserved";
            desc = "Reserved.";
            sw = r; hw = w;
            reset = 0x0;
        } reserved_11_11[11:11];
        field {
            name = "sata_refclk0_cken";
            desc = "SATA ctrl Port 0 refclk clock gating.
- 0: Off;
- 1: On.";
            sw = rw; hw = r;
            reset = 0x0;
        } sata_refclk0_cken[10:10];
        field {
            name = "sata_mpll_dword0_cken";
            desc = "SATA ctrl Port 0 mpll_dword clock gate.
- 0: Off;
- 1: On.";
            sw = rw; hw = r;
            reset = 0x0;
        } sata_mpll_dword0_cken[9:9];
        field {
            name = "sata_cko_alive_cken";
            desc = "SATA ctrl cko_alive clock gate.
- 0: Off;
- 1: On.";
            sw = rw; hw = r;
            reset = 0x0;
        } sata_cko_alive_cken[8:8];
        field {
            name = "sata_rx2_cken";
            desc = "SATA ctrl rx2 clock gate.
- 0: Off;
- 1: On.";
            sw = rw; hw = r;
            reset = 0x0;
        } sata_rx2_cken[7:7];
        field {
            name = "sata_rx1_cken";
            desc = "SATA ctrl rx1 clock gate.
- 0: Off.
- 1: On.";
            sw = rw; hw = r;
            reset = 0x0;
        } sata_rx1_cken[6:6];
        field {
            name = "sata_rx0_cken";
            desc = "SATA ctrl rx0 clock gating.
- 0: Off;
- 1: On.";
            sw = rw; hw = r;
            reset = 0x0;
        } sata_rx0_cken[5:5];
        field {
            name = "sata_bus_cken";
            desc = "SATA ctrl bus clock gate.
- 0: Off.
- 1: On.";
            sw = rw; hw = r;
            reset = 0x0;
        } sata_bus_cken[4:4];
        field {
            name = "reserved";
            desc = "Reserved.";
            sw = r; hw = w;
            reset = 0x0;
        } reserved_3_0[3:0];
    } PERI_CRG45 @ 0xb4;
    reg {
        name = "PERI_CRG46";
        desc = "PERI_CRG46 is the clock and soft reset control register related to USB2 and USB3. PERI_CRG46 (offset 0x00B8, total reset 0x0FF0_F0FF; PROVEN: Hi3535 data sheet, PDF page 366, section 3.2.7).";
        field {
            name = "reserved";
            desc = "Reserved.";
            sw = r; hw = w;
            reset = 0x0;
        } reserved_31_28[31:28];
        field {
            name = "usb3_utmi_cken";
            desc = "usb3ctrl utmi clock gate.
- 0: Off.
- 1: On.";
            sw = rw; hw = r;
            reset = 0x1;
        } usb3_utmi_cken[27:27];
        field {
            name = "usb3_pcs_ref_cken";
            desc = "usb3ctrl pcs_ref clock gate.
- 0: Off;
- 1: On.";
            sw = rw; hw = r;
            reset = 0x1;
        } usb3_pcs_ref_cken[26:26];
        field {
            name = "usb3_mpll_dword_cken";
            desc = "usb3ctrl dword clock gating.
- 0: Off;
- 1: On.";
            sw = rw; hw = r;
            reset = 0x1;
        } usb3_mpll_dword_cken[25:25];
        field {
            name = "usb3_mpll_qword_cken";
            desc = "usb3ctrl qword clock gating.
- 0: Off;
- 1: On.";
            sw = rw; hw = r;
            reset = 0x1;
        } usb3_mpll_qword_cken[24:24];
        field {
            name = "usb3_rx_cken";
            desc = "usb3ctrl rx clock gate.
- 0: Off;
- 1: On.";
            sw = rw; hw = r;
            reset = 0x1;
        } usb3_rx_cken[23:23];
        field {
            name = "usb3_suspend_cken";
            desc = "usb3ctrl suspend clock gating.
- 0: Off;
- 1: On.";
            sw = rw; hw = r;
            reset = 0x1;
        } usb3_suspend_cken[22:22];
        field {
            name = "usb3_ref_cken";
            desc = "usb3ctrl ref clock gating.
- 0: Off;
- 1: On.";
            sw = rw; hw = r;
            reset = 0x1;
        } usb3_ref_cken[21:21];
        field {
            name = "usb3_bus_cken";
            desc = "usb3ctrl bus clock gate.
- 0: Off;
- 1: On.";
            sw = rw; hw = r;
            reset = 0x1;
        } usb3_bus_cken[20:20];
        field {
            name = "reserved";
            desc = "Reserved.";
            sw = r; hw = w;
            reset = 0x0;
        } reserved_19_19[19:19];
        field {
            name = "usb3_ref_ssp_en";
            desc = "usb3phy superspeed domain clock enable.
- 0: Off;
- 1: On.";
            sw = rw; hw = r;
            reset = 0x0;
        } usb3_ref_ssp_en[18:18];
        field {
            name = "usb3_ref_use_pad";
            desc = "usb3phy reference clock selection.
- 0: Internal CRG;
- 1: Pad.";
            sw = rw; hw = r;
            reset = 0x0;
        } usb3_ref_use_pad[17:17];
        field {
            name = "usb3_phy_refclk_sel";
            desc = "usb3phy refclk select.
- 0: Crystal clock;
- 1: Internal 100M clock.";
            sw = rw; hw = r;
            reset = 0x0;
        } usb3_phy_refclk_sel[16:16];
        field {
            name = "usb3_phy_ref_cken";
            desc = "usb3phy refclk gating.
- 0: Off;
- 1: On.";
            sw = rw; hw = r;
            reset = 0x1;
        } usb3_phy_ref_cken[15:15];
        field {
            name = "usb3_phy_srst_treq";
            desc = "usb3phy tpor soft reset request.
- 0: No reset.
- 1: Reset.";
            sw = rw; hw = r;
            reset = 0x1;
        } usb3_phy_srst_treq[14:14];
        field {
            name = "usb3_phy_srst_req";
            desc = "usb3phy por soft reset request.
- 0: No reset.
- 1: Reset.";
            sw = rw; hw = r;
            reset = 0x1;
        } usb3_phy_srst_req[13:13];
        field {
            name = "usb3_vcc_srst_req";
            desc = "usb3ctrl vcc soft reset request.
- 0: No reset;
- 1: Reset.";
            sw = rw; hw = r;
            reset = 0x1;
        } usb3_vcc_srst_req[12:12];
        field {
            name = "reserved";
            desc = "Reserved.";
            sw = r; hw = w;
            reset = 0x0;
        } reserved_11_8[11:8];
        field {
            name = "usb2_cken";
            desc = "USB PHY reference clock gate.
- 0: Off.
- 1: On.";
            sw = rw; hw = r;
            reset = 0x1;
        } usb2_cken[7:7];
        field {
            name = "usb2_ctrl_utmi1_req";
            desc = "USB2 controller port1 soft reset request.
- 0: Release reset;
- 1: Reset.";
            sw = rw; hw = r;
            reset = 0x1;
        } usb2_ctrl_utmi1_req[6:6];
        field {
            name = "usb2_ctrl_utmi0_req";
            desc = "Soft reset request of USB2 controller port0.
- 0: Release reset;
- 1: Reset.";
            sw = rw; hw = r;
            reset = 0x1;
        } usb2_ctrl_utmi0_req[5:5];
        field {
            name = "usb2_ctrl_hub_req";
            desc = "Soft reset request of the USB2 controller hub.
- 0: Deassert reset;
- 1: Reset.";
            sw = rw; hw = r;
            reset = 0x1;
        } usb2_ctrl_hub_req[4:4];
        field {
            name = "usb2phy_port1_treq";
            desc = "Soft reset request of USB2 PHY PORT1.
- 0: Deassert reset;
- 1: Reset.";
            sw = rw; hw = r;
            reset = 0x1;
        } usb2phy_port1_treq[3:3];
        field {
            name = "usb2phy_port0_treq";
            desc = "Soft reset request for USB2 PHY PORT0.
- 0: Deassert reset;
- 1: Reset.";
            sw = rw; hw = r;
            reset = 0x1;
        } usb2phy_port0_treq[2:2];
        field {
            name = "usb2phy_req";
            desc = "Soft reset request for the USB2 PHY.
- 0: Deassert reset;
- 1: Reset.";
            sw = rw; hw = r;
            reset = 0x1;
        } usb2phy_req[1:1];
        field {
            name = "usb2_ahb_srst_req";
            desc = "USB2 controller bus soft reset request.
- 0: Deassert reset.
- 1: Reset.";
            sw = rw; hw = r;
            reset = 0x1;
        } usb2_ahb_srst_req[0:0];
    } PERI_CRG46 @ 0xb8;
    reg {
        name = "PERI_CRG48";
        desc = "PERI_CRG48 is the clock and soft reset control register related to SFC. PERI_CRG48 (offset 0x00C0, total reset 0x0000_0002; PROVEN: Hi3535 data sheet, PDF page 368, section 3.2.7).";
        field {
            name = "reserved";
            desc = "Reserved.";
            sw = r; hw = w;
            reset = 0x0;
        } reserved_31_4[31:4];
        field {
            name = "sfc_cksel";
            desc = "SFC2X clock source select.
- 00: 24M clock.
- 01: 83M clock. 1X: 125M clock.";
            sw = rw; hw = r;
            reset = 0x0;
        } sfc_cksel[3:2];
        field {
            name = "sfc_cken";
            desc = "SFC clock gating configuration.
- 0: Turn off the clock;
- 1: Turn on the clock.";
            sw = rw; hw = r;
            reset = 0x1;
        } sfc_cken[1:1];
        field {
            name = "sfc_srst_req";
            desc = "Soft reset request of the SFC.
- 0: Release reset.
- 1: Reset.";
            sw = rw; hw = r;
            reset = 0x0;
        } sfc_srst_req[0:0];
    } PERI_CRG48 @ 0xc0;
    reg {
        name = "PERI_CRG50";
        desc = "PERI_CRG50 is the clock and soft reset control register related to the TOE and GMAC interfaces. PERI_CRG50 (offset 0x00C8, total reset 0x0000_00AA; PROVEN: Hi3535 data sheet, PDF page 369, section 3.2.7).";
        field {
            name = "reserved";
            desc = "Reserved.";
            sw = r; hw = w;
            reset = 0x0;
        } reserved_31_12[31:12];
        field {
            name = "toe_cksel";
            desc = "TOE clock select.
- 0: 150MHz.
- 1: 100MHz.";
            sw = rw; hw = r;
            reset = 0x0;
        } toe_cksel[11:11];
        field {
            name = "ext_fephy_cksel";
            desc = "External FE PHY clock select.
- 0: 25M.
- 1: 50M.";
            sw = rw; hw = r;
            reset = 0x0;
        } ext_fephy_cksel[10:10];
        field {
            name = "rmii1_cksel";
            desc = "RMII1 clock select.
- 0: Select the CRG clock;
- 1: Select the PAD input.";
            sw = rw; hw = r;
            reset = 0x0;
        } rmii1_cksel[9:9];
        field {
            name = "rmii0_cksel";
            desc = "RMII0 clock select.
- 0: Select the CRG clock;
- 1: Select the PAD input.";
            sw = rw; hw = r;
            reset = 0x0;
        } rmii0_cksel[8:8];
        field {
            name = "gmac1_if_cken";
            desc = "GMAC1_IF clock gate configuration.
- 0: Turn off the clock;
- 1: Turn on the clock.";
            sw = rw; hw = r;
            reset = 0x1;
        } gmac1_if_cken[7:7];
        field {
            name = "gmac1_if_srst_req";
            desc = "Soft reset request of GMAC1_IF.
- 0: Deassert reset.
- 1: Reset.";
            sw = rw; hw = r;
            reset = 0x0;
        } gmac1_if_srst_req[6:6];
        field {
            name = "gmac0_if_cken";
            desc = "GMAC0_IF clock gate configuration.
- 0: Turn off the clock;
- 1: Turn on the clock.";
            sw = rw; hw = r;
            reset = 0x1;
        } gmac0_if_cken[5:5];
        field {
            name = "gmac0_if_srst_req";
            desc = "Soft reset request for GMAC0_IF.
- 0: Deassert reset;
- 1: Reset.";
            sw = rw; hw = r;
            reset = 0x0;
        } gmac0_if_srst_req[4:4];
        field {
            name = "toe_hcken";
            desc = "TOE bus clock gate configuration.
- 0: Clock off.
- 1: Clock on.";
            sw = rw; hw = r;
            reset = 0x1;
        } toe_hcken[3:3];
        field {
            name = "toe_hrst_req";
            desc = "Bus soft reset request for TOE.
- 0: Deassert reset;
- 1: Reset.";
            sw = rw; hw = r;
            reset = 0x0;
        } toe_hrst_req[2:2];
        field {
            name = "toe_cken";
            desc = "TOE clock gating configuration.
- 0: Turn off the clock;
- 1: Turn on the clock.";
            sw = rw; hw = r;
            reset = 0x1;
        } toe_cken[1:1];
        field {
            name = "toe_srst_req";
            desc = "Soft reset request of the TOE.
- 0: Release reset.
- 1: Reset.";
            sw = rw; hw = r;
            reset = 0x0;
        } toe_srst_req[0:0];
    } PERI_CRG50 @ 0xc8;
    reg {
        name = "PERI_CRG52";
        desc = "PERI_CRG52 is the NandC-related clock and soft reset control register. PERI_CRG52 (offset 0x00D0, total reset 0x0000_0002; PROVEN: Hi3535 data sheet, PDF page 371, section 3.2.7).";
        field {
            name = "reserved";
            desc = "Reserved.";
            sw = r; hw = w;
            reset = 0x0;
        } reserved_31_3[31:3];
        field {
            name = "nfc_cksel";
            desc = "NFC clock source select.
- 0: 24M clock;
- 1: 200M clock.";
            sw = rw; hw = r;
            reset = 0x0;
        } nfc_cksel[2:2];
        field {
            name = "nfc_cken";
            desc = "NFC clock gate configuration.
- 0: Clock off;
- 1: Clock on.";
            sw = rw; hw = r;
            reset = 0x1;
        } nfc_cken[1:1];
        field {
            name = "nfc_srst_req";
            desc = "Soft reset request of the NFC.
- 0: Release reset;
- 1: Reset.";
            sw = rw; hw = r;
            reset = 0x0;
        } nfc_srst_req[0:0];
    } PERI_CRG52 @ 0xd0;
    reg {
        name = "PERI_CRG54";
        desc = "PERI_CRG54 is the DDRTEST-related clock and soft reset control register. PERI_CRG54 (offset 0x00D8, total reset 0x0000_0002; PROVEN: Hi3535 data sheet, PDF page 371, section 3.2.7).";
        field {
            name = "reserved";
            desc = "Reserved.";
            sw = r; hw = w;
            reset = 0x0;
        } reserved_31_4[31:4];
        field {
            name = "ddrtest_cken";
            desc = "DDRTEST clock gate configuration.
- 0: Turn off the clock;
- 1: Turn on the clock.";
            sw = rw; hw = r;
            reset = 0x0;
        } ddrtest_cken[3:3];
        field {
            name = "ddrtest_srst_req";
            desc = "Soft reset request of the DDRTEST.
- 0: Deassert reset.
- 1: Reset.";
            sw = rw; hw = r;
            reset = 0x0;
        } ddrtest_srst_req[2:2];
        field {
            name = "reserved";
            desc = "Reserved.";
            sw = r; hw = w;
            reset = 0x2;
        } reserved_1_0[1:0];
    } PERI_CRG54 @ 0xd8;
    reg {
        name = "PERI_CRG56";
        desc = "PERI_CRG56 is the clock and soft reset control register related to DMA. PERI_CRG56 (offset 0x00E0, total reset 0x0000_0008; PROVEN: Hi3535 data sheet, PDF page 372, section 3.2.7).";
        field {
            name = "reserved";
            desc = "Reserved.";
            sw = r; hw = w;
            reset = 0x2;
        } reserved_31_2[31:2];
        field {
            name = "dma_cken";
            desc = "DMA clock gate configuration.
- 0: Turn off the clock;
- 1: Turn on the clock.";
            sw = rw; hw = r;
            reset = 0x0;
        } dma_cken[1:1];
        field {
            name = "dma_srst_req";
            desc = "Soft reset request of the DMA.
- 0: Release reset;
- 1: Reset.";
            sw = rw; hw = r;
            reset = 0x0;
        } dma_srst_req[0:0];
    } PERI_CRG56 @ 0xe0;
    reg {
        name = "PERI_CRG57";
        desc = "PERI_CRG57 is the soft reset control register for other CRG interface modules. PERI_CRG57 (offset 0x00E4, total reset 0x000F_F001; PROVEN: Hi3535 data sheet, PDF page 373, section 3.2.7).";
        field {
            name = "reserved";
            desc = "Reserved.";
            sw = r; hw = w;
            reset = 0x0;
        } reserved_31_20[31:20];
        field {
            name = "uart_cksel";
            desc = "UART clock select.
- 0: Select the APB clock.
- 1: Select the 2M clock.";
            sw = rw; hw = r;
            reset = 0x1;
        } uart_cksel[19:19];
        field {
            name = "uart3_cken";
            desc = "UART3 clock gate.
- 0: Clock off.
- 1: Clock on.";
            sw = rw; hw = r;
            reset = 0x1;
        } uart3_cken[18:18];
        field {
            name = "uart2_cken";
            desc = "UART2 clock gating.
- 0: Clock off;
- 1: Clock on.";
            sw = rw; hw = r;
            reset = 0x1;
        } uart2_cken[17:17];
        field {
            name = "uart1_cken";
            desc = "UART1 clock gate.
- 0: Clock off;
- 1: Clock on.";
            sw = rw; hw = r;
            reset = 0x1;
        } uart1_cken[16:16];
        field {
            name = "uart0_cken";
            desc = "UART0 clock gate.
- 0: Clock off.
- 1: Clock on.";
            sw = rw; hw = r;
            reset = 0x1;
        } uart0_cken[15:15];
        field {
            name = "ssp1_cken";
            desc = "SSP1 clock gate.
- 0: Turn the clock off.
- 1: Turn the clock on.";
            sw = rw; hw = r;
            reset = 0x1;
        } ssp1_cken[14:14];
        field {
            name = "ssp0_cken";
            desc = "SSP0 clock gate.
- 0: Turn the clock off.
- 1: Turn the clock on.";
            sw = rw; hw = r;
            reset = 0x1;
        } ssp0_cken[13:13];
        field {
            name = "ir_cken";
            desc = "IR clock gate.
- 0: Clock off;
- 1: Clock on.";
            sw = rw; hw = r;
            reset = 0x1;
        } ir_cken[12:12];
        field {
            name = "reserved";
            desc = "Reserved.";
            sw = r; hw = w;
            reset = 0x0;
        } reserved_11_11[11:11];
        field {
            name = "uart3_srst_req";
            desc = "Soft reset request of UART3.
- 0: Release reset;
- 1: Reset.";
            sw = rw; hw = r;
            reset = 0x0;
        } uart3_srst_req[10:10];
        field {
            name = "uart2_srst_req";
            desc = "Soft reset request of UART2.
- 0: Deassert reset;
- 1: Reset.";
            sw = rw; hw = r;
            reset = 0x0;
        } uart2_srst_req[9:9];
        field {
            name = "uart1_srst_req";
            desc = "Soft reset request of UART1.
- 0: Deassert reset.
- 1: Reset.";
            sw = rw; hw = r;
            reset = 0x0;
        } uart1_srst_req[8:8];
        field {
            name = "uart0_srst_req";
            desc = "Soft reset request of UART0.
- 0: Release reset;
- 1: Reset.";
            sw = rw; hw = r;
            reset = 0x0;
        } uart0_srst_req[7:7];
        field {
            name = "ssp1_srst_req";
            desc = "SSP1 soft reset request.
- 0: Release reset;
- 1: Reset.";
            sw = rw; hw = r;
            reset = 0x0;
        } ssp1_srst_req[6:6];
        field {
            name = "ssp0_srst_req";
            desc = "Soft reset request of SSP0.
- 0: Deassert reset;
- 1: Reset.";
            sw = rw; hw = r;
            reset = 0x0;
        } ssp0_srst_req[5:5];
        field {
            name = "ir_srst_req";
            desc = "Soft reset request of the IR.
- 0: Release reset;
- 1: Reset.";
            sw = rw; hw = r;
            reset = 0x0;
        } ir_srst_req[4:4];
        field {
            name = "reserved";
            desc = "Reserved.";
            sw = r; hw = w;
            reset = 0x0;
        } reserved_3_3[3:3];
        field {
            name = "tcap_srst_req";
            desc = "Soft reset request of t_cap.
- 0: Deassert reset;
- 1: Reset.";
            sw = rw; hw = r;
            reset = 0x0;
        } tcap_srst_req[2:2];
        field {
            name = "i2c_srst_req";
            desc = "Soft reset request of the I2C.
- 0: Deassert reset.
- 1: Reset.";
            sw = rw; hw = r;
            reset = 0x0;
        } i2c_srst_req[1:1];
        field {
            name = "test_clk_en";
            desc = "Test clock enable register.
- 0: All test clocks off;
- 1: All test clocks on.";
            sw = rw; hw = r;
            reset = 0x1;
        } test_clk_en[0:0];
    } PERI_CRG57 @ 0xe4;
    reg {
        name = "PERI_CRG58";
        desc = "PERI_CRG58 is the CRG status register. PERI_CRG58 (offset 0x00E8, total reset 0x0000_0000; PROVEN: Hi3535 data sheet, PDF page 375, section 3.2.7).";
        field {
            name = "reserved";
            desc = "Reserved.";
            sw = r; hw = w;
            reset = 0x0;
        } reserved_31_20[31:20];
        field {
            name = "reserved";
            desc = "Reserved.";
            sw = r; hw = w;
            reset = 0x0;
        } reserved_19_6[19:6];
        field {
            name = "epll_lock";
            desc = "EPLL LOCK status.
- 0: Unlock.
- 1: Locked.";
            sw = r; hw = w;
            reset = 0x0;
        } epll_lock[5:5];
        field {
            name = "vpll2_lock";
            desc = "VPLL2 LOCK status.
- 0: Unlock.
- 1: Locked.";
            sw = r; hw = w;
            reset = 0x0;
        } vpll2_lock[4:4];
        field {
            name = "vpll1_lock";
            desc = "VPLL1 LOCK status.
- 0: Unlock;
- 1: Locked.";
            sw = r; hw = w;
            reset = 0x0;
        } vpll1_lock[3:3];
        field {
            name = "vpll0_lock";
            desc = "VPLL0 LOCK status.
- 0: Unlock;
- 1: Locked.";
            sw = r; hw = w;
            reset = 0x0;
        } vpll0_lock[2:2];
        field {
            name = "bpll_lock";
            desc = "BPLL LOCK status.
- 0: Unlock.
- 1: Locked.";
            sw = r; hw = w;
            reset = 0x0;
        } bpll_lock[1:1];
        field {
            name = "apll_lock";
            desc = "APLL LOCK status.
- 0: Unlocked;
- 1: Locked.";
            sw = r; hw = w;
            reset = 0x0;
        } apll_lock[0:0];
    } PERI_CRG58 @ 0xe8;
    reg {
        name = "PERI_CRG59";
        desc = "PERI_CRG59 is the GMAC interface control register. Before changing the mode configuration, first reset mac_if so that mac_if latches the newly modified state at the moment reset is deasserted, which completes the mode change. The default operating mode is RGMII. PERI_CRG59 (offset 0x00EC, total reset 0x003F_003F; PROVEN: Hi3535 data sheet, PDF page 376, section 3.2.7).";
        field {
            name = "reserved";
            desc = "Reserved. The data sheet row is [31:22] (RW), which overlaps gmac1_phy_select [23:21]; the upper bits [31:24] are INFERRED from the field layout (the total reset value 0x003F_003F leaves bits 31:24 at 0).";
            sw = rw; hw = r;
            reset = 0x0;
        } reserved_31_24[31:24];
        field {
            name = "gmac1_phy_select";
            desc = "GMAC1 PHY interface mode.
- 000: GMII/MII mode;
- 001: RGMII mode;
- 100: RMII mode;
Others: Reserved.";
            sw = rw; hw = r;
            reset = 0x1;
        } gmac1_phy_select[23:21];
        field {
            name = "gmac1_duplex_mode";
            desc = "GMAC1 PHY duplex mode.
- 0: Half Duplex mode.
- 1: Full Duplex mode.";
            sw = rw; hw = r;
            reset = 0x1;
        } gmac1_duplex_mode[20:20];
        field {
            name = "gmac1_tx_config";
            desc = "GMAC1 transmit configuration enable signal.
- 0: Tx Config Disable;
- 1: Tx Config Enable.";
            sw = rw; hw = r;
            reset = 0x1;
        } gmac1_tx_config[19:19];
        field {
            name = "gmac1_link_status";
            desc = "GMAC1 PHY link status control.
- 0: Link Down.
- 1: Link Up.";
            sw = rw; hw = r;
            reset = 0x1;
        } gmac1_link_status[18:18];
        field {
            name = "gmac1_mac_speed";
            desc = "GMAC1 10/100 Mbps mode.
- 0: 10 Mbps.
- 1: 100 Mbps.";
            sw = rw; hw = r;
            reset = 0x1;
        } gmac1_mac_speed[17:17];
        field {
            name = "gmac1_port_select";
            desc = "GMAC1 gigabit select enable.
- 0: 1000Mbps.
- 1: 10/100Mbps.";
            sw = rw; hw = r;
            reset = 0x1;
        } gmac1_port_select[16:16];
        field {
            name = "reserved";
            desc = "Reserved.";
            sw = rw; hw = r;
            reset = 0x0;
        } reserved_15_8[15:8];
        field {
            name = "gmac0_phy_select";
            desc = "GMAC0 PHY interface mode.
- 000: GMII/MII mode;
- 001: RGMII mode;
- 100: RMII mode; Others: Reserved.";
            sw = rw; hw = r;
            reset = 0x1;
        } gmac0_phy_select[7:5];
        field {
            name = "gmac0_duplex_mode";
            desc = "GMAC0 PHY duplex mode.
- 0: Half Duplex mode;
- 1: Full Duplex mode.";
            sw = rw; hw = r;
            reset = 0x1;
        } gmac0_duplex_mode[4:4];
        field {
            name = "gmac0_tx_config";
            desc = "GMAC0 transmit configuration enable signal.
- 0: Tx Config Disable;
- 1: Tx Config Enable.";
            sw = rw; hw = r;
            reset = 0x1;
        } gmac0_tx_config[3:3];
        field {
            name = "gmac0_link_status";
            desc = "GMAC0 PHY link status control.
- 0: Link Down;
- 1: Link Up.";
            sw = rw; hw = r;
            reset = 0x1;
        } gmac0_link_status[2:2];
        field {
            name = "gmac0_mac_speed";
            desc = "GMAC0 10/100 Mbps mode.
- 0: 10 Mbps.
- 1: 100 Mbps.";
            sw = rw; hw = r;
            reset = 0x1;
        } gmac0_mac_speed[1:1];
        field {
            name = "gmac0_port_select";
            desc = "GMAC0 gigabit select enable.
- 0: 1000Mbps;
- 1: 10/100Mbps.";
            sw = rw; hw = r;
            reset = 0x1;
        } gmac0_port_select[0:0];
    } PERI_CRG59 @ 0xec;
    reg {
        name = "PERI_CRG60";
        desc = "PERI_CRG60 is the GMAC interface status register. This status information is valid only in RGMII mode; in other modes its value is undefined. PERI_CRG60 (offset 0x00F0, total reset 0x0000_0000; PROVEN: Hi3535 data sheet, PDF page 378, section 3.2.7).";
        field {
            name = "reserved";
            desc = "Reserved.";
            sw = r; hw = w;
            reset = 0x0;
        } reserved_31_20[31:20];
        field {
            name = "gmac1_phy_link_status";
            desc = "GMAC1 PHY link status.
- 0: Link Down;
- 1: Link Up.";
            sw = r; hw = w;
            reset = 0x0;
        } gmac1_phy_link_status[19:19];
        field {
            name = "gmac1_phy_link_speed";
            desc = "GMAC1 PHY connection clock frequency.
- 00: 2.5MHz;
- 01: 25MHz;
- 10: 125MHz;
- 11: reserved.";
            sw = r; hw = w;
            reset = 0x0;
        } gmac1_phy_link_speed[18:17];
        field {
            name = "gmac1_phy_link_mode";
            desc = "GMAC1 PHY link duplex mode.
- 0: half duplex mode;
- 1: full duplex mode.";
            sw = r; hw = w;
            reset = 0x0;
        } gmac1_phy_link_mode[16:16];
        field {
            name = "reserved";
            desc = "Reserved.";
            sw = r; hw = w;
            reset = 0x0;
        } reserved_15_4[15:4];
        field {
            name = "gmac0_phy_link_status";
            desc = "GMAC0 PHY link status.
- 0: Link Down;
- 1: Link Up.";
            sw = r; hw = w;
            reset = 0x0;
        } gmac0_phy_link_status[3:3];
        field {
            name = "gmac0_phy_link_speed";
            desc = "GMAC0 PHY connection clock frequency.
- 00: 2.5 MHz.
- 01: 25 MHz.
- 10: 125 MHz.
- 11: Reserved.";
            sw = r; hw = w;
            reset = 0x0;
        } gmac0_phy_link_speed[2:1];
        field {
            name = "gmac0_phy_link_mode";
            desc = "GMAC0 PHY connection duplex mode.
- 0: half duplex mode;
- 1: full duplex mode.";
            sw = r; hw = w;
            reset = 0x0;
        } gmac0_phy_link_mode[0:0];
    } PERI_CRG60 @ 0xf0;
    reg {
        name = "PERI_CRG61";
        desc = "PERI_CRG61 is the VDH reset status register. PERI_CRG61 (offset 0x00F4, total reset 0x0000_0000; PROVEN: Hi3535 data sheet, PDF page 379, section 3.2.7).";
        field {
            name = "reserved";
            desc = "Reserved.";
            sw = r; hw = w;
            reset = 0x0;
        } reserved_31_7[31:7];
        field {
            name = "vdh0_scd_srst_ok";
            desc = "VDH0 SCD reset status.";
            sw = r; hw = w;
            reset = 0x0;
        } vdh0_scd_srst_ok[6:6];
        field {
            name = "vdh0_mfd_srst_ok";
            desc = "VDH0 MFD reset status.";
            sw = r; hw = w;
            reset = 0x0;
        } vdh0_mfd_srst_ok[5:5];
        field {
            name = "vdh0_all_srst_ok";
            desc = "VDH0 ALL reset status.";
            sw = r; hw = w;
            reset = 0x0;
        } vdh0_all_srst_ok[4:4];
        field {
            name = "reserved";
            desc = "Reserved.";
            sw = r; hw = w;
            reset = 0x0;
        } reserved_3_3[3:3];
        field {
            name = "vdh1_scd_srst_ok";
            desc = "VDH1 SCD reset status.";
            sw = r; hw = w;
            reset = 0x0;
        } vdh1_scd_srst_ok[2:2];
        field {
            name = "vdh1_mfd_srst_ok";
            desc = "VDH1 MFD reset status.";
            sw = r; hw = w;
            reset = 0x0;
        } vdh1_mfd_srst_ok[1:1];
        field {
            name = "vdh1_all_srst_ok";
            desc = "VDH1 ALL reset status.";
            sw = r; hw = w;
            reset = 0x0;
        } vdh1_all_srst_ok[0:0];
    } PERI_CRG61 @ 0xf4;
    reg {
        name = "PERI_CRG67";
        desc = "PERI_CRG67 is the BPLL spread spectrum configuration register. PERI_CRG67 (offset 0x010C, total reset 0x0000_0004; PROVEN: Hi3535 data sheet, PDF page 380, section 3.2.7).";
        field {
            name = "reserved";
            desc = "Reserved.";
            sw = rw; hw = r;
            reset = 0x0;
        } reserved_31_12[31:12];
        field {
            name = "bpll_ssmod_ctrl";
            desc = "ssmod divval[11:8]: SSMOD divval control. ssmod spread[6:4]: SSMOD spread control.
- 000: 0;
- 001: 0.049%;
- 010: 0.098%;
- 011: 0.195%;
- 100: 0.391%;
- 101: 0.781%;
- 110: 1.563%;
- 110: 3.125%.
ssmod downspread[3]: SSMOD downspread control.
- 0: Center spread;
- 1: Down spread.
ssmod_disable[2]: SSMOD disable control.
- 0: enable;
- 1: disable.
ssmod_rst_req[1]: SSMOD reset control.
- 0: No reset;
- 1: Reset.
ssmod_cken[0]: SSMOD clock gate, off by default.
- 0: Off;
- 1: On.";
            sw = rw; hw = r;
            reset = 0x4;
        } bpll_ssmod_ctrl[11:0];
    } PERI_CRG67 @ 0x10c;
    reg {
        name = "PERI_CRG72";
        desc = "PERI_CRG72 is VPLL2 configuration register 0. PERI_CRG72 (offset 0x0120, total reset 0x1500_0000; PROVEN: Hi3535 data sheet, PDF page 381, section 3.2.7).";
        field {
            name = "reserved";
            desc = "Reserved.";
            sw = r; hw = w;
            reset = 0x0;
        } reserved_31_31[31:31];
        field {
            name = "vpll2_postdiv2";
            desc = "VPLL2 second-stage output divider.";
            sw = rw; hw = r;
            reset = 0x1;
        } vpll2_postdiv2[30:28];
        field {
            name = "reserved";
            desc = "Reserved.";
            sw = rw; hw = r;
            reset = 0x0;
        } reserved_27_27[27:27];
        field {
            name = "vpll2_postdiv1";
            desc = "VPLL2 first-stage output divider factor.";
            sw = rw; hw = r;
            reset = 0x5;
        } vpll2_postdiv1[26:24];
        field {
            name = "vpll2_frac";
            desc = "VPLL2 fractional divider.";
            sw = rw; hw = r;
            reset = 0x0;
        } vpll2_frac[23:0];
    } PERI_CRG72 @ 0x120;
    reg {
        name = "PERI_CRG73";
        desc = "PERI_CRG73 is VPLL2 configuration register 1. PERI_CRG73 (offset 0x0124, total reset 0x0100_2087; PROVEN: Hi3535 data sheet, PDF page 381, section 3.2.7).";
        field {
            name = "reserved";
            desc = "Reserved.";
            sw = r; hw = w;
            reset = 0x0;
        } reserved_31_27[31:27];
        field {
            name = "vpll2_bypass";
            desc = "VPLL2 clock divider bypass control.
- 0: Not bypassed;
- 1: Bypassed.";
            sw = rw; hw = r;
            reset = 0x0;
        } vpll2_bypass[26:26];
        field {
            name = "vpll2_dacpd";
            desc = "VPLL2 test signal control.
- 0: Normal operation;
- 1: Power down.";
            sw = rw; hw = r;
            reset = 0x0;
        } vpll2_dacpd[25:25];
        field {
            name = "vpll2_dsmpd";
            desc = "VPLL2 fractional divider control.
- 0: Fractional mode.
- 1: Integer mode.";
            sw = rw; hw = r;
            reset = 0x1;
        } vpll2_dsmpd[24:24];
        field {
            name = "vpll2_pd";
            desc = "VPLL2 power-down control.
- 0: Normal operating state.
- 1: Power-down state.";
            sw = rw; hw = r;
            reset = 0x0;
        } vpll2_pd[23:23];
        field {
            name = "vpll2_foutvcopd";
            desc = "VPLL2 VCO output Power Down control.
- 0: Normal clock output;
- 1: No clock output.";
            sw = rw; hw = r;
            reset = 0x0;
        } vpll2_foutvcopd[22:22];
        field {
            name = "vpll2_postdivpd";
            desc = "VPLL2 POSTDIV output Power Down control.
- 0: Normal clock output;
- 1: No clock output.";
            sw = rw; hw = r;
            reset = 0x0;
        } vpll2_postdivpd[21:21];
        field {
            name = "vpll2_fout4phasepd";
            desc = "VPLL2 FOUT output Power Down control.
- 0: Normal clock output;
- 1: No clock output.";
            sw = rw; hw = r;
            reset = 0x0;
        } vpll2_fout4phasepd[20:20];
        field {
            name = "reserved";
            desc = "Reserved.";
            sw = r; hw = w;
            reset = 0x0;
        } reserved_19_18[19:18];
        field {
            name = "vpll2_refdiv";
            desc = "VPLL2 reference clock divider.";
            sw = rw; hw = r;
            reset = 0x2;
        } vpll2_refdiv[17:12];
        field {
            name = "vpll2_fbdiv";
            desc = "VPLL2 integer multiplier.";
            sw = rw; hw = r;
            reset = 0x87;
        } vpll2_fbdiv[11:0];
    } PERI_CRG73 @ 0x124;
    reg {
        name = "PERI_CRG75";
        desc = "PERI_CRG75 is CORE HPM control register 1. PERI_CRG75 (offset 0x012C, total reset 0x0000_0000; PROVEN: Hi3535 data sheet, PDF page 383, section 3.2.7).";
        field {
            name = "reserved";
            desc = "Reserved.";
            sw = r; hw = w;
            reset = 0x0;
        } reserved_31_28[31:28];
        field {
            name = "core_hpm_srst_req";
            desc = "CORE HPM reset request, active high.
- 0: Deassert reset.
- 1: Reset.";
            sw = rw; hw = r;
            reset = 0x0;
        } core_hpm_srst_req[27:27];
        field {
            name = "core_hpm_monitor_en";
            desc = "CORE HPM loop monitoring enable.
- 0: Disable.
- 1: Enable.";
            sw = rw; hw = r;
            reset = 0x0;
        } core_hpm_monitor_en[26:26];
        field {
            name = "core_hpm_bypass";
            desc = "CORE HPM loop monitor bypass.
- 0: Not bypassed;
- 1: Bypassed.";
            sw = rw; hw = r;
            reset = 0x0;
        } core_hpm_bypass[25:25];
        field {
            name = "core_hpm_en";
            desc = "Enable one CORE HPM measurement process.
- 0: This value must stay 0 before starting a process;
- 1: Start one frequency adjustment process.";
            sw = rw; hw = r;
            reset = 0x0;
        } core_hpm_en[24:24];
        field {
            name = "reserved";
            desc = "Reserved.";
            sw = r; hw = w;
            reset = 0x0;
        } reserved_23_22[23:22];
        field {
            name = "core_hpm_offset";
            desc = "CORE HPM OFFSET value.";
            sw = rw; hw = r;
            reset = 0x0;
        } core_hpm_offset[21:12];
        field {
            name = "reserved";
            desc = "Reserved.";
            sw = r; hw = w;
            reset = 0x0;
        } reserved_11_10[11:10];
        field {
            name = "core_hpm_shift";
            desc = "CORE HPM SHIFT value.";
            sw = rw; hw = r;
            reset = 0x0;
        } core_hpm_shift[9:8];
        field {
            name = "reserved";
            desc = "Reserved.";
            sw = r; hw = w;
            reset = 0x0;
        } reserved_7_6[7:6];
        field {
            name = "core_hpm_div";
            desc = "CORE HPM clock divider ratio configuration. N: divide by (n+1).";
            sw = rw; hw = r;
            reset = 0x0;
        } core_hpm_div[5:0];
    } PERI_CRG75 @ 0x12c;
    reg {
        name = "PERI_CRG76";
        desc = "PERI_CRG76 is CORE HPM status register 1. PERI_CRG76 (offset 0x0130, total reset 0x0000_0000; PROVEN: Hi3535 data sheet, PDF page 384, section 3.2.7).";
        field {
            name = "reserved";
            desc = "Reserved.";
            sw = r; hw = w;
            reset = 0x0;
        } reserved_31_26[31:26];
        field {
            name = "core_hpm_up_warning";
            desc = "CORE HPM Warning upper limit.";
            sw = r; hw = w;
            reset = 0x0;
        } core_hpm_up_warning[25:25];
        field {
            name = "core_hpm_low_warning";
            desc = "CORE HPM Warning lower limit.";
            sw = r; hw = w;
            reset = 0x0;
        } core_hpm_low_warning[24:24];
        field {
            name = "reserved";
            desc = "Reserved.";
            sw = r; hw = w;
            reset = 0x0;
        } reserved_23_22[23:22];
        field {
            name = "core_hpm_pc_record1";
            desc = "CORE HPM raw code pattern 1.";
            sw = r; hw = w;
            reset = 0x0;
        } core_hpm_pc_record1[21:12];
        field {
            name = "reserved";
            desc = "Reserved.";
            sw = r; hw = w;
            reset = 0x0;
        } reserved_11_11[11:11];
        field {
            name = "core_hpm_pc_valid";
            desc = "CORE HPM output valid indication.
- 0: invalid.
- 1: valid.";
            sw = r; hw = w;
            reset = 0x0;
        } core_hpm_pc_valid[10:10];
        field {
            name = "core_hpm_pc_record0";
            desc = "CORE HPM raw code pattern 0.";
            sw = r; hw = w;
            reset = 0x0;
        } core_hpm_pc_record0[9:0];
    } PERI_CRG76 @ 0x130;
    reg {
        name = "PERI_CRG77";
        desc = "PERI_CRG77 is CORE HPM status register 2. PERI_CRG77 (offset 0x0134, total reset 0x0000_0000; PROVEN: Hi3535 data sheet, PDF page 385, section 3.2.7).";
        field {
            name = "reserved";
            desc = "Reserved.";
            sw = r; hw = w;
            reset = 0x0;
        } reserved_31_29[31:29];
        field {
            name = "core_hpm_rcc";
            desc = "CORE HPM output has RCC code.";
            sw = r; hw = w;
            reset = 0x0;
        } core_hpm_rcc[28:24];
        field {
            name = "reserved";
            desc = "Reserved.";
            sw = r; hw = w;
            reset = 0x0;
        } reserved_23_22[23:22];
        field {
            name = "core_hpm_pc_record3";
            desc = "CORE HPM original code pattern 3.";
            sw = r; hw = w;
            reset = 0x0;
        } core_hpm_pc_record3[21:12];
        field {
            name = "reserved";
            desc = "Reserved.";
            sw = r; hw = w;
            reset = 0x0;
        } reserved_11_10[11:10];
        field {
            name = "core_hpm_pc_record2";
            desc = "CORE HPM raw code pattern 2.";
            sw = r; hw = w;
            reset = 0x0;
        } core_hpm_pc_record2[9:0];
    } PERI_CRG77 @ 0x134;
    reg {
        name = "PERI_CRG78";
        desc = "PERI_CRG78 is CORE HPM control register 2. PERI_CRG78 (offset 0x0138, total reset 0x0000_0000; PROVEN: Hi3535 data sheet, PDF page 385, section 3.2.7).";
        field {
            name = "core_hpm_monitor_period";
            desc = "CORE HPM loop monitoring period. If the configured value is N, the monitoring period is T = N x 2048/1000 ms. The maximum monitoring interval is 522ms and the minimum is 2ms.";
            sw = rw; hw = r;
            reset = 0x0;
        } core_hpm_monitor_period[31:24];
        field {
            name = "reserved";
            desc = "Reserved.";
            sw = r; hw = w;
            reset = 0x0;
        } reserved_23_22[23:22];
        field {
            name = "core_hpm_lowlimit";
            desc = "CORE HPM lower limit.";
            sw = rw; hw = r;
            reset = 0x0;
        } core_hpm_lowlimit[21:12];
        field {
            name = "reserved";
            desc = "Reserved.";
            sw = r; hw = w;
            reset = 0x0;
        } reserved_11_10[11:10];
        field {
            name = "core_hpm_uplimit";
            desc = "CORE HPM upper limit value.";
            sw = rw; hw = r;
            reset = 0x0;
        } core_hpm_uplimit[9:0];
    } PERI_CRG78 @ 0x138;
    reg {
        name = "PERI_CRG79";
        desc = "PERI_CRG79 is CPU HPM control register 1. PERI_CRG79 (offset 0x013C, total reset 0x0000_0000; PROVEN: Hi3535 data sheet, PDF page 386, section 3.2.7).";
        field {
            name = "reserved";
            desc = "Reserved.";
            sw = rw; hw = r;
            reset = 0x0;
        } reserved_31_28[31:28];
        field {
            name = "cpu_hpm_srst_req";
            desc = "CPU HPM reset request, active low.
- 0: Reset;
- 1: Deassert reset.";
            sw = rw; hw = r;
            reset = 0x0;
        } cpu_hpm_srst_req[27:27];
        field {
            name = "cpu_hpm_monitor_en";
            desc = "CPU HPM loop monitoring enable.
- 0: Disable.
- 1: Enable.";
            sw = rw; hw = r;
            reset = 0x0;
        } cpu_hpm_monitor_en[26:26];
        field {
            name = "cpu_hpm_bypass";
            desc = "CPU HPM loop monitoring bypass.
- 0: Not bypassed;
- 1: Bypassed.";
            sw = rw; hw = r;
            reset = 0x0;
        } cpu_hpm_bypass[25:25];
        field {
            name = "cpu_hpm_en";
            desc = "Enable one CPU HPM measurement process.
- 0: This value must remain 0 before a process is started;
- 1: Start one frequency adjustment process.";
            sw = rw; hw = r;
            reset = 0x0;
        } cpu_hpm_en[24:24];
        field {
            name = "reserved";
            desc = "Reserved.";
            sw = r; hw = w;
            reset = 0x0;
        } reserved_23_22[23:22];
        field {
            name = "cpu_hpm_offset";
            desc = "CPU HPM OFFSET value.";
            sw = rw; hw = r;
            reset = 0x0;
        } cpu_hpm_offset[21:12];
        field {
            name = "reserved";
            desc = "Reserved.";
            sw = r; hw = w;
            reset = 0x0;
        } reserved_11_10[11:10];
        field {
            name = "cpu_hpm_shift";
            desc = "CPU HPM SHIFT value.";
            sw = rw; hw = r;
            reset = 0x0;
        } cpu_hpm_shift[9:8];
        field {
            name = "reserved";
            desc = "Reserved.";
            sw = r; hw = w;
            reset = 0x0;
        } reserved_7_6[7:6];
        field {
            name = "cpu_hpm_div";
            desc = "HPM clock divider ratio configuration. N: divide by (n+1).";
            sw = rw; hw = r;
            reset = 0x0;
        } cpu_hpm_div[5:0];
    } PERI_CRG79 @ 0x13c;
    reg {
        name = "PERI_CRG80";
        desc = "PERI_CRG80 is CPU HPM status register 1. PERI_CRG80 (offset 0x0140, total reset 0x0000_0000; PROVEN: Hi3535 data sheet, PDF page 387, section 3.2.7).";
        field {
            name = "reserved";
            desc = "Reserved.";
            sw = r; hw = w;
            reset = 0x0;
        } reserved_31_26[31:26];
        field {
            name = "cpu_hpm_up_warning";
            desc = "CPU HPM Warning upper limit.";
            sw = r; hw = w;
            reset = 0x0;
        } cpu_hpm_up_warning[25:25];
        field {
            name = "cpu_hpm_low_warning";
            desc = "CPU HPM Warning lower limit.";
            sw = r; hw = w;
            reset = 0x0;
        } cpu_hpm_low_warning[24:24];
        field {
            name = "reserved";
            desc = "Reserved.";
            sw = r; hw = w;
            reset = 0x0;
        } reserved_23_22[23:22];
        field {
            name = "cpu_hpm_pc_record1";
            desc = "CPU HPM raw code pattern 1.";
            sw = r; hw = w;
            reset = 0x0;
        } cpu_hpm_pc_record1[21:12];
        field {
            name = "reserved";
            desc = "Reserved.";
            sw = r; hw = w;
            reset = 0x0;
        } reserved_11_11[11:11];
        field {
            name = "cpu_hpm_pc_valid";
            desc = "CPU HPM output valid indication.
- 0: invalid;
- 1: valid.";
            sw = r; hw = w;
            reset = 0x0;
        } cpu_hpm_pc_valid[10:10];
        field {
            name = "cpu_hpm_pc_record0";
            desc = "CPU HPM raw pattern 0.";
            sw = r; hw = w;
            reset = 0x0;
        } cpu_hpm_pc_record0[9:0];
    } PERI_CRG80 @ 0x140;
    reg {
        name = "PERI_CRG81";
        desc = "PERI_CRG81 is CPU HPM status register 2. PERI_CRG81 (offset 0x0144, total reset 0x0000_0000; PROVEN: Hi3535 data sheet, PDF page 388, section 3.2.7).";
        field {
            name = "reserved";
            desc = "Reserved.";
            sw = r; hw = w;
            reset = 0x0;
        } reserved_31_29[31:29];
        field {
            name = "cpu_hpm_rcc";
            desc = "CPU HPM output RCC code.";
            sw = r; hw = w;
            reset = 0x0;
        } cpu_hpm_rcc[28:24];
        field {
            name = "reserved";
            desc = "Reserved.";
            sw = r; hw = w;
            reset = 0x0;
        } reserved_23_22[23:22];
        field {
            name = "cpu_hpm_pc_record3";
            desc = "CPU HPM raw code pattern 3.";
            sw = r; hw = w;
            reset = 0x0;
        } cpu_hpm_pc_record3[21:12];
        field {
            name = "reserved";
            desc = "Reserved.";
            sw = r; hw = w;
            reset = 0x0;
        } reserved_11_10[11:10];
        field {
            name = "cpu_hpm_pc_record2";
            desc = "CPU HPM raw code pattern 2.";
            sw = r; hw = w;
            reset = 0x0;
        } cpu_hpm_pc_record2[9:0];
    } PERI_CRG81 @ 0x144;
    reg {
        name = "PERI_CRG82";
        desc = "PERI_CRG82 is CPU HPM control register 2. PERI_CRG82 (offset 0x0148, total reset 0x0000_0000; PROVEN: Hi3535 data sheet, PDF page 388, section 3.2.7).";
        field {
            name = "cpu_hpm_monitor_period";
            desc = "CPU HPM loop monitor period. If the configured value is N, the monitoring period is T = N x 2048/1000 ms. The maximum monitoring interval is 522 ms and the minimum is 2 ms.";
            sw = rw; hw = r;
            reset = 0x0;
        } cpu_hpm_monitor_period[31:24];
        field {
            name = "reserved";
            desc = "Reserved.";
            sw = r; hw = w;
            reset = 0x0;
        } reserved_23_22[23:22];
        field {
            name = "cpu_hpm_lowlimit";
            desc = "CPU HPM lower limit.";
            sw = rw; hw = r;
            reset = 0x0;
        } cpu_hpm_lowlimit[21:12];
        field {
            name = "reserved";
            desc = "Reserved.";
            sw = rw; hw = r;
            reset = 0x0;
        } reserved_11_10[11:10];
        field {
            name = "cpu_hpm_uplimit";
            desc = "CPU HPM upper limit value.";
            sw = rw; hw = r;
            reset = 0x0;
        } cpu_hpm_uplimit[9:0];
    } PERI_CRG82 @ 0x148;
};

`endif
