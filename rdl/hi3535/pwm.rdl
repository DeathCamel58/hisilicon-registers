`ifndef EHI3535_PWM_RDL
`define EHI3535_PWM_RDL
regfile eHI3535_PWM {
    name = "PWM";
    desc = "PWM. 14 registers extracted programmatically from the Hi3535 H.264 codec processor (Hi3535 user guide) data sheet (Issue 00B08, 2014-02-25); chapter 13.9.5, table 13-20. Field names, bit ranges, access types and reset values are taken from the register tables; reset values are the data sheet total reset values split onto the fields (per-field values where the table has them). Label: PROVEN. Hardware not verified here (no board).";
    reg {
        name = "PWM0_CFG0";
        desc = "PWM0_CFG0 is the PWM0 configuration 0 register. PWM0_CFG0 (offset 0x0000, total reset 0x0000_018F; PROVEN: Hi3535 data sheet, PDF page 1417, section 13.9.5).";
        field {
            name = "reserved";
            desc = "Reserved.";
            sw = r; hw = w;
            reset = 0x0;
        } reserved_31_26[31:26];
        field {
            name = "pwm0_period";
            desc = "Number of periods of PWM0. Must not be set to 0 or 1; if set to 0 or 1, a high level is output.";
            sw = rw; hw = r;
            reset = 0x18f;
        } pwm0_period[25:0];
    } PWM0_CFG0 @ 0x0;
    reg {
        name = "PWM0_CFG1";
        desc = "PWM0_CFG1 is the PWM0 configuration 1 register. PWM0_CFG1 (offset 0x0004, total reset 0x0000_00C7; PROVEN: Hi3535 data sheet, PDF page 1417, section 13.9.5).";
        field {
            name = "reserved";
            desc = "Reserved.";
            sw = r; hw = w;
            reset = 0x0;
        } reserved_31_26[31:26];
        field {
            name = "pwm0_duty";
            desc = "Number of high-level beats of PWM0. If it is greater than or equal to the number of cycles, the output stays high.";
            sw = rw; hw = r;
            reset = 0xc7;
        } pwm0_duty[25:0];
    } PWM0_CFG1 @ 0x4;
    reg {
        name = "PWM0_CFG2";
        desc = "PWM0_CFG2 is PWM0 configuration register 2. PWM0_CFG2 (offset 0x0008, total reset 0x0000_0000; PROVEN: Hi3535 data sheet, PDF page 1418, section 13.9.5).";
        field {
            name = "reserved";
            desc = "Reserved.";
            sw = r; hw = w;
            reset = 0x0;
        } reserved_31_10[31:10];
        field {
            name = "pwm0_num";
            desc = "Number of square wave cycles output by PWM0.";
            sw = rw; hw = r;
            reset = 0x0;
        } pwm0_num[9:0];
    } PWM0_CFG2 @ 0x8;
    reg {
        name = "PWM0_CTRL";
        desc = "PWM0_CTRL is the control register of PWM0. PWM0_CTRL (offset 0x000C, total reset 0x0000_0000; PROVEN: Hi3535 data sheet, PDF page 1418, section 13.9.5).";
        field {
            name = "reserved";
            desc = "Reserved.";
            sw = r; hw = w;
            reset = 0x0;
        } reserved_31_3[31:3];
        field {
            name = "pwm0_keep";
            desc = "PWM output mode.
- 0: PWM0 outputs a fixed number of square waves;
- 1: PWM0 outputs square waves continuously.";
            sw = rw; hw = r;
            reset = 0x0;
        } pwm0_keep[2:2];
        field {
            name = "pwm0_inv";
            desc = "PWM output polarity control.
- 0: PWM0 outputs a normal square wave;
- 1: PWM0 outputs an inverted square wave.";
            sw = rw; hw = r;
            reset = 0x0;
        } pwm0_inv[1:1];
        field {
            name = "pwm0_enable";
            desc = "PWM enable control.
- 0: PWM0 module off;
- 1: PWM0 module enabled.";
            sw = rw; hw = r;
            reset = 0x0;
        } pwm0_enable[0:0];
    } PWM0_CTRL @ 0xc;
    reg {
        name = "PWM0_STATE0";
        desc = "PWM0_STATE0 is the PWM0 state 0 register. PWM0_STATE0 (offset 0x0010, total reset 0x0000_0000; PROVEN: Hi3535 data sheet, PDF page 1419, section 13.9.5).";
        field {
            name = "reserved";
            desc = "Reserved.";
            sw = r; hw = w;
            reset = 0x0;
        } reserved_31_26[31:26];
        field {
            name = "pwm0_period_st";
            desc = "Number of count cycles used by the PWM0 internal module.";
            sw = r; hw = w;
            reset = 0x0;
        } pwm0_period_st[25:0];
    } PWM0_STATE0 @ 0x10;
    reg {
        name = "PWM0_STATE1";
        desc = "PWM0_STATE1 is the PWM0 status 1 register. PWM0_STATE1 (offset 0x0014, total reset 0x0000_0000; PROVEN: Hi3535 data sheet, PDF page 1419, section 13.9.5).";
        field {
            name = "reserved";
            desc = "Reserved.";
            sw = r; hw = w;
            reset = 0x0;
        } reserved_31_26[31:26];
        field {
            name = "pwm0_duty_st";
            desc = "Number of high-level beats used by the internal module of PWM0.";
            sw = r; hw = w;
            reset = 0x0;
        } pwm0_duty_st[25:0];
    } PWM0_STATE1 @ 0x14;
    reg {
        name = "PWM0_STATE2";
        desc = "PWM0_STATE2 is the PWM0 status 2 register. PWM0_STATE2 (offset 0x0018, total reset 0x0000_0000; PROVEN: Hi3535 data sheet, PDF page 1420, section 13.9.5).";
        field {
            name = "reserved";
            desc = "Reserved.";
            sw = r; hw = w;
            reset = 0x0;
        } reserved_31_22[31:22];
        field {
            name = "pwm0_cnt_st";
            desc = "Number of square wave cycles that the PWM0 module still has to output. Meaningful only when pwm0_busy==1 and pwm0_keep_st==0.";
            sw = r; hw = w;
            reset = 0x0;
        } pwm0_cnt_st[21:12];
        field {
            name = "pwm0_keep_st";
            desc = "Square wave output mode used by the internal module of PWM0.
- 0: Output a fixed number of square waves;
- 1: Output square waves continuously.";
            sw = r; hw = w;
            reset = 0x0;
        } pwm0_keep_st[11:11];
        field {
            name = "pwm0_busy";
            desc = "Working status of the PWM0 module.
- 0: Idle, output complete;
- 1: Outputting a square wave.";
            sw = r; hw = w;
            reset = 0x0;
        } pwm0_busy[10:10];
        field {
            name = "pwm0_period_st";
            desc = "Number of square wave cycles used by the internal module of PWM0.";
            sw = r; hw = w;
            reset = 0x0;
        } pwm0_period_st[9:0];
    } PWM0_STATE2 @ 0x18;
    reg {
        name = "PWM1_CFG0";
        desc = "PWM1_CFG0 is the PWM1 configuration 0 register. PWM1_CFG0 (offset 0x0020, total reset 0x0000_018F; PROVEN: Hi3535 data sheet, PDF page 1420, section 13.9.5).";
        field {
            name = "reserved";
            desc = "Reserved.";
            sw = r; hw = w;
            reset = 0x0;
        } reserved_31_26[31:26];
        field {
            name = "pwm1_period";
            desc = "Number of periods of PWM1. Must not be set to 0 or 1; if set to 0 or 1, a high level is output.";
            sw = rw; hw = r;
            reset = 0x18f;
        } pwm1_period[25:0];
    } PWM1_CFG0 @ 0x20;
    reg {
        name = "PWM1_CFG1";
        desc = "PWM1_CFG1 is the PWM1 configuration 1 register. PWM1_CFG1 (offset 0x0024, total reset 0x0000_00C7; PROVEN: Hi3535 data sheet, PDF page 1421, section 13.9.5).";
        field {
            name = "reserved";
            desc = "Reserved.";
            sw = r; hw = w;
            reset = 0x0;
        } reserved_31_26[31:26];
        field {
            name = "pwm1_duty";
            desc = "Number of high-level beats of PWM1. If it is greater than or equal to the period count, the output stays high.";
            sw = rw; hw = r;
            reset = 0xc7;
        } pwm1_duty[25:0];
    } PWM1_CFG1 @ 0x24;
    reg {
        name = "PWM1_CFG2";
        desc = "PWM1_CFG2 is PWM1 configuration register 2. PWM1_CFG2 (offset 0x0028, total reset 0x0000_0000; PROVEN: Hi3535 data sheet, PDF page 1421, section 13.9.5).";
        field {
            name = "reserved";
            desc = "Reserved.";
            sw = r; hw = w;
            reset = 0x0;
        } reserved_31_10[31:10];
        field {
            name = "pwm1_num";
            desc = "Number of square waves output by PWM1.";
            sw = rw; hw = r;
            reset = 0x0;
        } pwm1_num[9:0];
    } PWM1_CFG2 @ 0x28;
    reg {
        name = "PWM1_CTRL";
        desc = "PWM1_CTRL is the PWM1 control register. PWM1_CTRL (offset 0x002C, total reset 0x0000_0000; PROVEN: Hi3535 data sheet, PDF page 1422, section 13.9.5).";
        field {
            name = "reserved";
            desc = "Reserved.";
            sw = r; hw = na;
            reset = 0x0;
        } reserved_31_3[31:3];
        field {
            name = "pwm1_keep";
            desc = "PWM output mode.
- 0: PWM1 outputs a fixed number of square wave cycles.
- 1: PWM1 outputs a square wave continuously.";
            sw = rw; hw = r;
            reset = 0x0;
        } pwm1_keep[2:2];
        field {
            name = "pwm1_inv";
            desc = "PWM output polarity control.
- 0: PWM1 outputs a normal square wave.
- 1: PWM1 outputs an inverted square wave.";
            sw = rw; hw = r;
            reset = 0x0;
        } pwm1_inv[1:1];
        field {
            name = "pwm1_enable";
            desc = "PWM enable control.
- 0: PWM1 module off.
- 1: PWM1 module enabled.";
            sw = rw; hw = r;
            reset = 0x0;
        } pwm1_enable[0:0];
    } PWM1_CTRL @ 0x2c;
    reg {
        name = "PWM1_STATE0";
        desc = "PWM1_STATE0 is the PWM1 status 0 register. PWM1_STATE0 (offset 0x0030, total reset 0x0000_0000; PROVEN: Hi3535 data sheet, PDF page 1422, section 13.9.5).";
        field {
            name = "reserved";
            desc = "Reserved.";
            sw = r; hw = w;
            reset = 0x0;
        } reserved_31_26[31:26];
        field {
            name = "pwm1_period_st";
            desc = "Number of counting cycles used by the internal module of PWM1.";
            sw = r; hw = w;
            reset = 0x0;
        } pwm1_period_st[25:0];
    } PWM1_STATE0 @ 0x30;
    reg {
        name = "PWM1_STATE1";
        desc = "PWM1_STATE1 is status register 1 of PWM1. PWM1_STATE1 (offset 0x0034, total reset 0x0000_0000; PROVEN: Hi3535 data sheet, PDF page 1423, section 13.9.5).";
        field {
            name = "reserved";
            desc = "Reserved.";
            sw = r; hw = w;
            reset = 0x0;
        } reserved_31_26[31:26];
        field {
            name = "pwm1_duty_st";
            desc = "Number of high-level beats used by the PWM1 internal module.";
            sw = r; hw = w;
            reset = 0x0;
        } pwm1_duty_st[25:0];
    } PWM1_STATE1 @ 0x34;
    reg {
        name = "PWM1_STATE2";
        desc = "PWM1_STATE2 is the PWM1 status 2 register. PWM1_STATE2 (offset 0x0038, total reset 0x0000_0000; PROVEN: Hi3535 data sheet, PDF page 1423, section 13.9.5).";
        field {
            name = "reserved";
            desc = "Reserved.";
            sw = r; hw = w;
            reset = 0x0;
        } reserved_31_22[31:22];
        field {
            name = "pwm1_cnt_st";
            desc = "Number of square wave cycles the PWM1 module still needs to output. Meaningful only when pwm1_busy==1 and pwm1_keep_st==0.";
            sw = r; hw = w;
            reset = 0x0;
        } pwm1_cnt_st[21:12];
        field {
            name = "pwm1_keep_st";
            desc = "Square wave output mode used by the internal module of PWM1.
- 0: Output a fixed number of square waves.
- 1: Output square waves continuously.";
            sw = r; hw = w;
            reset = 0x0;
        } pwm1_keep_st[11:11];
        field {
            name = "pwm1_busy";
            desc = "Operating status of the PWM1 module.
- 0: Idle, output completed;
- 1: Square wave output in progress.";
            sw = r; hw = w;
            reset = 0x0;
        } pwm1_busy[10:10];
        field {
            name = "pwm1_period_st";
            desc = "Number of square waves output by the internal module of PWM1. Contents";
            sw = r; hw = w;
            reset = 0x0;
        } pwm1_period_st[9:0];
    } PWM1_STATE2 @ 0x38;
};

`endif
