`ifndef EHI3535_TOE_RDL
`define EHI3535_TOE_RDL
regfile eHI3535_TOE {
    name = "GMAC and TOE (TCP offload engine) registers";
    desc = "GMAC and TOE (TCP offload engine) registers. 82 registers extracted programmatically from the Hi3535 H.264 codec processor (Hi3535 user guide) data sheet (Issue 00B08, 2014-02-25); chapter 5.6, table 5-11. Field names, bit ranges, access types and reset values are taken from the register tables; reset values are the data sheet total reset values split onto the fields (per-field values where the table has them). Label: PROVEN. Hardware not verified here (no board).";
    reg {
        name = "GMACN_CTRL_REG";
        desc = "GMACN_CTRL_REG is the configuration register of GMACn (0 to 1). It configures the operating modes of receive and transmit. GMACN_CTRL_REG (offset 0x0000+Nx0x4000 (N = 0~1), total reset 0x0000_0000; PROVEN: Hi3535 data sheet, PDF page 810, section 5.6).";
        field {
            name = "reserved";
            desc = "Reserved.";
            sw = r; hw = w;
            reset = 0x0;
        } reserved_31_16[31:16];
        field {
            name = "ps";
            desc = "PS: port select, selects between GMII and MII.
- 0: GMII (1000 Mbps);
- 1: MII (10/100 Mbps).";
            sw = rw; hw = r;
            reset = 0x0;
        } ps[15:15];
        field {
            name = "fes";
            desc = "FES: Speed, indicating the speed in FE (MII mode).
- 0: 10 Mbps;
- 1: 100 Mbps, valid only in RGMII mode.";
            sw = rw; hw = r;
            reset = 0x0;
        } fes[14:14];
        field {
            name = "do";
            desc = "DO: disable receiving own frames. When this bit is set to 1, the GMAC disables frame reception while it asserts gmii_txen_o in half-duplex mode. This bit has no effect in full-duplex mode.
- 0: In half-duplex mode, frame reception is enabled when gmii_txen_o is 1;
- 1: In half-duplex mode, frame reception is disabled when gmii_txen_o is 1.";
            sw = rw; hw = r;
            reset = 0x0;
        } do[13:13];
        field {
            name = "lm";
            desc = "LM: Loopback mode. In GMII/MII mode, when this bit is set to 1, the GMAC operates in loopback mode.
- 0: The GMAC does not operate in loopback mode.
- 1: The GMAC operates in loopback mode.";
            sw = rw; hw = r;
            reset = 0x0;
        } lm[12:12];
        field {
            name = "dm";
            desc = "DM: Duplex mode.
- 0: Half-duplex mode;
- 1: Full-duplex mode.";
            sw = rw; hw = r;
            reset = 0x0;
        } dm[11:11];
        field {
            name = "reserved";
            desc = "Reserved.";
            sw = r; hw = w;
            reset = 0x0;
        } reserved_10_10[10:10];
        field {
            name = "dr";
            desc = "DR: Disable retry. When this bit is set to 1, the GMAC makes only one transmission attempt. On a collision in half-duplex mode, the GMAC ignores the transmission of the current frame and reports a collision event. When this bit is 0, the GMAC retries according to the BL setting (bit[6:5]).
- 0: Retry on collision in half-duplex mode;
- 1: Do not retry on collision in half-duplex mode.";
            sw = rw; hw = r;
            reset = 0x0;
        } dr[9:9];
        field {
            name = "reserved";
            desc = "Reserved.";
            sw = r; hw = w;
            reset = 0x0;
        } reserved_8_7[8:7];
        field {
            name = "bl";
            desc = "BL: back-off limit. The back-off limit determines the random integer multiple of the slot time delay (4,096 bit times for 1000 Mbps and 512 bit times for 10/100 Mbps) that the GMAC waits before a retransmission attempt after a collision. Valid only in half-duplex mode.
- 00: k = min (n, 10);
- 01: k = min (n, 8);
- 10: k = min (n, 4);
- 11: k = min (n, 1).
Here n is the number of retransmission attempts, and the random variable r is in the range 0 ≤ r < 2k (2 to the power k)";
            sw = rw; hw = r;
            reset = 0x0;
        } bl[6:5];
        field {
            name = "reserved";
            desc = "Reserved.";
            sw = r; hw = w;
            reset = 0x0;
        } reserved_4_4[4:4];
        field {
            name = "te";
            desc = "TE: transmit enable.
- 0: Transmit disabled; the GMAC stops after finishing the current frame and sends no further frames;
- 1: Transmit enabled; the internal GMAC transmit state machine is enabled.";
            sw = rw; hw = r;
            reset = 0x0;
        } te[3:3];
        field {
            name = "re";
            desc = "RE: Receive enable.
- 0: Receive disabled; the GMAC stops after finishing the reception of the current frame and no longer receives subsequent frames.
- 1: Receive enabled; the internal receive state machine of the GMAC is enabled.";
            sw = rw; hw = r;
            reset = 0x0;
        } re[2:2];
        field {
            name = "reserved";
            desc = "Reserved.";
            sw = r; hw = w;
            reset = 0x0;
        } reserved_1_0[1:0];
    } GMACN_CTRL_REG_0 @ 0x0;
    reg {
        name = "GMACN_CTRL_REG";
        desc = "GMACN_CTRL_REG is the configuration register of GMACn (0 to 1). It configures the operating modes of receive and transmit. GMACN_CTRL_REG (offset 0x0000+Nx0x4000 (N = 0~1), total reset 0x0000_0000; PROVEN: Hi3535 data sheet, PDF page 810, section 5.6).";
        field {
            name = "reserved";
            desc = "Reserved.";
            sw = r; hw = w;
            reset = 0x0;
        } reserved_31_16[31:16];
        field {
            name = "ps";
            desc = "PS: port select, selects between GMII and MII.
- 0: GMII (1000 Mbps);
- 1: MII (10/100 Mbps).";
            sw = rw; hw = r;
            reset = 0x0;
        } ps[15:15];
        field {
            name = "fes";
            desc = "FES: Speed, indicating the speed in FE (MII mode).
- 0: 10 Mbps;
- 1: 100 Mbps, valid only in RGMII mode.";
            sw = rw; hw = r;
            reset = 0x0;
        } fes[14:14];
        field {
            name = "do";
            desc = "DO: disable receiving own frames. When this bit is set to 1, the GMAC disables frame reception while it asserts gmii_txen_o in half-duplex mode. This bit has no effect in full-duplex mode.
- 0: In half-duplex mode, frame reception is enabled when gmii_txen_o is 1;
- 1: In half-duplex mode, frame reception is disabled when gmii_txen_o is 1.";
            sw = rw; hw = r;
            reset = 0x0;
        } do[13:13];
        field {
            name = "lm";
            desc = "LM: Loopback mode. In GMII/MII mode, when this bit is set to 1, the GMAC operates in loopback mode.
- 0: The GMAC does not operate in loopback mode.
- 1: The GMAC operates in loopback mode.";
            sw = rw; hw = r;
            reset = 0x0;
        } lm[12:12];
        field {
            name = "dm";
            desc = "DM: Duplex mode.
- 0: Half-duplex mode;
- 1: Full-duplex mode.";
            sw = rw; hw = r;
            reset = 0x0;
        } dm[11:11];
        field {
            name = "reserved";
            desc = "Reserved.";
            sw = r; hw = w;
            reset = 0x0;
        } reserved_10_10[10:10];
        field {
            name = "dr";
            desc = "DR: Disable retry. When this bit is set to 1, the GMAC makes only one transmission attempt. On a collision in half-duplex mode, the GMAC ignores the transmission of the current frame and reports a collision event. When this bit is 0, the GMAC retries according to the BL setting (bit[6:5]).
- 0: Retry on collision in half-duplex mode;
- 1: Do not retry on collision in half-duplex mode.";
            sw = rw; hw = r;
            reset = 0x0;
        } dr[9:9];
        field {
            name = "reserved";
            desc = "Reserved.";
            sw = r; hw = w;
            reset = 0x0;
        } reserved_8_7[8:7];
        field {
            name = "bl";
            desc = "BL: back-off limit. The back-off limit determines the random integer multiple of the slot time delay (4,096 bit times for 1000 Mbps and 512 bit times for 10/100 Mbps) that the GMAC waits before a retransmission attempt after a collision. Valid only in half-duplex mode.
- 00: k = min (n, 10);
- 01: k = min (n, 8);
- 10: k = min (n, 4);
- 11: k = min (n, 1).
Here n is the number of retransmission attempts, and the random variable r is in the range 0 ≤ r < 2k (2 to the power k)";
            sw = rw; hw = r;
            reset = 0x0;
        } bl[6:5];
        field {
            name = "reserved";
            desc = "Reserved.";
            sw = r; hw = w;
            reset = 0x0;
        } reserved_4_4[4:4];
        field {
            name = "te";
            desc = "TE: transmit enable.
- 0: Transmit disabled; the GMAC stops after finishing the current frame and sends no further frames;
- 1: Transmit enabled; the internal GMAC transmit state machine is enabled.";
            sw = rw; hw = r;
            reset = 0x0;
        } te[3:3];
        field {
            name = "re";
            desc = "RE: Receive enable.
- 0: Receive disabled; the GMAC stops after finishing the reception of the current frame and no longer receives subsequent frames.
- 1: Receive enabled; the internal receive state machine of the GMAC is enabled.";
            sw = rw; hw = r;
            reset = 0x0;
        } re[2:2];
        field {
            name = "reserved";
            desc = "Reserved.";
            sw = r; hw = w;
            reset = 0x0;
        } reserved_1_0[1:0];
    } GMACN_CTRL_REG_1 @ 0x4000;
    reg {
        name = "GMACN_FRAME_FILTER";
        desc = "GMACN_FRAME_FILTER is the frame filter register of GMACn (0 to 1). It contains the filtering controls for received frames. GMACN_FRAME_FILTER (offset 0x0004+Nx0x4000 (N = 0~1), total reset 0x0000_0000; PROVEN: Hi3535 data sheet, PDF page 812, section 5.6).";
        field {
            name = "ra";
            desc = "RA: receive all.
- 0: The GMAC forwards only frames that pass the SA/DA filter to the CPU.
- 1: The GMAC forwards all frames to the CPU and writes the SA/DA filter status back to the descriptor.";
            sw = rw; hw = r;
            reset = 0x0;
        } ra[31:31];
        field {
            name = "reserved";
            desc = "Reserved.";
            sw = r; hw = w;
            reset = 0x0;
        } reserved_30_11[30:11];
        field {
            name = "hpf";
            desc = "HPF: hash or perfect filtering.
- 0: If the HUC/HMC bit is set to 1, the current frame passes filtering only when it meets the hash filtering condition;
- 1: When this bit is set to 1, if the current frame meets the hash filtering or the perfect filtering condition, it passes the address filter.";
            sw = rw; hw = r;
            reset = 0x0;
        } hpf[10:10];
        field {
            name = "saf";
            desc = "SAF: Source address filter enable.
- 0: The GMAC forwards the current frame to the CPU and writes the SA filter status back to the receive status in the descriptor.
- 1: The GMAC drops frames that fail the SA filter.";
            sw = rw; hw = r;
            reset = 0x0;
        } saf[9:9];
        field {
            name = "saif";
            desc = "SAIF: SA inverse filtering.
- 0: If the SA of a frame does not match the SA register, the frame is marked as failing the SA filter.
- 1: The address check module works in inverse mode: if the SA of a frame matches the SA register, the frame is marked as failing the SA filter.";
            sw = rw; hw = r;
            reset = 0x0;
        } saif[8:8];
        field {
            name = "pcf";
            desc = "PCF: pass control frames. These bits control the forwarding of all control frames (including all unicast and multicast pause frames).
- 00: The GMAC filters out all control frames arriving at the application;
- 01: The GMAC forwards all control frames except pause frames to the CPU, even if they fail address filtering;
- 10: The GMAC forwards all control frames to the CPU, even if they fail address filtering;
- 11: The GMAC forwards all control frames that pass address filtering to the CPU.";
            sw = rw; hw = r;
            reset = 0x0;
        } pcf[7:6];
        field {
            name = "dbf";
            desc = "DBF: disable broadcast frames.
- 0: Do not filter any received broadcast frames;
- 1: Filter all incoming broadcast frames and ignore other filter settings.";
            sw = rw; hw = r;
            reset = 0x0;
        } dbf[5:5];
        field {
            name = "pm";
            desc = "PM: Pass all multicast.
- 0: Multicast frames are filtered according to the HMC bit setting.
- 1: Pass all multicast frames.";
            sw = rw; hw = r;
            reset = 0x0;
        } pm[4:4];
        field {
            name = "daif";
            desc = "DAIF: DA inverse filtering.
- 0: If the DA of a frame does not match the DA registers, the frame is marked as failing DA filtering;
- 1: The address check module works in inverse mode: if the DA of a frame matches the DA registers, the frame is marked as failing DA filtering.";
            sw = rw; hw = r;
            reset = 0x0;
        } daif[3:3];
        field {
            name = "hmc";
            desc = "HMC: hash multicast.
- 0: The GMAC performs DA filtering of received multicast frames according to the DA register.
- 1: The GMAC performs DA filtering of received multicast frames according to the hash table.";
            sw = rw; hw = r;
            reset = 0x0;
        } hmc[2:2];
        field {
            name = "huc";
            desc = "HUC: hash unicast.
- 0: The GMAC performs DA filtering of received unicast frames according to the DA register.
- 1: The GMAC performs DA filtering of received unicast frames according to the hash table.";
            sw = rw; hw = r;
            reset = 0x0;
        } huc[1:1];
        field {
            name = "pr";
            desc = "PR: promiscuous mode. In this mode all incoming received frames are forwarded to the CPU, and the receive status is always 0.
- 0: Not in promiscuous mode;
- 1: In promiscuous mode.";
            sw = rw; hw = r;
            reset = 0x0;
        } pr[0:0];
    } GMACN_FRAME_FILTER_0 @ 0x4;
    reg {
        name = "GMACN_FRAME_FILTER";
        desc = "GMACN_FRAME_FILTER is the frame filter register of GMACn (0 to 1). It contains the filtering controls for received frames. GMACN_FRAME_FILTER (offset 0x0004+Nx0x4000 (N = 0~1), total reset 0x0000_0000; PROVEN: Hi3535 data sheet, PDF page 812, section 5.6).";
        field {
            name = "ra";
            desc = "RA: receive all.
- 0: The GMAC forwards only frames that pass the SA/DA filter to the CPU.
- 1: The GMAC forwards all frames to the CPU and writes the SA/DA filter status back to the descriptor.";
            sw = rw; hw = r;
            reset = 0x0;
        } ra[31:31];
        field {
            name = "reserved";
            desc = "Reserved.";
            sw = r; hw = w;
            reset = 0x0;
        } reserved_30_11[30:11];
        field {
            name = "hpf";
            desc = "HPF: hash or perfect filtering.
- 0: If the HUC/HMC bit is set to 1, the current frame passes filtering only when it meets the hash filtering condition;
- 1: When this bit is set to 1, if the current frame meets the hash filtering or the perfect filtering condition, it passes the address filter.";
            sw = rw; hw = r;
            reset = 0x0;
        } hpf[10:10];
        field {
            name = "saf";
            desc = "SAF: Source address filter enable.
- 0: The GMAC forwards the current frame to the CPU and writes the SA filter status back to the receive status in the descriptor.
- 1: The GMAC drops frames that fail the SA filter.";
            sw = rw; hw = r;
            reset = 0x0;
        } saf[9:9];
        field {
            name = "saif";
            desc = "SAIF: SA inverse filtering.
- 0: If the SA of a frame does not match the SA register, the frame is marked as failing the SA filter.
- 1: The address check module works in inverse mode: if the SA of a frame matches the SA register, the frame is marked as failing the SA filter.";
            sw = rw; hw = r;
            reset = 0x0;
        } saif[8:8];
        field {
            name = "pcf";
            desc = "PCF: pass control frames. These bits control the forwarding of all control frames (including all unicast and multicast pause frames).
- 00: The GMAC filters out all control frames arriving at the application;
- 01: The GMAC forwards all control frames except pause frames to the CPU, even if they fail address filtering;
- 10: The GMAC forwards all control frames to the CPU, even if they fail address filtering;
- 11: The GMAC forwards all control frames that pass address filtering to the CPU.";
            sw = rw; hw = r;
            reset = 0x0;
        } pcf[7:6];
        field {
            name = "dbf";
            desc = "DBF: disable broadcast frames.
- 0: Do not filter any received broadcast frames;
- 1: Filter all incoming broadcast frames and ignore other filter settings.";
            sw = rw; hw = r;
            reset = 0x0;
        } dbf[5:5];
        field {
            name = "pm";
            desc = "PM: Pass all multicast.
- 0: Multicast frames are filtered according to the HMC bit setting.
- 1: Pass all multicast frames.";
            sw = rw; hw = r;
            reset = 0x0;
        } pm[4:4];
        field {
            name = "daif";
            desc = "DAIF: DA inverse filtering.
- 0: If the DA of a frame does not match the DA registers, the frame is marked as failing DA filtering;
- 1: The address check module works in inverse mode: if the DA of a frame matches the DA registers, the frame is marked as failing DA filtering.";
            sw = rw; hw = r;
            reset = 0x0;
        } daif[3:3];
        field {
            name = "hmc";
            desc = "HMC: hash multicast.
- 0: The GMAC performs DA filtering of received multicast frames according to the DA register.
- 1: The GMAC performs DA filtering of received multicast frames according to the hash table.";
            sw = rw; hw = r;
            reset = 0x0;
        } hmc[2:2];
        field {
            name = "huc";
            desc = "HUC: hash unicast.
- 0: The GMAC performs DA filtering of received unicast frames according to the DA register.
- 1: The GMAC performs DA filtering of received unicast frames according to the hash table.";
            sw = rw; hw = r;
            reset = 0x0;
        } huc[1:1];
        field {
            name = "pr";
            desc = "PR: promiscuous mode. In this mode all incoming received frames are forwarded to the CPU, and the receive status is always 0.
- 0: Not in promiscuous mode;
- 1: In promiscuous mode.";
            sw = rw; hw = r;
            reset = 0x0;
        } pr[0:0];
    } GMACN_FRAME_FILTER_1 @ 0x4004;
    reg {
        name = "GMACN_GMII_ADDR";
        desc = "GMACN_GMII_ADDR is the GMII address register. It accesses the external PHY through the MDIO interface. GMACN_GMII_ADDR (offset 0x0010+Nx0x4000 (N = 0~1), total reset 0x0000_0000; PROVEN: Hi3535 data sheet, PDF page 813, section 5.6).";
        field {
            name = "reserved";
            desc = "Reserved.";
            sw = r; hw = w;
            reset = 0x0;
        } reserved_31_16[31:16];
        field {
            name = "pa";
            desc = "PA: Physical layer address. Distinguishes among the 32 external PHYs that may be accessed.";
            sw = rw; hw = r;
            reset = 0x0;
        } pa[15:11];
        field {
            name = "gr";
            desc = "GR: GMII register. Selects the register of the PHY being accessed.";
            sw = rw; hw = r;
            reset = 0x0;
        } gr[10:6];
        field {
            name = "cr";
            desc = "CR: CSR clock range. The CSR clock range determines the frequency of the MDC clock. When bit[5] is 0, the recommended CSR clock ranges that keep the MDC clock within its operating range (1.0 MHz to 2.5 MHz) are as follows. Select CSR clock MDC clock 0000 60-100 MHz clk_csr_i/42 0001 100-150 MHz clk_csr_i/62 0010 20-35 MHz clk_csr_i/16 0011 35-60 MHz clk_csr_i/26 0100 150-250 MHz clk_csr_i/102 0101 250-300 MHz clk_csr_i/124 0110,0111: Reserved. When bit[5] is 1, the MDC clock may exceed the 2.5 MHz clock limit specified by IEEE 802.3. Select MDC clock 1000 clk_csr_i/4 1001 clk_csr_i/6 1010 clk_csr_i/8 1011 clk_csr_i/10 1100 clk_csr_i/12 1101 clk_csr_i/14 1110 clk_csr_i/16 1111 clk_csr_i/18";
            sw = rw; hw = r;
            reset = 0x0;
        } cr[5:2];
        field {
            name = "gw";
            desc = "GW: GMII write.
- 0: Read operation.
- 1: Write operation.";
            sw = rw; hw = r;
            reset = 0x0;
        } gw[1:1];
        field {
            name = "gb";
            desc = "GB: GMII busy. Before writing the GMACn_GMII_DATA and GMACn_GMII_ADDR registers, this bit must read back as 0. While accessing the external PHY, software must keep this bit set to 1. The value of GMACn_GMII_DATA is valid only after the GMAC sets this bit to 0.
- 0: GMII busy;
- 1: GMII idle, read and write operations can be performed. (data sheet access type RWSC)";
            sw = rw; hw = r;
            reset = 0x0;
        } gb[0:0];
    } GMACN_GMII_ADDR_0 @ 0x10;
    reg {
        name = "GMACN_GMII_ADDR";
        desc = "GMACN_GMII_ADDR is the GMII address register. It accesses the external PHY through the MDIO interface. GMACN_GMII_ADDR (offset 0x0010+Nx0x4000 (N = 0~1), total reset 0x0000_0000; PROVEN: Hi3535 data sheet, PDF page 813, section 5.6).";
        field {
            name = "reserved";
            desc = "Reserved.";
            sw = r; hw = w;
            reset = 0x0;
        } reserved_31_16[31:16];
        field {
            name = "pa";
            desc = "PA: Physical layer address. Distinguishes among the 32 external PHYs that may be accessed.";
            sw = rw; hw = r;
            reset = 0x0;
        } pa[15:11];
        field {
            name = "gr";
            desc = "GR: GMII register. Selects the register of the PHY being accessed.";
            sw = rw; hw = r;
            reset = 0x0;
        } gr[10:6];
        field {
            name = "cr";
            desc = "CR: CSR clock range. The CSR clock range determines the frequency of the MDC clock. When bit[5] is 0, the recommended CSR clock ranges that keep the MDC clock within its operating range (1.0 MHz to 2.5 MHz) are as follows. Select CSR clock MDC clock 0000 60-100 MHz clk_csr_i/42 0001 100-150 MHz clk_csr_i/62 0010 20-35 MHz clk_csr_i/16 0011 35-60 MHz clk_csr_i/26 0100 150-250 MHz clk_csr_i/102 0101 250-300 MHz clk_csr_i/124 0110,0111: Reserved. When bit[5] is 1, the MDC clock may exceed the 2.5 MHz clock limit specified by IEEE 802.3. Select MDC clock 1000 clk_csr_i/4 1001 clk_csr_i/6 1010 clk_csr_i/8 1011 clk_csr_i/10 1100 clk_csr_i/12 1101 clk_csr_i/14 1110 clk_csr_i/16 1111 clk_csr_i/18";
            sw = rw; hw = r;
            reset = 0x0;
        } cr[5:2];
        field {
            name = "gw";
            desc = "GW: GMII write.
- 0: Read operation.
- 1: Write operation.";
            sw = rw; hw = r;
            reset = 0x0;
        } gw[1:1];
        field {
            name = "gb";
            desc = "GB: GMII busy. Before writing the GMACn_GMII_DATA and GMACn_GMII_ADDR registers, this bit must read back as 0. While accessing the external PHY, software must keep this bit set to 1. The value of GMACn_GMII_DATA is valid only after the GMAC sets this bit to 0.
- 0: GMII busy;
- 1: GMII idle, read and write operations can be performed. (data sheet access type RWSC)";
            sw = rw; hw = r;
            reset = 0x0;
        } gb[0:0];
    } GMACN_GMII_ADDR_1 @ 0x4010;
    reg {
        name = "GMACN_GMII_DATA";
        desc = "GMACN_GMII_DATA is the GMII data register. It stores the data to be written to the external PHY specific register (determined by GMACn_GMII_ADDR), and can also store the data read from the external PHY specific register. GMACN_GMII_DATA (offset 0x0014+Nx0x4000 (N = 0~1), total reset 0x0000_0000; PROVEN: Hi3535 data sheet, PDF page 815, section 5.6).";
        field {
            name = "reserved";
            desc = "Reserved.";
            sw = r; hw = w;
            reset = 0x0;
        } reserved_31_16[31:16];
        field {
            name = "gd";
            desc = "GD: GMII data. This data is the data read from the external PHY register after a read operation, or the data to be written to the external PHY register before a write operation.";
            sw = rw; hw = r;
            reset = 0x0;
        } gd[15:0];
    } GMACN_GMII_DATA_0 @ 0x14;
    reg {
        name = "GMACN_GMII_DATA";
        desc = "GMACN_GMII_DATA is the GMII data register. It stores the data to be written to the external PHY specific register (determined by GMACn_GMII_ADDR), and can also store the data read from the external PHY specific register. GMACN_GMII_DATA (offset 0x0014+Nx0x4000 (N = 0~1), total reset 0x0000_0000; PROVEN: Hi3535 data sheet, PDF page 815, section 5.6).";
        field {
            name = "reserved";
            desc = "Reserved.";
            sw = r; hw = w;
            reset = 0x0;
        } reserved_31_16[31:16];
        field {
            name = "gd";
            desc = "GD: GMII data. This data is the data read from the external PHY register after a read operation, or the data to be written to the external PHY register before a write operation.";
            sw = rw; hw = r;
            reset = 0x0;
        } gd[15:0];
    } GMACN_GMII_DATA_1 @ 0x4014;
    reg {
        name = "GMACN_ADDR0_HIGH";
        desc = "GMACN_ADDR0_HIGH is the register holding the high 16 bits [47:32] of the first MAC address of GMACn (0 to 1). GMACN_ADDR0_HIGH (offset 0x0040+Nx0x4000 (N = 0~1), total reset 0x8000_FFFF; PROVEN: Hi3535 data sheet, PDF page 815, section 5.6).";
        field {
            name = "mo";
            desc = "MO: constant 1.";
            sw = r; hw = w;
            reset = 0x1;
        } mo[31:31];
        field {
            name = "reserved";
            desc = "Reserved.";
            sw = r; hw = w;
            reset = 0x0;
        } reserved_30_16[30:16];
        field {
            name = "a_47_32";
            desc = "A[47:32]: Contains the upper 16 bits [47:32] of the 6-byte MAC address, used for receive frame filtering and for transmitting pause frames.";
            sw = rw; hw = r;
            reset = 0xffff;
        } a_47_32[15:0];
    } GMACN_ADDR0_HIGH_0 @ 0x40;
    reg {
        name = "GMACN_ADDR0_HIGH";
        desc = "GMACN_ADDR0_HIGH is the register holding the high 16 bits [47:32] of the first MAC address of GMACn (0 to 1). GMACN_ADDR0_HIGH (offset 0x0040+Nx0x4000 (N = 0~1), total reset 0x8000_FFFF; PROVEN: Hi3535 data sheet, PDF page 815, section 5.6).";
        field {
            name = "mo";
            desc = "MO: constant 1.";
            sw = r; hw = w;
            reset = 0x1;
        } mo[31:31];
        field {
            name = "reserved";
            desc = "Reserved.";
            sw = r; hw = w;
            reset = 0x0;
        } reserved_30_16[30:16];
        field {
            name = "a_47_32";
            desc = "A[47:32]: Contains the upper 16 bits [47:32] of the 6-byte MAC address, used for receive frame filtering and for transmitting pause frames.";
            sw = rw; hw = r;
            reset = 0xffff;
        } a_47_32[15:0];
    } GMACN_ADDR0_HIGH_1 @ 0x4040;
    reg {
        name = "GMACN_ADDRX_HIGH";
        desc = "GMACN_ADDRX_HIGH is the register for the high 16 bits [47:32] of the X-th (1 to 15) MAC address of GMACn (0 to 1). GMACN_ADDRX_HIGH (offset 0x0048+Xx0x8 (X = 0~14), total reset 0x0000_FFFF; PROVEN: Hi3535 data sheet, PDF page 816, section 5.6). Registers for X = 1..15 (offset 0x40 + n x 0x4000 + X x 0x8; instances 0..14 below are X = 1..15). Address registers 1-15 (X) and 16-31 (Y) of GMAC n sit at the formula offsets of the data sheet (0x40 + n x 0x4000 + X x 0x8 / 0x780 + n x 0x4000 + Y x 0x8); modelled for GMAC 0 as 15 resp. 16 instances, GMAC 1 is the same layout 0x4000 higher.";
        field {
            name = "ae";
            desc = "AE: address enable.
- 0: When this bit is 0, the address filter module ignores this MAC address;
- 1: When this bit is 1, the address filter module uses this MAC address for perfect filtering.";
            sw = rw; hw = r;
            reset = 0x0;
        } ae[31:31];
        field {
            name = "sa";
            desc = "SA: source address.
- 0: This MAC address is used for comparison with the DA of received frames.
- 1: This MAC address is used for comparison with the SA of received frames.";
            sw = rw; hw = r;
            reset = 0x0;
        } sa[30:30];
        field {
            name = "mbc";
            desc = "MBC: mask byte control. These bits are the mask control bits for each byte of the MAC address. Each bit means:
- 0: The GMAC uses this byte for address filtering;
- 1: The GMAC does not use this byte for address filtering.
The MAC address byte corresponding to each bit is as follows: bit[29]: byte 6 of the MAC address [47:40]; bit[28]: byte 5 of the MAC address [39:32]; bit[27]: byte 4 of the MAC address [31:24]; bit[26]: byte 3 of the MAC address [23:16]; bit[25]: byte 2 of the MAC address [15:8]; bit[24]: byte 1 of the MAC address [7:0].";
            sw = rw; hw = r;
            reset = 0x0;
        } mbc[29:24];
        field {
            name = "reserved";
            desc = "Reserved.";
            sw = r; hw = w;
            reset = 0x0;
        } reserved_23_16[23:16];
        field {
            name = "mac_addr_h16";
            desc = "A[47:32]: Contains the upper 16 bits [47:32] of the 6-byte MAC address, used for receive frame filtering and for transmitting pause frames.";
            sw = rw; hw = r;
            reset = 0xffff;
        } mac_addr_h16[15:0];
    } GMACN_ADDRX_HIGH_0 @ 0x48;
    reg {
        name = "GMACN_ADDRX_HIGH";
        desc = "GMACN_ADDRX_HIGH is the register for the high 16 bits [47:32] of the X-th (1 to 15) MAC address of GMACn (0 to 1). GMACN_ADDRX_HIGH (offset 0x0048+Xx0x8 (X = 0~14), total reset 0x0000_FFFF; PROVEN: Hi3535 data sheet, PDF page 816, section 5.6). Registers for X = 1..15 (offset 0x40 + n x 0x4000 + X x 0x8; instances 0..14 below are X = 1..15). Address registers 1-15 (X) and 16-31 (Y) of GMAC n sit at the formula offsets of the data sheet (0x40 + n x 0x4000 + X x 0x8 / 0x780 + n x 0x4000 + Y x 0x8); modelled for GMAC 0 as 15 resp. 16 instances, GMAC 1 is the same layout 0x4000 higher.";
        field {
            name = "ae";
            desc = "AE: address enable.
- 0: When this bit is 0, the address filter module ignores this MAC address;
- 1: When this bit is 1, the address filter module uses this MAC address for perfect filtering.";
            sw = rw; hw = r;
            reset = 0x0;
        } ae[31:31];
        field {
            name = "sa";
            desc = "SA: source address.
- 0: This MAC address is used for comparison with the DA of received frames.
- 1: This MAC address is used for comparison with the SA of received frames.";
            sw = rw; hw = r;
            reset = 0x0;
        } sa[30:30];
        field {
            name = "mbc";
            desc = "MBC: mask byte control. These bits are the mask control bits for each byte of the MAC address. Each bit means:
- 0: The GMAC uses this byte for address filtering;
- 1: The GMAC does not use this byte for address filtering.
The MAC address byte corresponding to each bit is as follows: bit[29]: byte 6 of the MAC address [47:40]; bit[28]: byte 5 of the MAC address [39:32]; bit[27]: byte 4 of the MAC address [31:24]; bit[26]: byte 3 of the MAC address [23:16]; bit[25]: byte 2 of the MAC address [15:8]; bit[24]: byte 1 of the MAC address [7:0].";
            sw = rw; hw = r;
            reset = 0x0;
        } mbc[29:24];
        field {
            name = "reserved";
            desc = "Reserved.";
            sw = r; hw = w;
            reset = 0x0;
        } reserved_23_16[23:16];
        field {
            name = "mac_addr_h16";
            desc = "A[47:32]: Contains the upper 16 bits [47:32] of the 6-byte MAC address, used for receive frame filtering and for transmitting pause frames.";
            sw = rw; hw = r;
            reset = 0xffff;
        } mac_addr_h16[15:0];
    } GMACN_ADDRX_HIGH_1 @ 0x50;
    reg {
        name = "GMACN_ADDRX_HIGH";
        desc = "GMACN_ADDRX_HIGH is the register for the high 16 bits [47:32] of the X-th (1 to 15) MAC address of GMACn (0 to 1). GMACN_ADDRX_HIGH (offset 0x0048+Xx0x8 (X = 0~14), total reset 0x0000_FFFF; PROVEN: Hi3535 data sheet, PDF page 816, section 5.6). Registers for X = 1..15 (offset 0x40 + n x 0x4000 + X x 0x8; instances 0..14 below are X = 1..15). Address registers 1-15 (X) and 16-31 (Y) of GMAC n sit at the formula offsets of the data sheet (0x40 + n x 0x4000 + X x 0x8 / 0x780 + n x 0x4000 + Y x 0x8); modelled for GMAC 0 as 15 resp. 16 instances, GMAC 1 is the same layout 0x4000 higher.";
        field {
            name = "ae";
            desc = "AE: address enable.
- 0: When this bit is 0, the address filter module ignores this MAC address;
- 1: When this bit is 1, the address filter module uses this MAC address for perfect filtering.";
            sw = rw; hw = r;
            reset = 0x0;
        } ae[31:31];
        field {
            name = "sa";
            desc = "SA: source address.
- 0: This MAC address is used for comparison with the DA of received frames.
- 1: This MAC address is used for comparison with the SA of received frames.";
            sw = rw; hw = r;
            reset = 0x0;
        } sa[30:30];
        field {
            name = "mbc";
            desc = "MBC: mask byte control. These bits are the mask control bits for each byte of the MAC address. Each bit means:
- 0: The GMAC uses this byte for address filtering;
- 1: The GMAC does not use this byte for address filtering.
The MAC address byte corresponding to each bit is as follows: bit[29]: byte 6 of the MAC address [47:40]; bit[28]: byte 5 of the MAC address [39:32]; bit[27]: byte 4 of the MAC address [31:24]; bit[26]: byte 3 of the MAC address [23:16]; bit[25]: byte 2 of the MAC address [15:8]; bit[24]: byte 1 of the MAC address [7:0].";
            sw = rw; hw = r;
            reset = 0x0;
        } mbc[29:24];
        field {
            name = "reserved";
            desc = "Reserved.";
            sw = r; hw = w;
            reset = 0x0;
        } reserved_23_16[23:16];
        field {
            name = "mac_addr_h16";
            desc = "A[47:32]: Contains the upper 16 bits [47:32] of the 6-byte MAC address, used for receive frame filtering and for transmitting pause frames.";
            sw = rw; hw = r;
            reset = 0xffff;
        } mac_addr_h16[15:0];
    } GMACN_ADDRX_HIGH_2 @ 0x58;
    reg {
        name = "GMACN_ADDRX_HIGH";
        desc = "GMACN_ADDRX_HIGH is the register for the high 16 bits [47:32] of the X-th (1 to 15) MAC address of GMACn (0 to 1). GMACN_ADDRX_HIGH (offset 0x0048+Xx0x8 (X = 0~14), total reset 0x0000_FFFF; PROVEN: Hi3535 data sheet, PDF page 816, section 5.6). Registers for X = 1..15 (offset 0x40 + n x 0x4000 + X x 0x8; instances 0..14 below are X = 1..15). Address registers 1-15 (X) and 16-31 (Y) of GMAC n sit at the formula offsets of the data sheet (0x40 + n x 0x4000 + X x 0x8 / 0x780 + n x 0x4000 + Y x 0x8); modelled for GMAC 0 as 15 resp. 16 instances, GMAC 1 is the same layout 0x4000 higher.";
        field {
            name = "ae";
            desc = "AE: address enable.
- 0: When this bit is 0, the address filter module ignores this MAC address;
- 1: When this bit is 1, the address filter module uses this MAC address for perfect filtering.";
            sw = rw; hw = r;
            reset = 0x0;
        } ae[31:31];
        field {
            name = "sa";
            desc = "SA: source address.
- 0: This MAC address is used for comparison with the DA of received frames.
- 1: This MAC address is used for comparison with the SA of received frames.";
            sw = rw; hw = r;
            reset = 0x0;
        } sa[30:30];
        field {
            name = "mbc";
            desc = "MBC: mask byte control. These bits are the mask control bits for each byte of the MAC address. Each bit means:
- 0: The GMAC uses this byte for address filtering;
- 1: The GMAC does not use this byte for address filtering.
The MAC address byte corresponding to each bit is as follows: bit[29]: byte 6 of the MAC address [47:40]; bit[28]: byte 5 of the MAC address [39:32]; bit[27]: byte 4 of the MAC address [31:24]; bit[26]: byte 3 of the MAC address [23:16]; bit[25]: byte 2 of the MAC address [15:8]; bit[24]: byte 1 of the MAC address [7:0].";
            sw = rw; hw = r;
            reset = 0x0;
        } mbc[29:24];
        field {
            name = "reserved";
            desc = "Reserved.";
            sw = r; hw = w;
            reset = 0x0;
        } reserved_23_16[23:16];
        field {
            name = "mac_addr_h16";
            desc = "A[47:32]: Contains the upper 16 bits [47:32] of the 6-byte MAC address, used for receive frame filtering and for transmitting pause frames.";
            sw = rw; hw = r;
            reset = 0xffff;
        } mac_addr_h16[15:0];
    } GMACN_ADDRX_HIGH_3 @ 0x60;
    reg {
        name = "GMACN_ADDRX_HIGH";
        desc = "GMACN_ADDRX_HIGH is the register for the high 16 bits [47:32] of the X-th (1 to 15) MAC address of GMACn (0 to 1). GMACN_ADDRX_HIGH (offset 0x0048+Xx0x8 (X = 0~14), total reset 0x0000_FFFF; PROVEN: Hi3535 data sheet, PDF page 816, section 5.6). Registers for X = 1..15 (offset 0x40 + n x 0x4000 + X x 0x8; instances 0..14 below are X = 1..15). Address registers 1-15 (X) and 16-31 (Y) of GMAC n sit at the formula offsets of the data sheet (0x40 + n x 0x4000 + X x 0x8 / 0x780 + n x 0x4000 + Y x 0x8); modelled for GMAC 0 as 15 resp. 16 instances, GMAC 1 is the same layout 0x4000 higher.";
        field {
            name = "ae";
            desc = "AE: address enable.
- 0: When this bit is 0, the address filter module ignores this MAC address;
- 1: When this bit is 1, the address filter module uses this MAC address for perfect filtering.";
            sw = rw; hw = r;
            reset = 0x0;
        } ae[31:31];
        field {
            name = "sa";
            desc = "SA: source address.
- 0: This MAC address is used for comparison with the DA of received frames.
- 1: This MAC address is used for comparison with the SA of received frames.";
            sw = rw; hw = r;
            reset = 0x0;
        } sa[30:30];
        field {
            name = "mbc";
            desc = "MBC: mask byte control. These bits are the mask control bits for each byte of the MAC address. Each bit means:
- 0: The GMAC uses this byte for address filtering;
- 1: The GMAC does not use this byte for address filtering.
The MAC address byte corresponding to each bit is as follows: bit[29]: byte 6 of the MAC address [47:40]; bit[28]: byte 5 of the MAC address [39:32]; bit[27]: byte 4 of the MAC address [31:24]; bit[26]: byte 3 of the MAC address [23:16]; bit[25]: byte 2 of the MAC address [15:8]; bit[24]: byte 1 of the MAC address [7:0].";
            sw = rw; hw = r;
            reset = 0x0;
        } mbc[29:24];
        field {
            name = "reserved";
            desc = "Reserved.";
            sw = r; hw = w;
            reset = 0x0;
        } reserved_23_16[23:16];
        field {
            name = "mac_addr_h16";
            desc = "A[47:32]: Contains the upper 16 bits [47:32] of the 6-byte MAC address, used for receive frame filtering and for transmitting pause frames.";
            sw = rw; hw = r;
            reset = 0xffff;
        } mac_addr_h16[15:0];
    } GMACN_ADDRX_HIGH_4 @ 0x68;
    reg {
        name = "GMACN_ADDRX_HIGH";
        desc = "GMACN_ADDRX_HIGH is the register for the high 16 bits [47:32] of the X-th (1 to 15) MAC address of GMACn (0 to 1). GMACN_ADDRX_HIGH (offset 0x0048+Xx0x8 (X = 0~14), total reset 0x0000_FFFF; PROVEN: Hi3535 data sheet, PDF page 816, section 5.6). Registers for X = 1..15 (offset 0x40 + n x 0x4000 + X x 0x8; instances 0..14 below are X = 1..15). Address registers 1-15 (X) and 16-31 (Y) of GMAC n sit at the formula offsets of the data sheet (0x40 + n x 0x4000 + X x 0x8 / 0x780 + n x 0x4000 + Y x 0x8); modelled for GMAC 0 as 15 resp. 16 instances, GMAC 1 is the same layout 0x4000 higher.";
        field {
            name = "ae";
            desc = "AE: address enable.
- 0: When this bit is 0, the address filter module ignores this MAC address;
- 1: When this bit is 1, the address filter module uses this MAC address for perfect filtering.";
            sw = rw; hw = r;
            reset = 0x0;
        } ae[31:31];
        field {
            name = "sa";
            desc = "SA: source address.
- 0: This MAC address is used for comparison with the DA of received frames.
- 1: This MAC address is used for comparison with the SA of received frames.";
            sw = rw; hw = r;
            reset = 0x0;
        } sa[30:30];
        field {
            name = "mbc";
            desc = "MBC: mask byte control. These bits are the mask control bits for each byte of the MAC address. Each bit means:
- 0: The GMAC uses this byte for address filtering;
- 1: The GMAC does not use this byte for address filtering.
The MAC address byte corresponding to each bit is as follows: bit[29]: byte 6 of the MAC address [47:40]; bit[28]: byte 5 of the MAC address [39:32]; bit[27]: byte 4 of the MAC address [31:24]; bit[26]: byte 3 of the MAC address [23:16]; bit[25]: byte 2 of the MAC address [15:8]; bit[24]: byte 1 of the MAC address [7:0].";
            sw = rw; hw = r;
            reset = 0x0;
        } mbc[29:24];
        field {
            name = "reserved";
            desc = "Reserved.";
            sw = r; hw = w;
            reset = 0x0;
        } reserved_23_16[23:16];
        field {
            name = "mac_addr_h16";
            desc = "A[47:32]: Contains the upper 16 bits [47:32] of the 6-byte MAC address, used for receive frame filtering and for transmitting pause frames.";
            sw = rw; hw = r;
            reset = 0xffff;
        } mac_addr_h16[15:0];
    } GMACN_ADDRX_HIGH_5 @ 0x70;
    reg {
        name = "GMACN_ADDRX_HIGH";
        desc = "GMACN_ADDRX_HIGH is the register for the high 16 bits [47:32] of the X-th (1 to 15) MAC address of GMACn (0 to 1). GMACN_ADDRX_HIGH (offset 0x0048+Xx0x8 (X = 0~14), total reset 0x0000_FFFF; PROVEN: Hi3535 data sheet, PDF page 816, section 5.6). Registers for X = 1..15 (offset 0x40 + n x 0x4000 + X x 0x8; instances 0..14 below are X = 1..15). Address registers 1-15 (X) and 16-31 (Y) of GMAC n sit at the formula offsets of the data sheet (0x40 + n x 0x4000 + X x 0x8 / 0x780 + n x 0x4000 + Y x 0x8); modelled for GMAC 0 as 15 resp. 16 instances, GMAC 1 is the same layout 0x4000 higher.";
        field {
            name = "ae";
            desc = "AE: address enable.
- 0: When this bit is 0, the address filter module ignores this MAC address;
- 1: When this bit is 1, the address filter module uses this MAC address for perfect filtering.";
            sw = rw; hw = r;
            reset = 0x0;
        } ae[31:31];
        field {
            name = "sa";
            desc = "SA: source address.
- 0: This MAC address is used for comparison with the DA of received frames.
- 1: This MAC address is used for comparison with the SA of received frames.";
            sw = rw; hw = r;
            reset = 0x0;
        } sa[30:30];
        field {
            name = "mbc";
            desc = "MBC: mask byte control. These bits are the mask control bits for each byte of the MAC address. Each bit means:
- 0: The GMAC uses this byte for address filtering;
- 1: The GMAC does not use this byte for address filtering.
The MAC address byte corresponding to each bit is as follows: bit[29]: byte 6 of the MAC address [47:40]; bit[28]: byte 5 of the MAC address [39:32]; bit[27]: byte 4 of the MAC address [31:24]; bit[26]: byte 3 of the MAC address [23:16]; bit[25]: byte 2 of the MAC address [15:8]; bit[24]: byte 1 of the MAC address [7:0].";
            sw = rw; hw = r;
            reset = 0x0;
        } mbc[29:24];
        field {
            name = "reserved";
            desc = "Reserved.";
            sw = r; hw = w;
            reset = 0x0;
        } reserved_23_16[23:16];
        field {
            name = "mac_addr_h16";
            desc = "A[47:32]: Contains the upper 16 bits [47:32] of the 6-byte MAC address, used for receive frame filtering and for transmitting pause frames.";
            sw = rw; hw = r;
            reset = 0xffff;
        } mac_addr_h16[15:0];
    } GMACN_ADDRX_HIGH_6 @ 0x78;
    reg {
        name = "GMACN_ADDRX_HIGH";
        desc = "GMACN_ADDRX_HIGH is the register for the high 16 bits [47:32] of the X-th (1 to 15) MAC address of GMACn (0 to 1). GMACN_ADDRX_HIGH (offset 0x0048+Xx0x8 (X = 0~14), total reset 0x0000_FFFF; PROVEN: Hi3535 data sheet, PDF page 816, section 5.6). Registers for X = 1..15 (offset 0x40 + n x 0x4000 + X x 0x8; instances 0..14 below are X = 1..15). Address registers 1-15 (X) and 16-31 (Y) of GMAC n sit at the formula offsets of the data sheet (0x40 + n x 0x4000 + X x 0x8 / 0x780 + n x 0x4000 + Y x 0x8); modelled for GMAC 0 as 15 resp. 16 instances, GMAC 1 is the same layout 0x4000 higher.";
        field {
            name = "ae";
            desc = "AE: address enable.
- 0: When this bit is 0, the address filter module ignores this MAC address;
- 1: When this bit is 1, the address filter module uses this MAC address for perfect filtering.";
            sw = rw; hw = r;
            reset = 0x0;
        } ae[31:31];
        field {
            name = "sa";
            desc = "SA: source address.
- 0: This MAC address is used for comparison with the DA of received frames.
- 1: This MAC address is used for comparison with the SA of received frames.";
            sw = rw; hw = r;
            reset = 0x0;
        } sa[30:30];
        field {
            name = "mbc";
            desc = "MBC: mask byte control. These bits are the mask control bits for each byte of the MAC address. Each bit means:
- 0: The GMAC uses this byte for address filtering;
- 1: The GMAC does not use this byte for address filtering.
The MAC address byte corresponding to each bit is as follows: bit[29]: byte 6 of the MAC address [47:40]; bit[28]: byte 5 of the MAC address [39:32]; bit[27]: byte 4 of the MAC address [31:24]; bit[26]: byte 3 of the MAC address [23:16]; bit[25]: byte 2 of the MAC address [15:8]; bit[24]: byte 1 of the MAC address [7:0].";
            sw = rw; hw = r;
            reset = 0x0;
        } mbc[29:24];
        field {
            name = "reserved";
            desc = "Reserved.";
            sw = r; hw = w;
            reset = 0x0;
        } reserved_23_16[23:16];
        field {
            name = "mac_addr_h16";
            desc = "A[47:32]: Contains the upper 16 bits [47:32] of the 6-byte MAC address, used for receive frame filtering and for transmitting pause frames.";
            sw = rw; hw = r;
            reset = 0xffff;
        } mac_addr_h16[15:0];
    } GMACN_ADDRX_HIGH_7 @ 0x80;
    reg {
        name = "GMACN_ADDRX_HIGH";
        desc = "GMACN_ADDRX_HIGH is the register for the high 16 bits [47:32] of the X-th (1 to 15) MAC address of GMACn (0 to 1). GMACN_ADDRX_HIGH (offset 0x0048+Xx0x8 (X = 0~14), total reset 0x0000_FFFF; PROVEN: Hi3535 data sheet, PDF page 816, section 5.6). Registers for X = 1..15 (offset 0x40 + n x 0x4000 + X x 0x8; instances 0..14 below are X = 1..15). Address registers 1-15 (X) and 16-31 (Y) of GMAC n sit at the formula offsets of the data sheet (0x40 + n x 0x4000 + X x 0x8 / 0x780 + n x 0x4000 + Y x 0x8); modelled for GMAC 0 as 15 resp. 16 instances, GMAC 1 is the same layout 0x4000 higher.";
        field {
            name = "ae";
            desc = "AE: address enable.
- 0: When this bit is 0, the address filter module ignores this MAC address;
- 1: When this bit is 1, the address filter module uses this MAC address for perfect filtering.";
            sw = rw; hw = r;
            reset = 0x0;
        } ae[31:31];
        field {
            name = "sa";
            desc = "SA: source address.
- 0: This MAC address is used for comparison with the DA of received frames.
- 1: This MAC address is used for comparison with the SA of received frames.";
            sw = rw; hw = r;
            reset = 0x0;
        } sa[30:30];
        field {
            name = "mbc";
            desc = "MBC: mask byte control. These bits are the mask control bits for each byte of the MAC address. Each bit means:
- 0: The GMAC uses this byte for address filtering;
- 1: The GMAC does not use this byte for address filtering.
The MAC address byte corresponding to each bit is as follows: bit[29]: byte 6 of the MAC address [47:40]; bit[28]: byte 5 of the MAC address [39:32]; bit[27]: byte 4 of the MAC address [31:24]; bit[26]: byte 3 of the MAC address [23:16]; bit[25]: byte 2 of the MAC address [15:8]; bit[24]: byte 1 of the MAC address [7:0].";
            sw = rw; hw = r;
            reset = 0x0;
        } mbc[29:24];
        field {
            name = "reserved";
            desc = "Reserved.";
            sw = r; hw = w;
            reset = 0x0;
        } reserved_23_16[23:16];
        field {
            name = "mac_addr_h16";
            desc = "A[47:32]: Contains the upper 16 bits [47:32] of the 6-byte MAC address, used for receive frame filtering and for transmitting pause frames.";
            sw = rw; hw = r;
            reset = 0xffff;
        } mac_addr_h16[15:0];
    } GMACN_ADDRX_HIGH_8 @ 0x88;
    reg {
        name = "GMACN_ADDRX_HIGH";
        desc = "GMACN_ADDRX_HIGH is the register for the high 16 bits [47:32] of the X-th (1 to 15) MAC address of GMACn (0 to 1). GMACN_ADDRX_HIGH (offset 0x0048+Xx0x8 (X = 0~14), total reset 0x0000_FFFF; PROVEN: Hi3535 data sheet, PDF page 816, section 5.6). Registers for X = 1..15 (offset 0x40 + n x 0x4000 + X x 0x8; instances 0..14 below are X = 1..15). Address registers 1-15 (X) and 16-31 (Y) of GMAC n sit at the formula offsets of the data sheet (0x40 + n x 0x4000 + X x 0x8 / 0x780 + n x 0x4000 + Y x 0x8); modelled for GMAC 0 as 15 resp. 16 instances, GMAC 1 is the same layout 0x4000 higher.";
        field {
            name = "ae";
            desc = "AE: address enable.
- 0: When this bit is 0, the address filter module ignores this MAC address;
- 1: When this bit is 1, the address filter module uses this MAC address for perfect filtering.";
            sw = rw; hw = r;
            reset = 0x0;
        } ae[31:31];
        field {
            name = "sa";
            desc = "SA: source address.
- 0: This MAC address is used for comparison with the DA of received frames.
- 1: This MAC address is used for comparison with the SA of received frames.";
            sw = rw; hw = r;
            reset = 0x0;
        } sa[30:30];
        field {
            name = "mbc";
            desc = "MBC: mask byte control. These bits are the mask control bits for each byte of the MAC address. Each bit means:
- 0: The GMAC uses this byte for address filtering;
- 1: The GMAC does not use this byte for address filtering.
The MAC address byte corresponding to each bit is as follows: bit[29]: byte 6 of the MAC address [47:40]; bit[28]: byte 5 of the MAC address [39:32]; bit[27]: byte 4 of the MAC address [31:24]; bit[26]: byte 3 of the MAC address [23:16]; bit[25]: byte 2 of the MAC address [15:8]; bit[24]: byte 1 of the MAC address [7:0].";
            sw = rw; hw = r;
            reset = 0x0;
        } mbc[29:24];
        field {
            name = "reserved";
            desc = "Reserved.";
            sw = r; hw = w;
            reset = 0x0;
        } reserved_23_16[23:16];
        field {
            name = "mac_addr_h16";
            desc = "A[47:32]: Contains the upper 16 bits [47:32] of the 6-byte MAC address, used for receive frame filtering and for transmitting pause frames.";
            sw = rw; hw = r;
            reset = 0xffff;
        } mac_addr_h16[15:0];
    } GMACN_ADDRX_HIGH_9 @ 0x90;
    reg {
        name = "GMACN_ADDRX_HIGH";
        desc = "GMACN_ADDRX_HIGH is the register for the high 16 bits [47:32] of the X-th (1 to 15) MAC address of GMACn (0 to 1). GMACN_ADDRX_HIGH (offset 0x0048+Xx0x8 (X = 0~14), total reset 0x0000_FFFF; PROVEN: Hi3535 data sheet, PDF page 816, section 5.6). Registers for X = 1..15 (offset 0x40 + n x 0x4000 + X x 0x8; instances 0..14 below are X = 1..15). Address registers 1-15 (X) and 16-31 (Y) of GMAC n sit at the formula offsets of the data sheet (0x40 + n x 0x4000 + X x 0x8 / 0x780 + n x 0x4000 + Y x 0x8); modelled for GMAC 0 as 15 resp. 16 instances, GMAC 1 is the same layout 0x4000 higher.";
        field {
            name = "ae";
            desc = "AE: address enable.
- 0: When this bit is 0, the address filter module ignores this MAC address;
- 1: When this bit is 1, the address filter module uses this MAC address for perfect filtering.";
            sw = rw; hw = r;
            reset = 0x0;
        } ae[31:31];
        field {
            name = "sa";
            desc = "SA: source address.
- 0: This MAC address is used for comparison with the DA of received frames.
- 1: This MAC address is used for comparison with the SA of received frames.";
            sw = rw; hw = r;
            reset = 0x0;
        } sa[30:30];
        field {
            name = "mbc";
            desc = "MBC: mask byte control. These bits are the mask control bits for each byte of the MAC address. Each bit means:
- 0: The GMAC uses this byte for address filtering;
- 1: The GMAC does not use this byte for address filtering.
The MAC address byte corresponding to each bit is as follows: bit[29]: byte 6 of the MAC address [47:40]; bit[28]: byte 5 of the MAC address [39:32]; bit[27]: byte 4 of the MAC address [31:24]; bit[26]: byte 3 of the MAC address [23:16]; bit[25]: byte 2 of the MAC address [15:8]; bit[24]: byte 1 of the MAC address [7:0].";
            sw = rw; hw = r;
            reset = 0x0;
        } mbc[29:24];
        field {
            name = "reserved";
            desc = "Reserved.";
            sw = r; hw = w;
            reset = 0x0;
        } reserved_23_16[23:16];
        field {
            name = "mac_addr_h16";
            desc = "A[47:32]: Contains the upper 16 bits [47:32] of the 6-byte MAC address, used for receive frame filtering and for transmitting pause frames.";
            sw = rw; hw = r;
            reset = 0xffff;
        } mac_addr_h16[15:0];
    } GMACN_ADDRX_HIGH_10 @ 0x98;
    reg {
        name = "GMACN_ADDRX_HIGH";
        desc = "GMACN_ADDRX_HIGH is the register for the high 16 bits [47:32] of the X-th (1 to 15) MAC address of GMACn (0 to 1). GMACN_ADDRX_HIGH (offset 0x0048+Xx0x8 (X = 0~14), total reset 0x0000_FFFF; PROVEN: Hi3535 data sheet, PDF page 816, section 5.6). Registers for X = 1..15 (offset 0x40 + n x 0x4000 + X x 0x8; instances 0..14 below are X = 1..15). Address registers 1-15 (X) and 16-31 (Y) of GMAC n sit at the formula offsets of the data sheet (0x40 + n x 0x4000 + X x 0x8 / 0x780 + n x 0x4000 + Y x 0x8); modelled for GMAC 0 as 15 resp. 16 instances, GMAC 1 is the same layout 0x4000 higher.";
        field {
            name = "ae";
            desc = "AE: address enable.
- 0: When this bit is 0, the address filter module ignores this MAC address;
- 1: When this bit is 1, the address filter module uses this MAC address for perfect filtering.";
            sw = rw; hw = r;
            reset = 0x0;
        } ae[31:31];
        field {
            name = "sa";
            desc = "SA: source address.
- 0: This MAC address is used for comparison with the DA of received frames.
- 1: This MAC address is used for comparison with the SA of received frames.";
            sw = rw; hw = r;
            reset = 0x0;
        } sa[30:30];
        field {
            name = "mbc";
            desc = "MBC: mask byte control. These bits are the mask control bits for each byte of the MAC address. Each bit means:
- 0: The GMAC uses this byte for address filtering;
- 1: The GMAC does not use this byte for address filtering.
The MAC address byte corresponding to each bit is as follows: bit[29]: byte 6 of the MAC address [47:40]; bit[28]: byte 5 of the MAC address [39:32]; bit[27]: byte 4 of the MAC address [31:24]; bit[26]: byte 3 of the MAC address [23:16]; bit[25]: byte 2 of the MAC address [15:8]; bit[24]: byte 1 of the MAC address [7:0].";
            sw = rw; hw = r;
            reset = 0x0;
        } mbc[29:24];
        field {
            name = "reserved";
            desc = "Reserved.";
            sw = r; hw = w;
            reset = 0x0;
        } reserved_23_16[23:16];
        field {
            name = "mac_addr_h16";
            desc = "A[47:32]: Contains the upper 16 bits [47:32] of the 6-byte MAC address, used for receive frame filtering and for transmitting pause frames.";
            sw = rw; hw = r;
            reset = 0xffff;
        } mac_addr_h16[15:0];
    } GMACN_ADDRX_HIGH_11 @ 0xa0;
    reg {
        name = "GMACN_ADDRX_HIGH";
        desc = "GMACN_ADDRX_HIGH is the register for the high 16 bits [47:32] of the X-th (1 to 15) MAC address of GMACn (0 to 1). GMACN_ADDRX_HIGH (offset 0x0048+Xx0x8 (X = 0~14), total reset 0x0000_FFFF; PROVEN: Hi3535 data sheet, PDF page 816, section 5.6). Registers for X = 1..15 (offset 0x40 + n x 0x4000 + X x 0x8; instances 0..14 below are X = 1..15). Address registers 1-15 (X) and 16-31 (Y) of GMAC n sit at the formula offsets of the data sheet (0x40 + n x 0x4000 + X x 0x8 / 0x780 + n x 0x4000 + Y x 0x8); modelled for GMAC 0 as 15 resp. 16 instances, GMAC 1 is the same layout 0x4000 higher.";
        field {
            name = "ae";
            desc = "AE: address enable.
- 0: When this bit is 0, the address filter module ignores this MAC address;
- 1: When this bit is 1, the address filter module uses this MAC address for perfect filtering.";
            sw = rw; hw = r;
            reset = 0x0;
        } ae[31:31];
        field {
            name = "sa";
            desc = "SA: source address.
- 0: This MAC address is used for comparison with the DA of received frames.
- 1: This MAC address is used for comparison with the SA of received frames.";
            sw = rw; hw = r;
            reset = 0x0;
        } sa[30:30];
        field {
            name = "mbc";
            desc = "MBC: mask byte control. These bits are the mask control bits for each byte of the MAC address. Each bit means:
- 0: The GMAC uses this byte for address filtering;
- 1: The GMAC does not use this byte for address filtering.
The MAC address byte corresponding to each bit is as follows: bit[29]: byte 6 of the MAC address [47:40]; bit[28]: byte 5 of the MAC address [39:32]; bit[27]: byte 4 of the MAC address [31:24]; bit[26]: byte 3 of the MAC address [23:16]; bit[25]: byte 2 of the MAC address [15:8]; bit[24]: byte 1 of the MAC address [7:0].";
            sw = rw; hw = r;
            reset = 0x0;
        } mbc[29:24];
        field {
            name = "reserved";
            desc = "Reserved.";
            sw = r; hw = w;
            reset = 0x0;
        } reserved_23_16[23:16];
        field {
            name = "mac_addr_h16";
            desc = "A[47:32]: Contains the upper 16 bits [47:32] of the 6-byte MAC address, used for receive frame filtering and for transmitting pause frames.";
            sw = rw; hw = r;
            reset = 0xffff;
        } mac_addr_h16[15:0];
    } GMACN_ADDRX_HIGH_12 @ 0xa8;
    reg {
        name = "GMACN_ADDRX_HIGH";
        desc = "GMACN_ADDRX_HIGH is the register for the high 16 bits [47:32] of the X-th (1 to 15) MAC address of GMACn (0 to 1). GMACN_ADDRX_HIGH (offset 0x0048+Xx0x8 (X = 0~14), total reset 0x0000_FFFF; PROVEN: Hi3535 data sheet, PDF page 816, section 5.6). Registers for X = 1..15 (offset 0x40 + n x 0x4000 + X x 0x8; instances 0..14 below are X = 1..15). Address registers 1-15 (X) and 16-31 (Y) of GMAC n sit at the formula offsets of the data sheet (0x40 + n x 0x4000 + X x 0x8 / 0x780 + n x 0x4000 + Y x 0x8); modelled for GMAC 0 as 15 resp. 16 instances, GMAC 1 is the same layout 0x4000 higher.";
        field {
            name = "ae";
            desc = "AE: address enable.
- 0: When this bit is 0, the address filter module ignores this MAC address;
- 1: When this bit is 1, the address filter module uses this MAC address for perfect filtering.";
            sw = rw; hw = r;
            reset = 0x0;
        } ae[31:31];
        field {
            name = "sa";
            desc = "SA: source address.
- 0: This MAC address is used for comparison with the DA of received frames.
- 1: This MAC address is used for comparison with the SA of received frames.";
            sw = rw; hw = r;
            reset = 0x0;
        } sa[30:30];
        field {
            name = "mbc";
            desc = "MBC: mask byte control. These bits are the mask control bits for each byte of the MAC address. Each bit means:
- 0: The GMAC uses this byte for address filtering;
- 1: The GMAC does not use this byte for address filtering.
The MAC address byte corresponding to each bit is as follows: bit[29]: byte 6 of the MAC address [47:40]; bit[28]: byte 5 of the MAC address [39:32]; bit[27]: byte 4 of the MAC address [31:24]; bit[26]: byte 3 of the MAC address [23:16]; bit[25]: byte 2 of the MAC address [15:8]; bit[24]: byte 1 of the MAC address [7:0].";
            sw = rw; hw = r;
            reset = 0x0;
        } mbc[29:24];
        field {
            name = "reserved";
            desc = "Reserved.";
            sw = r; hw = w;
            reset = 0x0;
        } reserved_23_16[23:16];
        field {
            name = "mac_addr_h16";
            desc = "A[47:32]: Contains the upper 16 bits [47:32] of the 6-byte MAC address, used for receive frame filtering and for transmitting pause frames.";
            sw = rw; hw = r;
            reset = 0xffff;
        } mac_addr_h16[15:0];
    } GMACN_ADDRX_HIGH_13 @ 0xb0;
    reg {
        name = "GMACN_ADDRX_HIGH";
        desc = "GMACN_ADDRX_HIGH is the register for the high 16 bits [47:32] of the X-th (1 to 15) MAC address of GMACn (0 to 1). GMACN_ADDRX_HIGH (offset 0x0048+Xx0x8 (X = 0~14), total reset 0x0000_FFFF; PROVEN: Hi3535 data sheet, PDF page 816, section 5.6). Registers for X = 1..15 (offset 0x40 + n x 0x4000 + X x 0x8; instances 0..14 below are X = 1..15). Address registers 1-15 (X) and 16-31 (Y) of GMAC n sit at the formula offsets of the data sheet (0x40 + n x 0x4000 + X x 0x8 / 0x780 + n x 0x4000 + Y x 0x8); modelled for GMAC 0 as 15 resp. 16 instances, GMAC 1 is the same layout 0x4000 higher.";
        field {
            name = "ae";
            desc = "AE: address enable.
- 0: When this bit is 0, the address filter module ignores this MAC address;
- 1: When this bit is 1, the address filter module uses this MAC address for perfect filtering.";
            sw = rw; hw = r;
            reset = 0x0;
        } ae[31:31];
        field {
            name = "sa";
            desc = "SA: source address.
- 0: This MAC address is used for comparison with the DA of received frames.
- 1: This MAC address is used for comparison with the SA of received frames.";
            sw = rw; hw = r;
            reset = 0x0;
        } sa[30:30];
        field {
            name = "mbc";
            desc = "MBC: mask byte control. These bits are the mask control bits for each byte of the MAC address. Each bit means:
- 0: The GMAC uses this byte for address filtering;
- 1: The GMAC does not use this byte for address filtering.
The MAC address byte corresponding to each bit is as follows: bit[29]: byte 6 of the MAC address [47:40]; bit[28]: byte 5 of the MAC address [39:32]; bit[27]: byte 4 of the MAC address [31:24]; bit[26]: byte 3 of the MAC address [23:16]; bit[25]: byte 2 of the MAC address [15:8]; bit[24]: byte 1 of the MAC address [7:0].";
            sw = rw; hw = r;
            reset = 0x0;
        } mbc[29:24];
        field {
            name = "reserved";
            desc = "Reserved.";
            sw = r; hw = w;
            reset = 0x0;
        } reserved_23_16[23:16];
        field {
            name = "mac_addr_h16";
            desc = "A[47:32]: Contains the upper 16 bits [47:32] of the 6-byte MAC address, used for receive frame filtering and for transmitting pause frames.";
            sw = rw; hw = r;
            reset = 0xffff;
        } mac_addr_h16[15:0];
    } GMACN_ADDRX_HIGH_14 @ 0xb8;
    reg {
        name = "GMACN_ADDR0_LOW";
        desc = "GMACN_ADDR0_LOW is the register for the lower 32 bits [31:0] of the first MAC address of GMACn (0 to 1). GMACN_ADDR0_LOW (offset 0x0044+Nx0x4000 (N = 0~1), total reset 0xFFFF_FFFF; PROVEN: Hi3535 data sheet, PDF page 816, section 5.6).";
        field {
            name = "a_31_0";
            desc = "A[31:0]: Contains the lower 32 bits [31:0] of the 6-byte MAC address, used for receive frame filtering and for sending pause frames.";
            sw = rw; hw = r;
            reset = 0xffffffff;
        } a_31_0[31:0];
    } GMACN_ADDR0_LOW_0 @ 0x44;
    reg {
        name = "GMACN_ADDR0_LOW";
        desc = "GMACN_ADDR0_LOW is the register for the lower 32 bits [31:0] of the first MAC address of GMACn (0 to 1). GMACN_ADDR0_LOW (offset 0x0044+Nx0x4000 (N = 0~1), total reset 0xFFFF_FFFF; PROVEN: Hi3535 data sheet, PDF page 816, section 5.6).";
        field {
            name = "a_31_0";
            desc = "A[31:0]: Contains the lower 32 bits [31:0] of the 6-byte MAC address, used for receive frame filtering and for sending pause frames.";
            sw = rw; hw = r;
            reset = 0xffffffff;
        } a_31_0[31:0];
    } GMACN_ADDR0_LOW_1 @ 0x4044;
    reg {
        name = "GMACN_ADDRX_LOW";
        desc = "GMACN_ADDRX_LOW is the register for the lower 32 bits [31:0] of the X-th (1 to 15) MAC address of GMACn (0 to 1). GMACN_ADDRX_LOW (offset 0x004C+Xx0x8 (X = 0~14), total reset 0xFFFF_FFFF; PROVEN: Hi3535 data sheet, PDF page 817, section 5.6). Registers for X = 1..15 (offset 0x44 + n x 0x4000 + X x 0x8; instances 0..14 below are X = 1..15). Address registers 1-15 (X) and 16-31 (Y) of GMAC n sit at the formula offsets of the data sheet (0x40 + n x 0x4000 + X x 0x8 / 0x780 + n x 0x4000 + Y x 0x8); modelled for GMAC 0 as 15 resp. 16 instances, GMAC 1 is the same layout 0x4000 higher.";
        field {
            name = "a_31_0";
            desc = "A[31:0]: Contains the lower 32 bits [31:0] of the 6-byte MAC address, used for receive frame filtering and for sending pause frames.";
            sw = rw; hw = r;
            reset = 0xffffffff;
        } a_31_0[31:0];
    } GMACN_ADDRX_LOW_0 @ 0x4c;
    reg {
        name = "GMACN_ADDRX_LOW";
        desc = "GMACN_ADDRX_LOW is the register for the lower 32 bits [31:0] of the X-th (1 to 15) MAC address of GMACn (0 to 1). GMACN_ADDRX_LOW (offset 0x004C+Xx0x8 (X = 0~14), total reset 0xFFFF_FFFF; PROVEN: Hi3535 data sheet, PDF page 817, section 5.6). Registers for X = 1..15 (offset 0x44 + n x 0x4000 + X x 0x8; instances 0..14 below are X = 1..15). Address registers 1-15 (X) and 16-31 (Y) of GMAC n sit at the formula offsets of the data sheet (0x40 + n x 0x4000 + X x 0x8 / 0x780 + n x 0x4000 + Y x 0x8); modelled for GMAC 0 as 15 resp. 16 instances, GMAC 1 is the same layout 0x4000 higher.";
        field {
            name = "a_31_0";
            desc = "A[31:0]: Contains the lower 32 bits [31:0] of the 6-byte MAC address, used for receive frame filtering and for sending pause frames.";
            sw = rw; hw = r;
            reset = 0xffffffff;
        } a_31_0[31:0];
    } GMACN_ADDRX_LOW_1 @ 0x54;
    reg {
        name = "GMACN_ADDRX_LOW";
        desc = "GMACN_ADDRX_LOW is the register for the lower 32 bits [31:0] of the X-th (1 to 15) MAC address of GMACn (0 to 1). GMACN_ADDRX_LOW (offset 0x004C+Xx0x8 (X = 0~14), total reset 0xFFFF_FFFF; PROVEN: Hi3535 data sheet, PDF page 817, section 5.6). Registers for X = 1..15 (offset 0x44 + n x 0x4000 + X x 0x8; instances 0..14 below are X = 1..15). Address registers 1-15 (X) and 16-31 (Y) of GMAC n sit at the formula offsets of the data sheet (0x40 + n x 0x4000 + X x 0x8 / 0x780 + n x 0x4000 + Y x 0x8); modelled for GMAC 0 as 15 resp. 16 instances, GMAC 1 is the same layout 0x4000 higher.";
        field {
            name = "a_31_0";
            desc = "A[31:0]: Contains the lower 32 bits [31:0] of the 6-byte MAC address, used for receive frame filtering and for sending pause frames.";
            sw = rw; hw = r;
            reset = 0xffffffff;
        } a_31_0[31:0];
    } GMACN_ADDRX_LOW_2 @ 0x5c;
    reg {
        name = "GMACN_ADDRX_LOW";
        desc = "GMACN_ADDRX_LOW is the register for the lower 32 bits [31:0] of the X-th (1 to 15) MAC address of GMACn (0 to 1). GMACN_ADDRX_LOW (offset 0x004C+Xx0x8 (X = 0~14), total reset 0xFFFF_FFFF; PROVEN: Hi3535 data sheet, PDF page 817, section 5.6). Registers for X = 1..15 (offset 0x44 + n x 0x4000 + X x 0x8; instances 0..14 below are X = 1..15). Address registers 1-15 (X) and 16-31 (Y) of GMAC n sit at the formula offsets of the data sheet (0x40 + n x 0x4000 + X x 0x8 / 0x780 + n x 0x4000 + Y x 0x8); modelled for GMAC 0 as 15 resp. 16 instances, GMAC 1 is the same layout 0x4000 higher.";
        field {
            name = "a_31_0";
            desc = "A[31:0]: Contains the lower 32 bits [31:0] of the 6-byte MAC address, used for receive frame filtering and for sending pause frames.";
            sw = rw; hw = r;
            reset = 0xffffffff;
        } a_31_0[31:0];
    } GMACN_ADDRX_LOW_3 @ 0x64;
    reg {
        name = "GMACN_ADDRX_LOW";
        desc = "GMACN_ADDRX_LOW is the register for the lower 32 bits [31:0] of the X-th (1 to 15) MAC address of GMACn (0 to 1). GMACN_ADDRX_LOW (offset 0x004C+Xx0x8 (X = 0~14), total reset 0xFFFF_FFFF; PROVEN: Hi3535 data sheet, PDF page 817, section 5.6). Registers for X = 1..15 (offset 0x44 + n x 0x4000 + X x 0x8; instances 0..14 below are X = 1..15). Address registers 1-15 (X) and 16-31 (Y) of GMAC n sit at the formula offsets of the data sheet (0x40 + n x 0x4000 + X x 0x8 / 0x780 + n x 0x4000 + Y x 0x8); modelled for GMAC 0 as 15 resp. 16 instances, GMAC 1 is the same layout 0x4000 higher.";
        field {
            name = "a_31_0";
            desc = "A[31:0]: Contains the lower 32 bits [31:0] of the 6-byte MAC address, used for receive frame filtering and for sending pause frames.";
            sw = rw; hw = r;
            reset = 0xffffffff;
        } a_31_0[31:0];
    } GMACN_ADDRX_LOW_4 @ 0x6c;
    reg {
        name = "GMACN_ADDRX_LOW";
        desc = "GMACN_ADDRX_LOW is the register for the lower 32 bits [31:0] of the X-th (1 to 15) MAC address of GMACn (0 to 1). GMACN_ADDRX_LOW (offset 0x004C+Xx0x8 (X = 0~14), total reset 0xFFFF_FFFF; PROVEN: Hi3535 data sheet, PDF page 817, section 5.6). Registers for X = 1..15 (offset 0x44 + n x 0x4000 + X x 0x8; instances 0..14 below are X = 1..15). Address registers 1-15 (X) and 16-31 (Y) of GMAC n sit at the formula offsets of the data sheet (0x40 + n x 0x4000 + X x 0x8 / 0x780 + n x 0x4000 + Y x 0x8); modelled for GMAC 0 as 15 resp. 16 instances, GMAC 1 is the same layout 0x4000 higher.";
        field {
            name = "a_31_0";
            desc = "A[31:0]: Contains the lower 32 bits [31:0] of the 6-byte MAC address, used for receive frame filtering and for sending pause frames.";
            sw = rw; hw = r;
            reset = 0xffffffff;
        } a_31_0[31:0];
    } GMACN_ADDRX_LOW_5 @ 0x74;
    reg {
        name = "GMACN_ADDRX_LOW";
        desc = "GMACN_ADDRX_LOW is the register for the lower 32 bits [31:0] of the X-th (1 to 15) MAC address of GMACn (0 to 1). GMACN_ADDRX_LOW (offset 0x004C+Xx0x8 (X = 0~14), total reset 0xFFFF_FFFF; PROVEN: Hi3535 data sheet, PDF page 817, section 5.6). Registers for X = 1..15 (offset 0x44 + n x 0x4000 + X x 0x8; instances 0..14 below are X = 1..15). Address registers 1-15 (X) and 16-31 (Y) of GMAC n sit at the formula offsets of the data sheet (0x40 + n x 0x4000 + X x 0x8 / 0x780 + n x 0x4000 + Y x 0x8); modelled for GMAC 0 as 15 resp. 16 instances, GMAC 1 is the same layout 0x4000 higher.";
        field {
            name = "a_31_0";
            desc = "A[31:0]: Contains the lower 32 bits [31:0] of the 6-byte MAC address, used for receive frame filtering and for sending pause frames.";
            sw = rw; hw = r;
            reset = 0xffffffff;
        } a_31_0[31:0];
    } GMACN_ADDRX_LOW_6 @ 0x7c;
    reg {
        name = "GMACN_ADDRX_LOW";
        desc = "GMACN_ADDRX_LOW is the register for the lower 32 bits [31:0] of the X-th (1 to 15) MAC address of GMACn (0 to 1). GMACN_ADDRX_LOW (offset 0x004C+Xx0x8 (X = 0~14), total reset 0xFFFF_FFFF; PROVEN: Hi3535 data sheet, PDF page 817, section 5.6). Registers for X = 1..15 (offset 0x44 + n x 0x4000 + X x 0x8; instances 0..14 below are X = 1..15). Address registers 1-15 (X) and 16-31 (Y) of GMAC n sit at the formula offsets of the data sheet (0x40 + n x 0x4000 + X x 0x8 / 0x780 + n x 0x4000 + Y x 0x8); modelled for GMAC 0 as 15 resp. 16 instances, GMAC 1 is the same layout 0x4000 higher.";
        field {
            name = "a_31_0";
            desc = "A[31:0]: Contains the lower 32 bits [31:0] of the 6-byte MAC address, used for receive frame filtering and for sending pause frames.";
            sw = rw; hw = r;
            reset = 0xffffffff;
        } a_31_0[31:0];
    } GMACN_ADDRX_LOW_7 @ 0x84;
    reg {
        name = "GMACN_ADDRX_LOW";
        desc = "GMACN_ADDRX_LOW is the register for the lower 32 bits [31:0] of the X-th (1 to 15) MAC address of GMACn (0 to 1). GMACN_ADDRX_LOW (offset 0x004C+Xx0x8 (X = 0~14), total reset 0xFFFF_FFFF; PROVEN: Hi3535 data sheet, PDF page 817, section 5.6). Registers for X = 1..15 (offset 0x44 + n x 0x4000 + X x 0x8; instances 0..14 below are X = 1..15). Address registers 1-15 (X) and 16-31 (Y) of GMAC n sit at the formula offsets of the data sheet (0x40 + n x 0x4000 + X x 0x8 / 0x780 + n x 0x4000 + Y x 0x8); modelled for GMAC 0 as 15 resp. 16 instances, GMAC 1 is the same layout 0x4000 higher.";
        field {
            name = "a_31_0";
            desc = "A[31:0]: Contains the lower 32 bits [31:0] of the 6-byte MAC address, used for receive frame filtering and for sending pause frames.";
            sw = rw; hw = r;
            reset = 0xffffffff;
        } a_31_0[31:0];
    } GMACN_ADDRX_LOW_8 @ 0x8c;
    reg {
        name = "GMACN_ADDRX_LOW";
        desc = "GMACN_ADDRX_LOW is the register for the lower 32 bits [31:0] of the X-th (1 to 15) MAC address of GMACn (0 to 1). GMACN_ADDRX_LOW (offset 0x004C+Xx0x8 (X = 0~14), total reset 0xFFFF_FFFF; PROVEN: Hi3535 data sheet, PDF page 817, section 5.6). Registers for X = 1..15 (offset 0x44 + n x 0x4000 + X x 0x8; instances 0..14 below are X = 1..15). Address registers 1-15 (X) and 16-31 (Y) of GMAC n sit at the formula offsets of the data sheet (0x40 + n x 0x4000 + X x 0x8 / 0x780 + n x 0x4000 + Y x 0x8); modelled for GMAC 0 as 15 resp. 16 instances, GMAC 1 is the same layout 0x4000 higher.";
        field {
            name = "a_31_0";
            desc = "A[31:0]: Contains the lower 32 bits [31:0] of the 6-byte MAC address, used for receive frame filtering and for sending pause frames.";
            sw = rw; hw = r;
            reset = 0xffffffff;
        } a_31_0[31:0];
    } GMACN_ADDRX_LOW_9 @ 0x94;
    reg {
        name = "GMACN_ADDRX_LOW";
        desc = "GMACN_ADDRX_LOW is the register for the lower 32 bits [31:0] of the X-th (1 to 15) MAC address of GMACn (0 to 1). GMACN_ADDRX_LOW (offset 0x004C+Xx0x8 (X = 0~14), total reset 0xFFFF_FFFF; PROVEN: Hi3535 data sheet, PDF page 817, section 5.6). Registers for X = 1..15 (offset 0x44 + n x 0x4000 + X x 0x8; instances 0..14 below are X = 1..15). Address registers 1-15 (X) and 16-31 (Y) of GMAC n sit at the formula offsets of the data sheet (0x40 + n x 0x4000 + X x 0x8 / 0x780 + n x 0x4000 + Y x 0x8); modelled for GMAC 0 as 15 resp. 16 instances, GMAC 1 is the same layout 0x4000 higher.";
        field {
            name = "a_31_0";
            desc = "A[31:0]: Contains the lower 32 bits [31:0] of the 6-byte MAC address, used for receive frame filtering and for sending pause frames.";
            sw = rw; hw = r;
            reset = 0xffffffff;
        } a_31_0[31:0];
    } GMACN_ADDRX_LOW_10 @ 0x9c;
    reg {
        name = "GMACN_ADDRX_LOW";
        desc = "GMACN_ADDRX_LOW is the register for the lower 32 bits [31:0] of the X-th (1 to 15) MAC address of GMACn (0 to 1). GMACN_ADDRX_LOW (offset 0x004C+Xx0x8 (X = 0~14), total reset 0xFFFF_FFFF; PROVEN: Hi3535 data sheet, PDF page 817, section 5.6). Registers for X = 1..15 (offset 0x44 + n x 0x4000 + X x 0x8; instances 0..14 below are X = 1..15). Address registers 1-15 (X) and 16-31 (Y) of GMAC n sit at the formula offsets of the data sheet (0x40 + n x 0x4000 + X x 0x8 / 0x780 + n x 0x4000 + Y x 0x8); modelled for GMAC 0 as 15 resp. 16 instances, GMAC 1 is the same layout 0x4000 higher.";
        field {
            name = "a_31_0";
            desc = "A[31:0]: Contains the lower 32 bits [31:0] of the 6-byte MAC address, used for receive frame filtering and for sending pause frames.";
            sw = rw; hw = r;
            reset = 0xffffffff;
        } a_31_0[31:0];
    } GMACN_ADDRX_LOW_11 @ 0xa4;
    reg {
        name = "GMACN_ADDRX_LOW";
        desc = "GMACN_ADDRX_LOW is the register for the lower 32 bits [31:0] of the X-th (1 to 15) MAC address of GMACn (0 to 1). GMACN_ADDRX_LOW (offset 0x004C+Xx0x8 (X = 0~14), total reset 0xFFFF_FFFF; PROVEN: Hi3535 data sheet, PDF page 817, section 5.6). Registers for X = 1..15 (offset 0x44 + n x 0x4000 + X x 0x8; instances 0..14 below are X = 1..15). Address registers 1-15 (X) and 16-31 (Y) of GMAC n sit at the formula offsets of the data sheet (0x40 + n x 0x4000 + X x 0x8 / 0x780 + n x 0x4000 + Y x 0x8); modelled for GMAC 0 as 15 resp. 16 instances, GMAC 1 is the same layout 0x4000 higher.";
        field {
            name = "a_31_0";
            desc = "A[31:0]: Contains the lower 32 bits [31:0] of the 6-byte MAC address, used for receive frame filtering and for sending pause frames.";
            sw = rw; hw = r;
            reset = 0xffffffff;
        } a_31_0[31:0];
    } GMACN_ADDRX_LOW_12 @ 0xac;
    reg {
        name = "GMACN_ADDRX_LOW";
        desc = "GMACN_ADDRX_LOW is the register for the lower 32 bits [31:0] of the X-th (1 to 15) MAC address of GMACn (0 to 1). GMACN_ADDRX_LOW (offset 0x004C+Xx0x8 (X = 0~14), total reset 0xFFFF_FFFF; PROVEN: Hi3535 data sheet, PDF page 817, section 5.6). Registers for X = 1..15 (offset 0x44 + n x 0x4000 + X x 0x8; instances 0..14 below are X = 1..15). Address registers 1-15 (X) and 16-31 (Y) of GMAC n sit at the formula offsets of the data sheet (0x40 + n x 0x4000 + X x 0x8 / 0x780 + n x 0x4000 + Y x 0x8); modelled for GMAC 0 as 15 resp. 16 instances, GMAC 1 is the same layout 0x4000 higher.";
        field {
            name = "a_31_0";
            desc = "A[31:0]: Contains the lower 32 bits [31:0] of the 6-byte MAC address, used for receive frame filtering and for sending pause frames.";
            sw = rw; hw = r;
            reset = 0xffffffff;
        } a_31_0[31:0];
    } GMACN_ADDRX_LOW_13 @ 0xb4;
    reg {
        name = "GMACN_ADDRX_LOW";
        desc = "GMACN_ADDRX_LOW is the register for the lower 32 bits [31:0] of the X-th (1 to 15) MAC address of GMACn (0 to 1). GMACN_ADDRX_LOW (offset 0x004C+Xx0x8 (X = 0~14), total reset 0xFFFF_FFFF; PROVEN: Hi3535 data sheet, PDF page 817, section 5.6). Registers for X = 1..15 (offset 0x44 + n x 0x4000 + X x 0x8; instances 0..14 below are X = 1..15). Address registers 1-15 (X) and 16-31 (Y) of GMAC n sit at the formula offsets of the data sheet (0x40 + n x 0x4000 + X x 0x8 / 0x780 + n x 0x4000 + Y x 0x8); modelled for GMAC 0 as 15 resp. 16 instances, GMAC 1 is the same layout 0x4000 higher.";
        field {
            name = "a_31_0";
            desc = "A[31:0]: Contains the lower 32 bits [31:0] of the 6-byte MAC address, used for receive frame filtering and for sending pause frames.";
            sw = rw; hw = r;
            reset = 0xffffffff;
        } a_31_0[31:0];
    } GMACN_ADDRX_LOW_14 @ 0xbc;
    reg {
        name = "GMACN_MMC_CTRL";
        desc = "GMACN_MMC_CTRL is the MMC control register. It sets the operating mode of the management counters. GMACN_MMC_CTRL (offset 0x0100+Nx0x4000 (N = 0~1), total reset 0x0000_0000; PROVEN: Hi3535 data sheet, PDF page 819, section 5.6).";
        field {
            name = "reserved";
            desc = "Reserved.";
            sw = r; hw = w;
            reset = 0x0;
        } reserved_31_6[31:6];
        field {
            name = "fh_pre";
            desc = "Full-Half preset
- 0: When cnt_pre is 1, all MMC counters are preset to a nearly half-full value. All byte counters are preset to 0x7FFF_F800 (half-full minus 2048), and all frame counters are preset to 0x7FFF_FFF0 (half-full minus 16).
- 1: When cnt_pre is 1, all MMC counters are preset to a nearly full value. All byte counters are preset to 0xFFFF_F800 (full minus 2048), and all frame counters are preset to 0xFFFF_FFF0 (full minus 16). For 16-bit byte counters, the nearly half-full value is 0x7800 and the nearly full value is 0xF800; for 16-bit frame counters, the nearly half-full value is 0x7FF0 and the nearly full value is 0xFFF0.";
            sw = rw; hw = r;
            reset = 0x0;
        } fh_pre[5:5];
        field {
            name = "cnt_pre";
            desc = "Counter preset.
- 0: Do not preset the counters;
- 1: Preset the counters. When this bit is 1, all counters are initialized to an almost-full or almost-half-full value according to the fh_pre setting. This bit is cleared automatically after one cycle and is mainly used to debug MMC counter interrupts. (data sheet access type RWSC)";
            sw = rw; hw = r;
            reset = 0x0;
        } cnt_pre[4:4];
        field {
            name = "mmc_cf";
            desc = "MMC counter freeze.
- 0: Do not freeze the MMC counters.
- 1: Freeze the MMC counters. All MMC counters are then not updated until this bit is set to 0 again. While this bit is 1, all MMC counters can be cleared on read.";
            sw = rw; hw = r;
            reset = 0x0;
        } mmc_cf[3:3];
        field {
            name = "rst_on_rd";
            desc = "Read reset.
- 0: Do not perform a read reset.
- 1: Perform a read reset. The MMC counters are automatically reset to zero after the read operation completes.";
            sw = rw; hw = r;
            reset = 0x0;
        } rst_on_rd[2:2];
        field {
            name = "cnt_sr";
            desc = "Counter wrap stop.
- 0: The counter wraps around automatically; it returns to zero after reaching the maximum value;
- 1: The counter stops wrapping. It does not return to zero after reaching the maximum value.";
            sw = rw; hw = r;
            reset = 0x0;
        } cnt_sr[1:1];
        field {
            name = "cnt_rst";
            desc = "Counter reset.
- 0: Do not reset the counters.
- 1: Reset the counters. All counters are cleared, and this bit is cleared automatically after one cycle. (data sheet access type RWSC)";
            sw = rw; hw = r;
            reset = 0x0;
        } cnt_rst[0:0];
    } GMACN_MMC_CTRL_0 @ 0x100;
    reg {
        name = "GMACN_MMC_CTRL";
        desc = "GMACN_MMC_CTRL is the MMC control register. It sets the operating mode of the management counters. GMACN_MMC_CTRL (offset 0x0100+Nx0x4000 (N = 0~1), total reset 0x0000_0000; PROVEN: Hi3535 data sheet, PDF page 819, section 5.6).";
        field {
            name = "reserved";
            desc = "Reserved.";
            sw = r; hw = w;
            reset = 0x0;
        } reserved_31_6[31:6];
        field {
            name = "fh_pre";
            desc = "Full-Half preset
- 0: When cnt_pre is 1, all MMC counters are preset to a nearly half-full value. All byte counters are preset to 0x7FFF_F800 (half-full minus 2048), and all frame counters are preset to 0x7FFF_FFF0 (half-full minus 16).
- 1: When cnt_pre is 1, all MMC counters are preset to a nearly full value. All byte counters are preset to 0xFFFF_F800 (full minus 2048), and all frame counters are preset to 0xFFFF_FFF0 (full minus 16). For 16-bit byte counters, the nearly half-full value is 0x7800 and the nearly full value is 0xF800; for 16-bit frame counters, the nearly half-full value is 0x7FF0 and the nearly full value is 0xFFF0.";
            sw = rw; hw = r;
            reset = 0x0;
        } fh_pre[5:5];
        field {
            name = "cnt_pre";
            desc = "Counter preset.
- 0: Do not preset the counters;
- 1: Preset the counters. When this bit is 1, all counters are initialized to an almost-full or almost-half-full value according to the fh_pre setting. This bit is cleared automatically after one cycle and is mainly used to debug MMC counter interrupts. (data sheet access type RWSC)";
            sw = rw; hw = r;
            reset = 0x0;
        } cnt_pre[4:4];
        field {
            name = "mmc_cf";
            desc = "MMC counter freeze.
- 0: Do not freeze the MMC counters.
- 1: Freeze the MMC counters. All MMC counters are then not updated until this bit is set to 0 again. While this bit is 1, all MMC counters can be cleared on read.";
            sw = rw; hw = r;
            reset = 0x0;
        } mmc_cf[3:3];
        field {
            name = "rst_on_rd";
            desc = "Read reset.
- 0: Do not perform a read reset.
- 1: Perform a read reset. The MMC counters are automatically reset to zero after the read operation completes.";
            sw = rw; hw = r;
            reset = 0x0;
        } rst_on_rd[2:2];
        field {
            name = "cnt_sr";
            desc = "Counter wrap stop.
- 0: The counter wraps around automatically; it returns to zero after reaching the maximum value;
- 1: The counter stops wrapping. It does not return to zero after reaching the maximum value.";
            sw = rw; hw = r;
            reset = 0x0;
        } cnt_sr[1:1];
        field {
            name = "cnt_rst";
            desc = "Counter reset.
- 0: Do not reset the counters.
- 1: Reset the counters. All counters are cleared, and this bit is cleared automatically after one cycle. (data sheet access type RWSC)";
            sw = rw; hw = r;
            reset = 0x0;
        } cnt_rst[0:0];
    } GMACN_MMC_CTRL_1 @ 0x4100;
    reg {
        name = "GMACN_MMC_TXOCTETCOUNT_GB";
        desc = "GMACN_MMC_TXOCTETCOUNT_GB is the counter of transmitted bytes, excluding preamble and retransmitted bytes, good and bad frames. GMACN_MMC_TXOCTETCOUNT_GB (offset 0x0114+Nx0x4000 (N = 0~1), total reset None; PROVEN: Hi3535 data sheet, PDF page 820, section 5.6).";
        field {
            name = "txoctetcount_gb";
            desc = "Transmitted byte count, excluding preamble and retransmitted bytes, including good and bad frames.";
            sw = r; hw = w;
        } txoctetcount_gb[31:0];
    } GMACN_MMC_TXOCTETCOUNT_GB_0 @ 0x114;
    reg {
        name = "GMACN_MMC_TXOCTETCOUNT_GB";
        desc = "GMACN_MMC_TXOCTETCOUNT_GB is the counter of transmitted bytes, excluding preamble and retransmitted bytes, good and bad frames. GMACN_MMC_TXOCTETCOUNT_GB (offset 0x0114+Nx0x4000 (N = 0~1), total reset None; PROVEN: Hi3535 data sheet, PDF page 820, section 5.6).";
        field {
            name = "txoctetcount_gb";
            desc = "Transmitted byte count, excluding preamble and retransmitted bytes, including good and bad frames.";
            sw = r; hw = w;
        } txoctetcount_gb[31:0];
    } GMACN_MMC_TXOCTETCOUNT_GB_1 @ 0x4114;
    reg {
        name = "GMACN_MMC_TXFRAMECOUNT_GB";
        desc = "GMACN_MMC_TXFRAMECOUNT_GB is the counter of transmitted frames, good and bad, excluding retransmitted frames. GMACN_MMC_TXFRAMECOUNT_GB (offset 0x0118+Nx0x4000 (N = 0~1), total reset None; PROVEN: Hi3535 data sheet, PDF page 821, section 5.6).";
        field {
            name = "txframecount_gb";
            desc = "Count of transmitted frames, including good and bad frames, excluding retransmitted frames.";
            sw = r; hw = w;
        } txframecount_gb[31:0];
    } GMACN_MMC_TXFRAMECOUNT_GB_0 @ 0x118;
    reg {
        name = "GMACN_MMC_TXFRAMECOUNT_GB";
        desc = "GMACN_MMC_TXFRAMECOUNT_GB is the counter of transmitted frames, good and bad, excluding retransmitted frames. GMACN_MMC_TXFRAMECOUNT_GB (offset 0x0118+Nx0x4000 (N = 0~1), total reset None; PROVEN: Hi3535 data sheet, PDF page 821, section 5.6).";
        field {
            name = "txframecount_gb";
            desc = "Count of transmitted frames, including good and bad frames, excluding retransmitted frames.";
            sw = r; hw = w;
        } txframecount_gb[31:0];
    } GMACN_MMC_TXFRAMECOUNT_GB_1 @ 0x4118;
    reg {
        name = "GMACN_MMC_TXBROADCASTFRAMES_G";
        desc = "GMACN_MMC_TXBROADCASTFRAMES_G is the counter of transmitted good broadcast frames. GMACN_MMC_TXBROADCASTFRAMES_G (offset 0x011C+Nx0x4000 (N = 0~1), total reset None; PROVEN: Hi3535 data sheet, PDF page 821, section 5.6).";
        field {
            name = "txbroadcastframes_g";
            desc = "Count of transmitted good broadcast frames.";
            sw = r; hw = w;
        } txbroadcastframes_g[31:0];
    } GMACN_MMC_TXBROADCASTFRAMES_G_0 @ 0x11c;
    reg {
        name = "GMACN_MMC_TXBROADCASTFRAMES_G";
        desc = "GMACN_MMC_TXBROADCASTFRAMES_G is the counter of transmitted good broadcast frames. GMACN_MMC_TXBROADCASTFRAMES_G (offset 0x011C+Nx0x4000 (N = 0~1), total reset None; PROVEN: Hi3535 data sheet, PDF page 821, section 5.6).";
        field {
            name = "txbroadcastframes_g";
            desc = "Count of transmitted good broadcast frames.";
            sw = r; hw = w;
        } txbroadcastframes_g[31:0];
    } GMACN_MMC_TXBROADCASTFRAMES_G_1 @ 0x411c;
    reg {
        name = "GMACN_MMC_TXMULTICASTFRAMES_G";
        desc = "GMACN_MMC_TXMULTICASTFRAMES_G is the counter of transmitted good multicast frames. GMACN_MMC_TXMULTICASTFRAMES_G (offset 0x0120+Nx0x4000 (N = 0~1), total reset None; PROVEN: Hi3535 data sheet, PDF page 822, section 5.6).";
        field {
            name = "txmulticastframes_g";
            desc = "Count of transmitted good multicast frames.";
            sw = r; hw = w;
        } txmulticastframes_g[31:0];
    } GMACN_MMC_TXMULTICASTFRAMES_G_0 @ 0x120;
    reg {
        name = "GMACN_MMC_TXMULTICASTFRAMES_G";
        desc = "GMACN_MMC_TXMULTICASTFRAMES_G is the counter of transmitted good multicast frames. GMACN_MMC_TXMULTICASTFRAMES_G (offset 0x0120+Nx0x4000 (N = 0~1), total reset None; PROVEN: Hi3535 data sheet, PDF page 822, section 5.6).";
        field {
            name = "txmulticastframes_g";
            desc = "Count of transmitted good multicast frames.";
            sw = r; hw = w;
        } txmulticastframes_g[31:0];
    } GMACN_MMC_TXMULTICASTFRAMES_G_1 @ 0x4120;
    reg {
        name = "GMACN_MMC_TX64OCTETS_GB";
        desc = "GMACN_MMC_TX64OCTETS_GB is the counter register for transmitted frames of 64 bytes, including good and bad frames, excluding the preamble and retransmitted frames. GMACN_MMC_TX64OCTETS_GB (offset 0x0124+Nx0x4000 (N = 0~1), total reset 0x0000_0000; PROVEN: Hi3535 data sheet, PDF page 822, section 5.6).";
        field {
            name = "tx64octets_gb";
            desc = "Count of frames of 64 bytes in length, including good and bad frames, excluding the preamble and retransmitted frames.";
            sw = r; hw = w;
            reset = 0x0;
        } tx64octets_gb[31:0];
    } GMACN_MMC_TX64OCTETS_GB_0 @ 0x124;
    reg {
        name = "GMACN_MMC_TX64OCTETS_GB";
        desc = "GMACN_MMC_TX64OCTETS_GB is the counter register for transmitted frames of 64 bytes, including good and bad frames, excluding the preamble and retransmitted frames. GMACN_MMC_TX64OCTETS_GB (offset 0x0124+Nx0x4000 (N = 0~1), total reset 0x0000_0000; PROVEN: Hi3535 data sheet, PDF page 822, section 5.6).";
        field {
            name = "tx64octets_gb";
            desc = "Count of frames of 64 bytes in length, including good and bad frames, excluding the preamble and retransmitted frames.";
            sw = r; hw = w;
            reset = 0x0;
        } tx64octets_gb[31:0];
    } GMACN_MMC_TX64OCTETS_GB_1 @ 0x4124;
    reg {
        name = "GMACN_MMC_TX65TO127OCTETS_GB";
        desc = "GMACN_MMC_TX65TO127OCTETS_GB is the counter of transmitted frames of 65 to 127 bytes, good and bad frames, excluding preamble and retransmitted frames. GMACN_MMC_TX65TO127OCTETS_GB (offset 0x0128+Nx0x4000 (N = 0~1), total reset None; PROVEN: Hi3535 data sheet, PDF page 823, section 5.6).";
        field {
            name = "tx65to127octets_gb";
            desc = "Count of frames of 65 to 127 bytes, including good and bad frames, excluding the preamble and retransmitted frames.";
            sw = r; hw = w;
        } tx65to127octets_gb[31:0];
    } GMACN_MMC_TX65TO127OCTETS_GB_0 @ 0x128;
    reg {
        name = "GMACN_MMC_TX65TO127OCTETS_GB";
        desc = "GMACN_MMC_TX65TO127OCTETS_GB is the counter of transmitted frames of 65 to 127 bytes, good and bad frames, excluding preamble and retransmitted frames. GMACN_MMC_TX65TO127OCTETS_GB (offset 0x0128+Nx0x4000 (N = 0~1), total reset None; PROVEN: Hi3535 data sheet, PDF page 823, section 5.6).";
        field {
            name = "tx65to127octets_gb";
            desc = "Count of frames of 65 to 127 bytes, including good and bad frames, excluding the preamble and retransmitted frames.";
            sw = r; hw = w;
        } tx65to127octets_gb[31:0];
    } GMACN_MMC_TX65TO127OCTETS_GB_1 @ 0x4128;
    reg {
        name = "GMACN_MMC_TX128TO255OCTETS_GB";
        desc = "GMACN_MMC_TX128TO255OCTETS_GB is the counter of transmitted frames of 128 to 255 bytes, good and bad frames, excluding preamble and retransmitted frames. GMACN_MMC_TX128TO255OCTETS_GB (offset 0x012C+Nx0x4000 (N = 0~1), total reset None; PROVEN: Hi3535 data sheet, PDF page 823, section 5.6).";
        field {
            name = "tx128to255octets_gb";
            desc = "Frame count for frames of 128 to 255 bytes, including good and bad frames, excluding preamble and retransmitted frames.";
            sw = r; hw = w;
        } tx128to255octets_gb[31:0];
    } GMACN_MMC_TX128TO255OCTETS_GB_0 @ 0x12c;
    reg {
        name = "GMACN_MMC_TX128TO255OCTETS_GB";
        desc = "GMACN_MMC_TX128TO255OCTETS_GB is the counter of transmitted frames of 128 to 255 bytes, good and bad frames, excluding preamble and retransmitted frames. GMACN_MMC_TX128TO255OCTETS_GB (offset 0x012C+Nx0x4000 (N = 0~1), total reset None; PROVEN: Hi3535 data sheet, PDF page 823, section 5.6).";
        field {
            name = "tx128to255octets_gb";
            desc = "Frame count for frames of 128 to 255 bytes, including good and bad frames, excluding preamble and retransmitted frames.";
            sw = r; hw = w;
        } tx128to255octets_gb[31:0];
    } GMACN_MMC_TX128TO255OCTETS_GB_1 @ 0x412c;
    reg {
        name = "GMACN_MMC_TX256TO511OCTETS_GB";
        desc = "GMACN_MMC_TX256TO511OCTETS_GB is the counter of transmitted frames of 256 to 511 bytes, good and bad frames, excluding preamble and retransmitted frames. GMACN_MMC_TX256TO511OCTETS_GB (offset 0x0130+Nx0x4000 (N = 0~1), total reset None; PROVEN: Hi3535 data sheet, PDF page 824, section 5.6).";
        field {
            name = "tx256to511octets_gb";
            desc = "Frame counter for frames of 256 to 511 bytes, including good and bad frames, excluding the preamble and retransmitted frames.";
            sw = r; hw = w;
        } tx256to511octets_gb[31:0];
    } GMACN_MMC_TX256TO511OCTETS_GB_0 @ 0x130;
    reg {
        name = "GMACN_MMC_TX256TO511OCTETS_GB";
        desc = "GMACN_MMC_TX256TO511OCTETS_GB is the counter of transmitted frames of 256 to 511 bytes, good and bad frames, excluding preamble and retransmitted frames. GMACN_MMC_TX256TO511OCTETS_GB (offset 0x0130+Nx0x4000 (N = 0~1), total reset None; PROVEN: Hi3535 data sheet, PDF page 824, section 5.6).";
        field {
            name = "tx256to511octets_gb";
            desc = "Frame counter for frames of 256 to 511 bytes, including good and bad frames, excluding the preamble and retransmitted frames.";
            sw = r; hw = w;
        } tx256to511octets_gb[31:0];
    } GMACN_MMC_TX256TO511OCTETS_GB_1 @ 0x4130;
    reg {
        name = "GMACN_MMC_TX512TO1023OCTETS_GB";
        desc = "GMACN_MMC_TX512TO1023OCTETS_GB is the counter of transmitted frames of 512 to 1023 bytes, good and bad frames, excluding preamble and retransmitted frames. GMACN_MMC_TX512TO1023OCTETS_GB (offset 0x0134+Nx0x4000 (N = 0~1), total reset None; PROVEN: Hi3535 data sheet, PDF page 824, section 5.6).";
        field {
            name = "tx512to1023octets_gb";
            desc = "Count of frames of 512 to 1023 bytes, including good and bad frames, excluding the preamble and retransmitted frames.";
            sw = r; hw = w;
        } tx512to1023octets_gb[31:0];
    } GMACN_MMC_TX512TO1023OCTETS_GB_0 @ 0x134;
    reg {
        name = "GMACN_MMC_TX512TO1023OCTETS_GB";
        desc = "GMACN_MMC_TX512TO1023OCTETS_GB is the counter of transmitted frames of 512 to 1023 bytes, good and bad frames, excluding preamble and retransmitted frames. GMACN_MMC_TX512TO1023OCTETS_GB (offset 0x0134+Nx0x4000 (N = 0~1), total reset None; PROVEN: Hi3535 data sheet, PDF page 824, section 5.6).";
        field {
            name = "tx512to1023octets_gb";
            desc = "Count of frames of 512 to 1023 bytes, including good and bad frames, excluding the preamble and retransmitted frames.";
            sw = r; hw = w;
        } tx512to1023octets_gb[31:0];
    } GMACN_MMC_TX512TO1023OCTETS_GB_1 @ 0x4134;
    reg {
        name = "GMACN_MMC_TX1024TOMAXOCTETS_GB";
        desc = "GMACN_MMC_TX1024TOMAXOCTETS_GB is the counter of transmitted frames of 1024 bytes up to the maximum frame length, good and bad frames, excluding preamble and retransmitted frames. GMACN_MMC_TX1024TOMAXOCTETS_GB (offset 0x0138+Nx0x4000 (N = 0~1), total reset None; PROVEN: Hi3535 data sheet, PDF page 825, section 5.6).";
        field {
            name = "tx1024tomaxoctets_gb";
            desc = "Frame count for frames from 1024 bytes up to the maximum frame length, including good and bad frames, excluding preamble and retransmitted frames.";
            sw = r; hw = w;
        } tx1024tomaxoctets_gb[31:0];
    } GMACN_MMC_TX1024TOMAXOCTETS_GB_0 @ 0x138;
    reg {
        name = "GMACN_MMC_TX1024TOMAXOCTETS_GB";
        desc = "GMACN_MMC_TX1024TOMAXOCTETS_GB is the counter of transmitted frames of 1024 bytes up to the maximum frame length, good and bad frames, excluding preamble and retransmitted frames. GMACN_MMC_TX1024TOMAXOCTETS_GB (offset 0x0138+Nx0x4000 (N = 0~1), total reset None; PROVEN: Hi3535 data sheet, PDF page 825, section 5.6).";
        field {
            name = "tx1024tomaxoctets_gb";
            desc = "Frame count for frames from 1024 bytes up to the maximum frame length, including good and bad frames, excluding preamble and retransmitted frames.";
            sw = r; hw = w;
        } tx1024tomaxoctets_gb[31:0];
    } GMACN_MMC_TX1024TOMAXOCTETS_GB_1 @ 0x4138;
    reg {
        name = "GMACN_MMC_TXUNICASTFRAMES_GB";
        desc = "GMACN_MMC_TXUNICASTFRAMES_GB is the counter of transmitted unicast frames, good and bad. GMACN_MMC_TXUNICASTFRAMES_GB (offset 0x013C+Nx0x4000 (N = 0~1), total reset None; PROVEN: Hi3535 data sheet, PDF page 825, section 5.6).";
        field {
            name = "txunicastframes_gb";
            desc = "Count of transmitted unicast frames, including good and bad frames.";
            sw = r; hw = w;
        } txunicastframes_gb[31:0];
    } GMACN_MMC_TXUNICASTFRAMES_GB_0 @ 0x13c;
    reg {
        name = "GMACN_MMC_TXUNICASTFRAMES_GB";
        desc = "GMACN_MMC_TXUNICASTFRAMES_GB is the counter of transmitted unicast frames, good and bad. GMACN_MMC_TXUNICASTFRAMES_GB (offset 0x013C+Nx0x4000 (N = 0~1), total reset None; PROVEN: Hi3535 data sheet, PDF page 825, section 5.6).";
        field {
            name = "txunicastframes_gb";
            desc = "Count of transmitted unicast frames, including good and bad frames.";
            sw = r; hw = w;
        } txunicastframes_gb[31:0];
    } GMACN_MMC_TXUNICASTFRAMES_GB_1 @ 0x413c;
    reg {
        name = "GMACN_MMC_TXMULTICASTFRAMES_GB";
        desc = "GMACN_MMC_TXMULTICASTFRAMES_GB is the counter of transmitted multicast frames, good and bad. GMACN_MMC_TXMULTICASTFRAMES_GB (offset 0x0140+Nx0x4000 (N = 0~1), total reset None; PROVEN: Hi3535 data sheet, PDF page 826, section 5.6).";
        field {
            name = "txmulticastframes_gb";
            desc = "Count of transmitted multicast frames, including good and bad frames.";
            sw = r; hw = w;
        } txmulticastframes_gb[31:0];
    } GMACN_MMC_TXMULTICASTFRAMES_GB_0 @ 0x140;
    reg {
        name = "GMACN_MMC_TXMULTICASTFRAMES_GB";
        desc = "GMACN_MMC_TXMULTICASTFRAMES_GB is the counter of transmitted multicast frames, good and bad. GMACN_MMC_TXMULTICASTFRAMES_GB (offset 0x0140+Nx0x4000 (N = 0~1), total reset None; PROVEN: Hi3535 data sheet, PDF page 826, section 5.6).";
        field {
            name = "txmulticastframes_gb";
            desc = "Count of transmitted multicast frames, including good and bad frames.";
            sw = r; hw = w;
        } txmulticastframes_gb[31:0];
    } GMACN_MMC_TXMULTICASTFRAMES_GB_1 @ 0x4140;
    reg {
        name = "GMACN_MMC_TXBROADCASTFRAMES_GB";
        desc = "GMACN_MMC_TXBROADCASTFRAMES_GB is the counter of transmitted broadcast frames, good and bad. GMACN_MMC_TXBROADCASTFRAMES_GB (offset 0x0144+Nx0x4000 (N = 0~1), total reset None; PROVEN: Hi3535 data sheet, PDF page 826, section 5.6).";
        field {
            name = "txbroadcastframes_gb";
            desc = "Count of transmitted broadcast frames, including good and bad frames.";
            sw = r; hw = w;
        } txbroadcastframes_gb[31:0];
    } GMACN_MMC_TXBROADCASTFRAMES_GB_0 @ 0x144;
    reg {
        name = "GMACN_MMC_TXBROADCASTFRAMES_GB";
        desc = "GMACN_MMC_TXBROADCASTFRAMES_GB is the counter of transmitted broadcast frames, good and bad. GMACN_MMC_TXBROADCASTFRAMES_GB (offset 0x0144+Nx0x4000 (N = 0~1), total reset None; PROVEN: Hi3535 data sheet, PDF page 826, section 5.6).";
        field {
            name = "txbroadcastframes_gb";
            desc = "Count of transmitted broadcast frames, including good and bad frames.";
            sw = r; hw = w;
        } txbroadcastframes_gb[31:0];
    } GMACN_MMC_TXBROADCASTFRAMES_GB_1 @ 0x4144;
    reg {
        name = "GMACN_MMC_TXUNDERFLOWERROR";
        desc = "GMACN_MMC_TXUNDERFLOWERROR is the counter of transmitted frames aborted because of a frame underflow error. GMACN_MMC_TXUNDERFLOWERROR (offset 0x0148+Nx0x4000 (N = 0~1), total reset None; PROVEN: Hi3535 data sheet, PDF page 827, section 5.6).";
        field {
            name = "txunderflowerror";
            desc = "Count of transmitted frames canceled because of a frame underflow error.";
            sw = r; hw = w;
        } txunderflowerror[31:0];
    } GMACN_MMC_TXUNDERFLOWERROR_0 @ 0x148;
    reg {
        name = "GMACN_MMC_TXUNDERFLOWERROR";
        desc = "GMACN_MMC_TXUNDERFLOWERROR is the counter of transmitted frames aborted because of a frame underflow error. GMACN_MMC_TXUNDERFLOWERROR (offset 0x0148+Nx0x4000 (N = 0~1), total reset None; PROVEN: Hi3535 data sheet, PDF page 827, section 5.6).";
        field {
            name = "txunderflowerror";
            desc = "Count of transmitted frames canceled because of a frame underflow error.";
            sw = r; hw = w;
        } txunderflowerror[31:0];
    } GMACN_MMC_TXUNDERFLOWERROR_1 @ 0x4148;
    reg {
        name = "GMACN_MMC_TXSINGLECOL_G";
        desc = "GMACN_MMC_TXSINGLECOL_G is the counter register for frames transmitted successfully after a single collision in half-duplex mode. GMACN_MMC_TXSINGLECOL_G (offset 0x014C+Nx0x4000 (N = 0~1), total reset 0x0000_0000; PROVEN: Hi3535 data sheet, PDF page 827, section 5.6).";
        field {
            name = "txsinglecol_g";
            desc = "In half-duplex mode, count of frames successfully transmitted after a single collision.";
            sw = r; hw = w;
            reset = 0x0;
        } txsinglecol_g[31:0];
    } GMACN_MMC_TXSINGLECOL_G_0 @ 0x14c;
    reg {
        name = "GMACN_MMC_TXSINGLECOL_G";
        desc = "GMACN_MMC_TXSINGLECOL_G is the counter register for frames transmitted successfully after a single collision in half-duplex mode. GMACN_MMC_TXSINGLECOL_G (offset 0x014C+Nx0x4000 (N = 0~1), total reset 0x0000_0000; PROVEN: Hi3535 data sheet, PDF page 827, section 5.6).";
        field {
            name = "txsinglecol_g";
            desc = "In half-duplex mode, count of frames successfully transmitted after a single collision.";
            sw = r; hw = w;
            reset = 0x0;
        } txsinglecol_g[31:0];
    } GMACN_MMC_TXSINGLECOL_G_1 @ 0x414c;
    reg {
        name = "GMACN_MMC_TXMULTICOL_G";
        desc = "GMACN_MMC_TXMULTICOL_G is the counter register for frames transmitted successfully after multiple collisions in half-duplex mode. GMACN_MMC_TXMULTICOL_G (offset 0x0150+Nx0x4000 (N = 0~1), total reset 0x0000_0000; PROVEN: Hi3535 data sheet, PDF page 827, section 5.6).";
        field {
            name = "txmulticol_g";
            desc = "Count of frames successfully transmitted after multiple collisions in half-duplex mode.";
            sw = r; hw = w;
            reset = 0x0;
        } txmulticol_g[31:0];
    } GMACN_MMC_TXMULTICOL_G_0 @ 0x150;
    reg {
        name = "GMACN_MMC_TXMULTICOL_G";
        desc = "GMACN_MMC_TXMULTICOL_G is the counter register for frames transmitted successfully after multiple collisions in half-duplex mode. GMACN_MMC_TXMULTICOL_G (offset 0x0150+Nx0x4000 (N = 0~1), total reset 0x0000_0000; PROVEN: Hi3535 data sheet, PDF page 827, section 5.6).";
        field {
            name = "txmulticol_g";
            desc = "Count of frames successfully transmitted after multiple collisions in half-duplex mode.";
            sw = r; hw = w;
            reset = 0x0;
        } txmulticol_g[31:0];
    } GMACN_MMC_TXMULTICOL_G_1 @ 0x4150;
    reg {
        name = "GMACN_MMC_TXDEFERRED";
        desc = "GMACN_MMC_TXDEFERRED is the register for the count of frames successfully transmitted after a deferral in half-duplex mode. GMACN_MMC_TXDEFERRED (offset 0x0154+Nx0x4000 (N = 0~1), total reset 0x0000_0000; PROVEN: Hi3535 data sheet, PDF page 828, section 5.6).";
        field {
            name = "txdeferred";
            desc = "In half-duplex mode, count of frames successfully transmitted after a delay.";
            sw = r; hw = w;
            reset = 0x0;
        } txdeferred[31:0];
    } GMACN_MMC_TXDEFERRED_0 @ 0x154;
    reg {
        name = "GMACN_MMC_TXDEFERRED";
        desc = "GMACN_MMC_TXDEFERRED is the register for the count of frames successfully transmitted after a deferral in half-duplex mode. GMACN_MMC_TXDEFERRED (offset 0x0154+Nx0x4000 (N = 0~1), total reset 0x0000_0000; PROVEN: Hi3535 data sheet, PDF page 828, section 5.6).";
        field {
            name = "txdeferred";
            desc = "In half-duplex mode, count of frames successfully transmitted after a delay.";
            sw = r; hw = w;
            reset = 0x0;
        } txdeferred[31:0];
    } GMACN_MMC_TXDEFERRED_1 @ 0x4154;
    reg {
        name = "GMACN_MMC_TXLATECOL";
        desc = "GMACN_MMC_TXLATECOL is the register counting frames whose transmission was aborted because of a late collision error. GMACN_MMC_TXLATECOL (offset 0x0158+Nx0x4000 (N = 0~1), total reset 0x0000_0000; PROVEN: Hi3535 data sheet, PDF page 828, section 5.6).";
        field {
            name = "txlatecol";
            desc = "Count of frames whose transmission was aborted because of a late collision error.";
            sw = r; hw = w;
            reset = 0x0;
        } txlatecol[31:0];
    } GMACN_MMC_TXLATECOL_0 @ 0x158;
    reg {
        name = "GMACN_MMC_TXLATECOL";
        desc = "GMACN_MMC_TXLATECOL is the register counting frames whose transmission was aborted because of a late collision error. GMACN_MMC_TXLATECOL (offset 0x0158+Nx0x4000 (N = 0~1), total reset 0x0000_0000; PROVEN: Hi3535 data sheet, PDF page 828, section 5.6).";
        field {
            name = "txlatecol";
            desc = "Count of frames whose transmission was aborted because of a late collision error.";
            sw = r; hw = w;
            reset = 0x0;
        } txlatecol[31:0];
    } GMACN_MMC_TXLATECOL_1 @ 0x4158;
    reg {
        name = "GMACN_MMC_TXEXESSCOL";
        desc = "GMACN_MMC_TXEXESSCOL is the register for the count of frames whose transmission was aborted because of 16 consecutive transmission collisions. GMACN_MMC_TXEXESSCOL (offset 0x015C+Nx0x4000 (N = 0~1), total reset 0x0000_0000; PROVEN: Hi3535 data sheet, PDF page 829, section 5.6).";
        field {
            name = "txexesscol";
            desc = "Count of frames whose transmission was canceled because of 16 consecutive transmit collisions.";
            sw = r; hw = w;
            reset = 0x0;
        } txexesscol[31:0];
    } GMACN_MMC_TXEXESSCOL_0 @ 0x15c;
    reg {
        name = "GMACN_MMC_TXEXESSCOL";
        desc = "GMACN_MMC_TXEXESSCOL is the register for the count of frames whose transmission was aborted because of 16 consecutive transmission collisions. GMACN_MMC_TXEXESSCOL (offset 0x015C+Nx0x4000 (N = 0~1), total reset 0x0000_0000; PROVEN: Hi3535 data sheet, PDF page 829, section 5.6).";
        field {
            name = "txexesscol";
            desc = "Count of frames whose transmission was canceled because of 16 consecutive transmit collisions.";
            sw = r; hw = w;
            reset = 0x0;
        } txexesscol[31:0];
    } GMACN_MMC_TXEXESSCOL_1 @ 0x415c;
    reg {
        name = "GMACN_MMC_TXCARRIERERROR";
        desc = "GMACN_MMC_TXCARRIERERROR is the register counting frames whose transmission was aborted because of a carrier sense error (no carrier or loss of carrier). GMACN_MMC_TXCARRIERERROR (offset 0x0160+Nx0x4000 (N = 0~1), total reset 0x0000_0000; PROVEN: Hi3535 data sheet, PDF page 829, section 5.6).";
        field {
            name = "txcarriererror";
            desc = "Count of frames whose transmission was aborted due to a carrier sense error (no carrier or loss of carrier).";
            sw = r; hw = w;
            reset = 0x0;
        } txcarriererror[31:0];
    } GMACN_MMC_TXCARRIERERROR_0 @ 0x160;
    reg {
        name = "GMACN_MMC_TXCARRIERERROR";
        desc = "GMACN_MMC_TXCARRIERERROR is the register counting frames whose transmission was aborted because of a carrier sense error (no carrier or loss of carrier). GMACN_MMC_TXCARRIERERROR (offset 0x0160+Nx0x4000 (N = 0~1), total reset 0x0000_0000; PROVEN: Hi3535 data sheet, PDF page 829, section 5.6).";
        field {
            name = "txcarriererror";
            desc = "Count of frames whose transmission was aborted due to a carrier sense error (no carrier or loss of carrier).";
            sw = r; hw = w;
            reset = 0x0;
        } txcarriererror[31:0];
    } GMACN_MMC_TXCARRIERERROR_1 @ 0x4160;
    reg {
        name = "GMACN_MMC_TXOCTETCOUNT_G";
        desc = "GMACN_MMC_TXOCTETCOUNT_G is the transmitted byte counter register. It excludes the preamble and counts good frames only. GMACN_MMC_TXOCTETCOUNT_G (offset 0x0164+Nx0x4000 (N = 0~1), total reset 0x0000_0000; PROVEN: Hi3535 data sheet, PDF page 830, section 5.6).";
        field {
            name = "txoctetcount_g";
            desc = "Transmitted byte count, excluding the preamble and counting good frames only.";
            sw = r; hw = w;
            reset = 0x0;
        } txoctetcount_g[31:0];
    } GMACN_MMC_TXOCTETCOUNT_G_0 @ 0x164;
    reg {
        name = "GMACN_MMC_TXOCTETCOUNT_G";
        desc = "GMACN_MMC_TXOCTETCOUNT_G is the transmitted byte counter register. It excludes the preamble and counts good frames only. GMACN_MMC_TXOCTETCOUNT_G (offset 0x0164+Nx0x4000 (N = 0~1), total reset 0x0000_0000; PROVEN: Hi3535 data sheet, PDF page 830, section 5.6).";
        field {
            name = "txoctetcount_g";
            desc = "Transmitted byte count, excluding the preamble and counting good frames only.";
            sw = r; hw = w;
            reset = 0x0;
        } txoctetcount_g[31:0];
    } GMACN_MMC_TXOCTETCOUNT_G_1 @ 0x4164;
    reg {
        name = "GMACN_MMC_TXFRAMECOUNT_G";
        desc = "GMACN_MMC_TXFRAMECOUNT_G is the register counting transmitted good frames. GMACN_MMC_TXFRAMECOUNT_G (offset 0x0168+Nx0x4000 (N = 0~1), total reset 0x0000_0000; PROVEN: Hi3535 data sheet, PDF page 830, section 5.6).";
        field {
            name = "txframecount_g";
            desc = "Count of transmitted good frames.";
            sw = r; hw = w;
            reset = 0x0;
        } txframecount_g[31:0];
    } GMACN_MMC_TXFRAMECOUNT_G_0 @ 0x168;
    reg {
        name = "GMACN_MMC_TXFRAMECOUNT_G";
        desc = "GMACN_MMC_TXFRAMECOUNT_G is the register counting transmitted good frames. GMACN_MMC_TXFRAMECOUNT_G (offset 0x0168+Nx0x4000 (N = 0~1), total reset 0x0000_0000; PROVEN: Hi3535 data sheet, PDF page 830, section 5.6).";
        field {
            name = "txframecount_g";
            desc = "Count of transmitted good frames.";
            sw = r; hw = w;
            reset = 0x0;
        } txframecount_g[31:0];
    } GMACN_MMC_TXFRAMECOUNT_G_1 @ 0x4168;
    reg {
        name = "GMACN_MMC_TXEXCESSDEF";
        desc = "GMACN_MMC_TXEXCESSDEF is the register counting frames whose transmission was aborted because of excessive deferral (exceeding twice the maximum frame length time). GMACN_MMC_TXEXCESSDEF (offset 0x016C+Nx0x4000 (N = 0~1), total reset 0x0000_0000; PROVEN: Hi3535 data sheet, PDF page 830, section 5.6).";
        field {
            name = "txexcessdef";
            desc = "Frame count of frames whose transmission was aborted because of excessive deferral (exceeding twice the maximum frame length time).";
            sw = r; hw = w;
            reset = 0x0;
        } txexcessdef[31:0];
    } GMACN_MMC_TXEXCESSDEF_0 @ 0x16c;
    reg {
        name = "GMACN_MMC_TXEXCESSDEF";
        desc = "GMACN_MMC_TXEXCESSDEF is the register counting frames whose transmission was aborted because of excessive deferral (exceeding twice the maximum frame length time). GMACN_MMC_TXEXCESSDEF (offset 0x016C+Nx0x4000 (N = 0~1), total reset 0x0000_0000; PROVEN: Hi3535 data sheet, PDF page 830, section 5.6).";
        field {
            name = "txexcessdef";
            desc = "Frame count of frames whose transmission was aborted because of excessive deferral (exceeding twice the maximum frame length time).";
            sw = r; hw = w;
            reset = 0x0;
        } txexcessdef[31:0];
    } GMACN_MMC_TXEXCESSDEF_1 @ 0x416c;
    reg {
        name = "GMACN_MMC_TXPAUSEFRAMES";
        desc = "GMACN_MMC_TXPAUSEFRAMES is the counter register for transmitted good pause frames. GMACN_MMC_TXPAUSEFRAMES (offset 0x0170+Nx0x4000 (N = 0~1), total reset 0x0000_0000; PROVEN: Hi3535 data sheet, PDF page 831, section 5.6).";
        field {
            name = "txpauseframes";
            desc = "Count of transmitted good pause frames.";
            sw = r; hw = w;
            reset = 0x0;
        } txpauseframes[31:0];
    } GMACN_MMC_TXPAUSEFRAMES_0 @ 0x170;
    reg {
        name = "GMACN_MMC_TXPAUSEFRAMES";
        desc = "GMACN_MMC_TXPAUSEFRAMES is the counter register for transmitted good pause frames. GMACN_MMC_TXPAUSEFRAMES (offset 0x0170+Nx0x4000 (N = 0~1), total reset 0x0000_0000; PROVEN: Hi3535 data sheet, PDF page 831, section 5.6).";
        field {
            name = "txpauseframes";
            desc = "Count of transmitted good pause frames.";
            sw = r; hw = w;
            reset = 0x0;
        } txpauseframes[31:0];
    } GMACN_MMC_TXPAUSEFRAMES_1 @ 0x4170;
    reg {
        name = "GMACN_MMC_TXVLANFRAMES_G";
        desc = "GMACN_MMC_TXVLANFRAMES_G is the register for the count of transmitted good VLAN frames. Excludes retransmitted frames. GMACN_MMC_TXVLANFRAMES_G (offset 0x0174+Nx0x4000 (N = 0~1), total reset 0x0000_0000; PROVEN: Hi3535 data sheet, PDF page 831, section 5.6).";
        field {
            name = "txvlanframes_g";
            desc = "Count of transmitted good VLAN frames, excluding retransmitted frames.";
            sw = r; hw = w;
            reset = 0x0;
        } txvlanframes_g[31:0];
    } GMACN_MMC_TXVLANFRAMES_G_0 @ 0x174;
    reg {
        name = "GMACN_MMC_TXVLANFRAMES_G";
        desc = "GMACN_MMC_TXVLANFRAMES_G is the register for the count of transmitted good VLAN frames. Excludes retransmitted frames. GMACN_MMC_TXVLANFRAMES_G (offset 0x0174+Nx0x4000 (N = 0~1), total reset 0x0000_0000; PROVEN: Hi3535 data sheet, PDF page 831, section 5.6).";
        field {
            name = "txvlanframes_g";
            desc = "Count of transmitted good VLAN frames, excluding retransmitted frames.";
            sw = r; hw = w;
            reset = 0x0;
        } txvlanframes_g[31:0];
    } GMACN_MMC_TXVLANFRAMES_G_1 @ 0x4174;
    reg {
        name = "GMACN_MMC_RXFRAMECOUNT_GB";
        desc = "GMACN_MMC_RXFRAMECOUNT_GB is the counter of received frames, good and bad. GMACN_MMC_RXFRAMECOUNT_GB (offset 0x0180+Nx0x4000 (N = 0~1), total reset None; PROVEN: Hi3535 data sheet, PDF page 832, section 5.6).";
        field {
            name = "rxframecount_gb";
            desc = "Count of received frames, including good and bad frames.";
            sw = r; hw = w;
        } rxframecount_gb[31:0];
    } GMACN_MMC_RXFRAMECOUNT_GB_0 @ 0x180;
    reg {
        name = "GMACN_MMC_RXFRAMECOUNT_GB";
        desc = "GMACN_MMC_RXFRAMECOUNT_GB is the counter of received frames, good and bad. GMACN_MMC_RXFRAMECOUNT_GB (offset 0x0180+Nx0x4000 (N = 0~1), total reset None; PROVEN: Hi3535 data sheet, PDF page 832, section 5.6).";
        field {
            name = "rxframecount_gb";
            desc = "Count of received frames, including good and bad frames.";
            sw = r; hw = w;
        } rxframecount_gb[31:0];
    } GMACN_MMC_RXFRAMECOUNT_GB_1 @ 0x4180;
    reg {
        name = "GMACN_MMC_RXOCTETCOUNT_GB";
        desc = "GMACN_MMC_RXOCTETCOUNT_GB is the counter of received bytes, excluding the preamble, good and bad frames. GMACN_MMC_RXOCTETCOUNT_GB (offset 0x0184+Nx0x4000 (N = 0~1), total reset None; PROVEN: Hi3535 data sheet, PDF page 832, section 5.6).";
        field {
            name = "rxoctetcount_gb";
            desc = "Count of received bytes, excluding the preamble, including good and bad frames.";
            sw = r; hw = w;
        } rxoctetcount_gb[31:0];
    } GMACN_MMC_RXOCTETCOUNT_GB_0 @ 0x184;
    reg {
        name = "GMACN_MMC_RXOCTETCOUNT_GB";
        desc = "GMACN_MMC_RXOCTETCOUNT_GB is the counter of received bytes, excluding the preamble, good and bad frames. GMACN_MMC_RXOCTETCOUNT_GB (offset 0x0184+Nx0x4000 (N = 0~1), total reset None; PROVEN: Hi3535 data sheet, PDF page 832, section 5.6).";
        field {
            name = "rxoctetcount_gb";
            desc = "Count of received bytes, excluding the preamble, including good and bad frames.";
            sw = r; hw = w;
        } rxoctetcount_gb[31:0];
    } GMACN_MMC_RXOCTETCOUNT_GB_1 @ 0x4184;
    reg {
        name = "GMACN_MMC_RXOCTETCOUNT_G";
        desc = "GMACN_MMC_RXOCTETCOUNT_G is the received byte count register. It excludes the preamble and counts good frames only. GMACN_MMC_RXOCTETCOUNT_G (offset 0x0188+Nx0x4000 (N = 0~1), total reset 0x0000_0000; PROVEN: Hi3535 data sheet, PDF page 832, section 5.6).";
        field {
            name = "rxoctetcount_g";
            desc = "Received byte count, excluding the preamble, good frames only.";
            sw = r; hw = w;
            reset = 0x0;
        } rxoctetcount_g[31:0];
    } GMACN_MMC_RXOCTETCOUNT_G_0 @ 0x188;
    reg {
        name = "GMACN_MMC_RXOCTETCOUNT_G";
        desc = "GMACN_MMC_RXOCTETCOUNT_G is the received byte count register. It excludes the preamble and counts good frames only. GMACN_MMC_RXOCTETCOUNT_G (offset 0x0188+Nx0x4000 (N = 0~1), total reset 0x0000_0000; PROVEN: Hi3535 data sheet, PDF page 832, section 5.6).";
        field {
            name = "rxoctetcount_g";
            desc = "Received byte count, excluding the preamble, good frames only.";
            sw = r; hw = w;
            reset = 0x0;
        } rxoctetcount_g[31:0];
    } GMACN_MMC_RXOCTETCOUNT_G_1 @ 0x4188;
    reg {
        name = "GMACN_MMC_RXBROADCASTFRAMES_G";
        desc = "GMACN_MMC_RXBROADCASTFRAMES_G is the counter of received good broadcast frames. GMACN_MMC_RXBROADCASTFRAMES_G (offset 0x018C+Nx0x4000 (N = 0~1), total reset None; PROVEN: Hi3535 data sheet, PDF page 833, section 5.6).";
        field {
            name = "rxbroadcastframes_g";
            desc = "Count of received broadcast frames.";
            sw = r; hw = w;
        } rxbroadcastframes_g[31:0];
    } GMACN_MMC_RXBROADCASTFRAMES_G_0 @ 0x18c;
    reg {
        name = "GMACN_MMC_RXBROADCASTFRAMES_G";
        desc = "GMACN_MMC_RXBROADCASTFRAMES_G is the counter of received good broadcast frames. GMACN_MMC_RXBROADCASTFRAMES_G (offset 0x018C+Nx0x4000 (N = 0~1), total reset None; PROVEN: Hi3535 data sheet, PDF page 833, section 5.6).";
        field {
            name = "rxbroadcastframes_g";
            desc = "Count of received broadcast frames.";
            sw = r; hw = w;
        } rxbroadcastframes_g[31:0];
    } GMACN_MMC_RXBROADCASTFRAMES_G_1 @ 0x418c;
    reg {
        name = "GMACN_MMC_RXMULTICASTFRAMES_G";
        desc = "GMACN_MMC_RXMULTICASTFRAMES_G is the counter of received good multicast frames. GMACN_MMC_RXMULTICASTFRAMES_G (offset 0x0190+Nx0x4000 (N = 0~1), total reset None; PROVEN: Hi3535 data sheet, PDF page 833, section 5.6).";
        field {
            name = "rxmulticastframes_g";
            desc = "Count of received multicast frames.";
            sw = r; hw = w;
        } rxmulticastframes_g[31:0];
    } GMACN_MMC_RXMULTICASTFRAMES_G_0 @ 0x190;
    reg {
        name = "GMACN_MMC_RXMULTICASTFRAMES_G";
        desc = "GMACN_MMC_RXMULTICASTFRAMES_G is the counter of received good multicast frames. GMACN_MMC_RXMULTICASTFRAMES_G (offset 0x0190+Nx0x4000 (N = 0~1), total reset None; PROVEN: Hi3535 data sheet, PDF page 833, section 5.6).";
        field {
            name = "rxmulticastframes_g";
            desc = "Count of received multicast frames.";
            sw = r; hw = w;
        } rxmulticastframes_g[31:0];
    } GMACN_MMC_RXMULTICASTFRAMES_G_1 @ 0x4190;
    reg {
        name = "GMACN_MMC_RXCRCERROR";
        desc = "GMACN_MMC_RXCRCERROR is the register counting received frames with CRC errors. GMACN_MMC_RXCRCERROR (offset 0x0194+Nx0x4000 (N = 0~1), total reset 0x0000_0000; PROVEN: Hi3535 data sheet, PDF page 834, section 5.6).";
        field {
            name = "rxcrcerror";
            desc = "Count of received frames with CRC errors.";
            sw = r; hw = w;
            reset = 0x0;
        } rxcrcerror[31:0];
    } GMACN_MMC_RXCRCERROR_0 @ 0x194;
    reg {
        name = "GMACN_MMC_RXCRCERROR";
        desc = "GMACN_MMC_RXCRCERROR is the register counting received frames with CRC errors. GMACN_MMC_RXCRCERROR (offset 0x0194+Nx0x4000 (N = 0~1), total reset 0x0000_0000; PROVEN: Hi3535 data sheet, PDF page 834, section 5.6).";
        field {
            name = "rxcrcerror";
            desc = "Count of received frames with CRC errors.";
            sw = r; hw = w;
            reset = 0x0;
        } rxcrcerror[31:0];
    } GMACN_MMC_RXCRCERROR_1 @ 0x4194;
    reg {
        name = "GMACN_MMC_RXALIGNMENTERROR";
        desc = "GMACN_MMC_RXALIGNMENTERROR is the counter of received frames with an alignment error (nibble); valid only in 10/100 Mbps mode. GMACN_MMC_RXALIGNMENTERROR (offset 0x0198+Nx0x4000 (N = 0~1), total reset None; PROVEN: Hi3535 data sheet, PDF page 834, section 5.6).";
        field {
            name = "rxalignmenterror";
            desc = "Count of received frames with an alignment error (half byte). Valid only in 10/100Mbps mode.";
            sw = r; hw = w;
        } rxalignmenterror[31:0];
    } GMACN_MMC_RXALIGNMENTERROR_0 @ 0x198;
    reg {
        name = "GMACN_MMC_RXALIGNMENTERROR";
        desc = "GMACN_MMC_RXALIGNMENTERROR is the counter of received frames with an alignment error (nibble); valid only in 10/100 Mbps mode. GMACN_MMC_RXALIGNMENTERROR (offset 0x0198+Nx0x4000 (N = 0~1), total reset None; PROVEN: Hi3535 data sheet, PDF page 834, section 5.6).";
        field {
            name = "rxalignmenterror";
            desc = "Count of received frames with an alignment error (half byte). Valid only in 10/100Mbps mode.";
            sw = r; hw = w;
        } rxalignmenterror[31:0];
    } GMACN_MMC_RXALIGNMENTERROR_1 @ 0x4198;
    reg {
        name = "GMACN_MMC_RXRUNTERROR";
        desc = "GMACN_MMC_RXRUNTERROR is the counter register for received runt frames (<64 bytes) with a CRC error. GMACN_MMC_RXRUNTERROR (offset 0x019C+Nx0x4000 (N = 0~1), total reset 0x0000_0000; PROVEN: Hi3535 data sheet, PDF page 835, section 5.6).";
        field {
            name = "rxrunterror";
            desc = "Count of received runt frames (<64 bytes) with a CRC error.";
            sw = r; hw = w;
            reset = 0x0;
        } rxrunterror[31:0];
    } GMACN_MMC_RXRUNTERROR_0 @ 0x19c;
    reg {
        name = "GMACN_MMC_RXRUNTERROR";
        desc = "GMACN_MMC_RXRUNTERROR is the counter register for received runt frames (<64 bytes) with a CRC error. GMACN_MMC_RXRUNTERROR (offset 0x019C+Nx0x4000 (N = 0~1), total reset 0x0000_0000; PROVEN: Hi3535 data sheet, PDF page 835, section 5.6).";
        field {
            name = "rxrunterror";
            desc = "Count of received runt frames (<64 bytes) with a CRC error.";
            sw = r; hw = w;
            reset = 0x0;
        } rxrunterror[31:0];
    } GMACN_MMC_RXRUNTERROR_1 @ 0x419c;
    reg {
        name = "GMACN_MMC_RXJABBERERROR";
        desc = "GMACN_MMC_RXJABBERERROR is the register counting received oversize frames (>1518 bytes) with CRC errors. GMACN_MMC_RXJABBERERROR (offset 0x01A0+Nx0x4000 (N = 0~1), total reset 0x0000_0000; PROVEN: Hi3535 data sheet, PDF page 835, section 5.6).";
        field {
            name = "rxjabbererror";
            desc = "Count of received oversized frames (>1518 bytes) with an RC error.";
            sw = r; hw = w;
            reset = 0x0;
        } rxjabbererror[31:0];
    } GMACN_MMC_RXJABBERERROR_0 @ 0x1a0;
    reg {
        name = "GMACN_MMC_RXJABBERERROR";
        desc = "GMACN_MMC_RXJABBERERROR is the register counting received oversize frames (>1518 bytes) with CRC errors. GMACN_MMC_RXJABBERERROR (offset 0x01A0+Nx0x4000 (N = 0~1), total reset 0x0000_0000; PROVEN: Hi3535 data sheet, PDF page 835, section 5.6).";
        field {
            name = "rxjabbererror";
            desc = "Count of received oversized frames (>1518 bytes) with an RC error.";
            sw = r; hw = w;
            reset = 0x0;
        } rxjabbererror[31:0];
    } GMACN_MMC_RXJABBERERROR_1 @ 0x41a0;
    reg {
        name = "GMACN_MMC_RXUNDERSIZE_G";
        desc = "GMACN_MMC_RXUNDERSIZE_G is the counter register for received undersize frames (<64 bytes) without any error. GMACN_MMC_RXUNDERSIZE_G (offset 0x01A4+Nx0x4000 (N = 0~1), total reset 0x0000_0000; PROVEN: Hi3535 data sheet, PDF page 835, section 5.6).";
        field {
            name = "rxundersize_g";
            desc = "Frame count of received undersize frames (<64 bytes) without any error.";
            sw = r; hw = w;
            reset = 0x0;
        } rxundersize_g[31:0];
    } GMACN_MMC_RXUNDERSIZE_G_0 @ 0x1a4;
    reg {
        name = "GMACN_MMC_RXUNDERSIZE_G";
        desc = "GMACN_MMC_RXUNDERSIZE_G is the counter register for received undersize frames (<64 bytes) without any error. GMACN_MMC_RXUNDERSIZE_G (offset 0x01A4+Nx0x4000 (N = 0~1), total reset 0x0000_0000; PROVEN: Hi3535 data sheet, PDF page 835, section 5.6).";
        field {
            name = "rxundersize_g";
            desc = "Frame count of received undersize frames (<64 bytes) without any error.";
            sw = r; hw = w;
            reset = 0x0;
        } rxundersize_g[31:0];
    } GMACN_MMC_RXUNDERSIZE_G_1 @ 0x41a4;
    reg {
        name = "GMACN_MMC_RXOVERSIZE_G";
        desc = "GMACN_MMC_RXOVERSIZE_G is the counter register for received oversize frames (>1518 bytes) without any error. GMACN_MMC_RXOVERSIZE_G (offset 0x01A8+Nx0x4000 (N = 0~1), total reset 0x0000_0000; PROVEN: Hi3535 data sheet, PDF page 836, section 5.6).";
        field {
            name = "rxoversize_g";
            desc = "Count of received oversized frames (>1518 bytes) without any error.";
            sw = r; hw = w;
            reset = 0x0;
        } rxoversize_g[31:0];
    } GMACN_MMC_RXOVERSIZE_G_0 @ 0x1a8;
    reg {
        name = "GMACN_MMC_RXOVERSIZE_G";
        desc = "GMACN_MMC_RXOVERSIZE_G is the counter register for received oversize frames (>1518 bytes) without any error. GMACN_MMC_RXOVERSIZE_G (offset 0x01A8+Nx0x4000 (N = 0~1), total reset 0x0000_0000; PROVEN: Hi3535 data sheet, PDF page 836, section 5.6).";
        field {
            name = "rxoversize_g";
            desc = "Count of received oversized frames (>1518 bytes) without any error.";
            sw = r; hw = w;
            reset = 0x0;
        } rxoversize_g[31:0];
    } GMACN_MMC_RXOVERSIZE_G_1 @ 0x41a8;
    reg {
        name = "GMACN_MMC_RX64OCTETS_GB";
        desc = "GMACN_MMC_RX64OCTETS_GB is the counter register for received frames of 64 bytes in length, including good and bad frames, excluding the preamble and retransmitted frames. GMACN_MMC_RX64OCTETS_GB (offset 0x01AC+Nx0x4000 (N = 0~1), total reset 0x0000_0000; PROVEN: Hi3535 data sheet, PDF page 836, section 5.6).";
        field {
            name = "rx64octets_gb";
            desc = "Count of received frames of 64 bytes, including good and bad frames, excluding the preamble and retransmitted frames.";
            sw = r; hw = w;
            reset = 0x0;
        } rx64octets_gb[31:0];
    } GMACN_MMC_RX64OCTETS_GB_0 @ 0x1ac;
    reg {
        name = "GMACN_MMC_RX64OCTETS_GB";
        desc = "GMACN_MMC_RX64OCTETS_GB is the counter register for received frames of 64 bytes in length, including good and bad frames, excluding the preamble and retransmitted frames. GMACN_MMC_RX64OCTETS_GB (offset 0x01AC+Nx0x4000 (N = 0~1), total reset 0x0000_0000; PROVEN: Hi3535 data sheet, PDF page 836, section 5.6).";
        field {
            name = "rx64octets_gb";
            desc = "Count of received frames of 64 bytes, including good and bad frames, excluding the preamble and retransmitted frames.";
            sw = r; hw = w;
            reset = 0x0;
        } rx64octets_gb[31:0];
    } GMACN_MMC_RX64OCTETS_GB_1 @ 0x41ac;
    reg {
        name = "GMACN_MMC_RX65TO127OCTETS_GB";
        desc = "GMACN_MMC_RX65TO127OCTETS_GB is the counter of received frames of 65 to 127 bytes, good and bad frames, excluding preamble and retransmitted frames. GMACN_MMC_RX65TO127OCTETS_GB (offset 0x01B0+Nx0x4000 (N = 0~1), total reset None; PROVEN: Hi3535 data sheet, PDF page 837, section 5.6).";
        field {
            name = "rx65to127octets_gb";
            desc = "Count of frames of the given byte length, including good and bad frames, excluding the preamble and retransmitted frames.";
            sw = r; hw = w;
        } rx65to127octets_gb[31:0];
    } GMACN_MMC_RX65TO127OCTETS_GB_0 @ 0x1b0;
    reg {
        name = "GMACN_MMC_RX65TO127OCTETS_GB";
        desc = "GMACN_MMC_RX65TO127OCTETS_GB is the counter of received frames of 65 to 127 bytes, good and bad frames, excluding preamble and retransmitted frames. GMACN_MMC_RX65TO127OCTETS_GB (offset 0x01B0+Nx0x4000 (N = 0~1), total reset None; PROVEN: Hi3535 data sheet, PDF page 837, section 5.6).";
        field {
            name = "rx65to127octets_gb";
            desc = "Count of frames of the given byte length, including good and bad frames, excluding the preamble and retransmitted frames.";
            sw = r; hw = w;
        } rx65to127octets_gb[31:0];
    } GMACN_MMC_RX65TO127OCTETS_GB_1 @ 0x41b0;
    reg {
        name = "GMACN_MMC_RX1024TOMAXOCTETS_GB";
        desc = "GMACN_MMC_RX1024TOMAXOCTETS_GB is the counter of received frames of 1024 bytes up to the maximum frame length, good and bad frames, excluding preamble and retransmitted frames. GMACN_MMC_RX1024TOMAXOCTETS_GB (offset 0x01C0+Nx0x4000 (N = 0~1), total reset None; PROVEN: Hi3535 data sheet, PDF page 839, section 5.6). INFERRED offset: both the summary and the detail table of the data sheet list 0x01B0 (the offset of GMACN_MMC_RX65TO127OCTETS_GB); 0x01C0 follows the 512..1023 counter at 0x01BC and the standard DesignWare GMAC counter layout.";
        field {
            name = "rx1024tomaxoctets_gb";
            desc = "Count of received frames from 1024 bytes up to the maximum frame length, including good and bad frames, excluding preamble and retransmitted frames.";
            sw = r; hw = w;
        } rx1024tomaxoctets_gb[31:0];
    } GMACN_MMC_RX1024TOMAXOCTETS_GB_0 @ 0x1c0;
    reg {
        name = "GMACN_MMC_RX1024TOMAXOCTETS_GB";
        desc = "GMACN_MMC_RX1024TOMAXOCTETS_GB is the counter of received frames of 1024 bytes up to the maximum frame length, good and bad frames, excluding preamble and retransmitted frames. GMACN_MMC_RX1024TOMAXOCTETS_GB (offset 0x01C0+Nx0x4000 (N = 0~1), total reset None; PROVEN: Hi3535 data sheet, PDF page 839, section 5.6). INFERRED offset: both the summary and the detail table of the data sheet list 0x01B0 (the offset of GMACN_MMC_RX65TO127OCTETS_GB); 0x01C0 follows the 512..1023 counter at 0x01BC and the standard DesignWare GMAC counter layout.";
        field {
            name = "rx1024tomaxoctets_gb";
            desc = "Count of received frames from 1024 bytes up to the maximum frame length, including good and bad frames, excluding preamble and retransmitted frames.";
            sw = r; hw = w;
        } rx1024tomaxoctets_gb[31:0];
    } GMACN_MMC_RX1024TOMAXOCTETS_GB_1 @ 0x41c0;
    reg {
        name = "GMACN_MMC_RX128TO255OCTETS_GB";
        desc = "GMACN_MMC_RX128TO255OCTETS_GB is the counter of received frames of 128 to 255 bytes, good and bad frames, excluding preamble and retransmitted frames. GMACN_MMC_RX128TO255OCTETS_GB (offset 0x01B4+Nx0x4000 (N = 0~1), total reset None; PROVEN: Hi3535 data sheet, PDF page 837, section 5.6).";
        field {
            name = "rx128to255octets_gb";
            desc = "Count of received frames of 128 to 255 bytes in length, including good and bad frames, excluding the preamble and retransmitted frames.";
            sw = r; hw = w;
        } rx128to255octets_gb[31:0];
    } GMACN_MMC_RX128TO255OCTETS_GB_0 @ 0x1b4;
    reg {
        name = "GMACN_MMC_RX128TO255OCTETS_GB";
        desc = "GMACN_MMC_RX128TO255OCTETS_GB is the counter of received frames of 128 to 255 bytes, good and bad frames, excluding preamble and retransmitted frames. GMACN_MMC_RX128TO255OCTETS_GB (offset 0x01B4+Nx0x4000 (N = 0~1), total reset None; PROVEN: Hi3535 data sheet, PDF page 837, section 5.6).";
        field {
            name = "rx128to255octets_gb";
            desc = "Count of received frames of 128 to 255 bytes in length, including good and bad frames, excluding the preamble and retransmitted frames.";
            sw = r; hw = w;
        } rx128to255octets_gb[31:0];
    } GMACN_MMC_RX128TO255OCTETS_GB_1 @ 0x41b4;
    reg {
        name = "GMACN_MMC_RX256TO511OCTETS_GB";
        desc = "GMACN_MMC_RX256TO511OCTETS_GB is the counter of received frames of 256 to 511 bytes, good and bad frames, excluding preamble and retransmitted frames. GMACN_MMC_RX256TO511OCTETS_GB (offset 0x01B8+Nx0x4000 (N = 0~1), total reset None; PROVEN: Hi3535 data sheet, PDF page 838, section 5.6).";
        field {
            name = "rx256to511octets_gb";
            desc = "Frame count of received frames of 256 to 511 bytes in length, including good and bad frames, excluding the preamble and retransmitted frames.";
            sw = r; hw = w;
        } rx256to511octets_gb[31:0];
    } GMACN_MMC_RX256TO511OCTETS_GB_0 @ 0x1b8;
    reg {
        name = "GMACN_MMC_RX256TO511OCTETS_GB";
        desc = "GMACN_MMC_RX256TO511OCTETS_GB is the counter of received frames of 256 to 511 bytes, good and bad frames, excluding preamble and retransmitted frames. GMACN_MMC_RX256TO511OCTETS_GB (offset 0x01B8+Nx0x4000 (N = 0~1), total reset None; PROVEN: Hi3535 data sheet, PDF page 838, section 5.6).";
        field {
            name = "rx256to511octets_gb";
            desc = "Frame count of received frames of 256 to 511 bytes in length, including good and bad frames, excluding the preamble and retransmitted frames.";
            sw = r; hw = w;
        } rx256to511octets_gb[31:0];
    } GMACN_MMC_RX256TO511OCTETS_GB_1 @ 0x41b8;
    reg {
        name = "GMACN_MMC_RX512TO1023OCTETS_GB";
        desc = "GMACN_MMC_RX512TO1023OCTETS_GB is the counter of received frames of 512 to 1023 bytes, good and bad frames, excluding preamble and retransmitted frames. GMACN_MMC_RX512TO1023OCTETS_GB (offset 0x01BC+Nx0x4000 (N = 0~1), total reset None; PROVEN: Hi3535 data sheet, PDF page 838, section 5.6).";
        field {
            name = "rx512to1023octets_gb";
            desc = "Count of received frames of 512 to 1023 bytes, including good and bad frames, excluding the preamble and retransmitted frames.";
            sw = r; hw = w;
        } rx512to1023octets_gb[31:0];
    } GMACN_MMC_RX512TO1023OCTETS_GB_0 @ 0x1bc;
    reg {
        name = "GMACN_MMC_RX512TO1023OCTETS_GB";
        desc = "GMACN_MMC_RX512TO1023OCTETS_GB is the counter of received frames of 512 to 1023 bytes, good and bad frames, excluding preamble and retransmitted frames. GMACN_MMC_RX512TO1023OCTETS_GB (offset 0x01BC+Nx0x4000 (N = 0~1), total reset None; PROVEN: Hi3535 data sheet, PDF page 838, section 5.6).";
        field {
            name = "rx512to1023octets_gb";
            desc = "Count of received frames of 512 to 1023 bytes, including good and bad frames, excluding the preamble and retransmitted frames.";
            sw = r; hw = w;
        } rx512to1023octets_gb[31:0];
    } GMACN_MMC_RX512TO1023OCTETS_GB_1 @ 0x41bc;
    reg {
        name = "GMACN_MMC_RXUNICASTFRAMES_G";
        desc = "GMACN_MMC_RXUNICASTFRAMES_G is the counter of received good unicast frames. GMACN_MMC_RXUNICASTFRAMES_G (offset 0x01C4+Nx0x4000 (N = 0~1), total reset None; PROVEN: Hi3535 data sheet, PDF page 839, section 5.6).";
        field {
            name = "rxunicastframes_g";
            desc = "Count of received good unicast frames.";
            sw = r; hw = w;
        } rxunicastframes_g[31:0];
    } GMACN_MMC_RXUNICASTFRAMES_G_0 @ 0x1c4;
    reg {
        name = "GMACN_MMC_RXUNICASTFRAMES_G";
        desc = "GMACN_MMC_RXUNICASTFRAMES_G is the counter of received good unicast frames. GMACN_MMC_RXUNICASTFRAMES_G (offset 0x01C4+Nx0x4000 (N = 0~1), total reset None; PROVEN: Hi3535 data sheet, PDF page 839, section 5.6).";
        field {
            name = "rxunicastframes_g";
            desc = "Count of received good unicast frames.";
            sw = r; hw = w;
        } rxunicastframes_g[31:0];
    } GMACN_MMC_RXUNICASTFRAMES_G_1 @ 0x41c4;
    reg {
        name = "GMACN_MMC_RXLENGTHERROR";
        desc = "GMACN_MMC_RXLENGTHERROR is the register for the count of frames with a length error (length/type field not equal to the frame size) among all received frames with a valid length field. GMACN_MMC_RXLENGTHERROR (offset 0x01C8+Nx0x4000 (N = 0~1), total reset 0x0000_0000; PROVEN: Hi3535 data sheet, PDF page 840, section 5.6).";
        field {
            name = "rxlengtherror";
            desc = "Count of frames with a length error (the length/type field does not equal the frame size) among all received frames that carry a valid length field.";
            sw = r; hw = w;
            reset = 0x0;
        } rxlengtherror[31:0];
    } GMACN_MMC_RXLENGTHERROR_0 @ 0x1c8;
    reg {
        name = "GMACN_MMC_RXLENGTHERROR";
        desc = "GMACN_MMC_RXLENGTHERROR is the register for the count of frames with a length error (length/type field not equal to the frame size) among all received frames with a valid length field. GMACN_MMC_RXLENGTHERROR (offset 0x01C8+Nx0x4000 (N = 0~1), total reset 0x0000_0000; PROVEN: Hi3535 data sheet, PDF page 840, section 5.6).";
        field {
            name = "rxlengtherror";
            desc = "Count of frames with a length error (the length/type field does not equal the frame size) among all received frames that carry a valid length field.";
            sw = r; hw = w;
            reset = 0x0;
        } rxlengtherror[31:0];
    } GMACN_MMC_RXLENGTHERROR_1 @ 0x41c8;
    reg {
        name = "GMACN_MMC_RXOUTOFRANGETYPE";
        desc = "GMACN_MMC_RXOUTOFRANGETYPE is the counter of received frames whose length field is outside the valid range (1501 to 1536 bytes). GMACN_MMC_RXOUTOFRANGETYPE (offset 0x01CC+Nx0x4000 (N = 0~1), total reset None; PROVEN: Hi3535 data sheet, PDF page 840, section 5.6).";
        field {
            name = "rxoutofrangetype";
            desc = "Count of received frames whose length field is not in the valid range (1501 to 1536 bytes).";
            sw = r; hw = w;
        } rxoutofrangetype[31:0];
    } GMACN_MMC_RXOUTOFRANGETYPE_0 @ 0x1cc;
    reg {
        name = "GMACN_MMC_RXOUTOFRANGETYPE";
        desc = "GMACN_MMC_RXOUTOFRANGETYPE is the counter of received frames whose length field is outside the valid range (1501 to 1536 bytes). GMACN_MMC_RXOUTOFRANGETYPE (offset 0x01CC+Nx0x4000 (N = 0~1), total reset None; PROVEN: Hi3535 data sheet, PDF page 840, section 5.6).";
        field {
            name = "rxoutofrangetype";
            desc = "Count of received frames whose length field is not in the valid range (1501 to 1536 bytes).";
            sw = r; hw = w;
        } rxoutofrangetype[31:0];
    } GMACN_MMC_RXOUTOFRANGETYPE_1 @ 0x41cc;
    reg {
        name = "GMACN_MMC_RXPAUSEFRAMES";
        desc = "GMACN_MMC_RXPAUSEFRAMES is the counter register for received valid pause frames. GMACN_MMC_RXPAUSEFRAMES (offset 0x01D0+Nx0x4000 (N = 0~1), total reset 0x0000_0000; PROVEN: Hi3535 data sheet, PDF page 841, section 5.6).";
        field {
            name = "rxpauseframes";
            desc = "Frame count of received valid pause frames.";
            sw = r; hw = w;
            reset = 0x0;
        } rxpauseframes[31:0];
    } GMACN_MMC_RXPAUSEFRAMES_0 @ 0x1d0;
    reg {
        name = "GMACN_MMC_RXPAUSEFRAMES";
        desc = "GMACN_MMC_RXPAUSEFRAMES is the counter register for received valid pause frames. GMACN_MMC_RXPAUSEFRAMES (offset 0x01D0+Nx0x4000 (N = 0~1), total reset 0x0000_0000; PROVEN: Hi3535 data sheet, PDF page 841, section 5.6).";
        field {
            name = "rxpauseframes";
            desc = "Frame count of received valid pause frames.";
            sw = r; hw = w;
            reset = 0x0;
        } rxpauseframes[31:0];
    } GMACN_MMC_RXPAUSEFRAMES_1 @ 0x41d0;
    reg {
        name = "GMACN_MMC_RXFIFOOVERFLOW";
        desc = "GMACN_MMC_RXFIFOOVERFLOW is the register for the count of received frames dropped because of FIFO overflow. GMACN_MMC_RXFIFOOVERFLOW (offset 0x01D4+Nx0x4000 (N = 0~1), total reset 0x0000_0000; PROVEN: Hi3535 data sheet, PDF page 841, section 5.6).";
        field {
            name = "rxfifooverflow";
            desc = "Frame count of received frames dropped because of FIFO overflow.";
            sw = r; hw = w;
            reset = 0x0;
        } rxfifooverflow[31:0];
    } GMACN_MMC_RXFIFOOVERFLOW_0 @ 0x1d4;
    reg {
        name = "GMACN_MMC_RXFIFOOVERFLOW";
        desc = "GMACN_MMC_RXFIFOOVERFLOW is the register for the count of received frames dropped because of FIFO overflow. GMACN_MMC_RXFIFOOVERFLOW (offset 0x01D4+Nx0x4000 (N = 0~1), total reset 0x0000_0000; PROVEN: Hi3535 data sheet, PDF page 841, section 5.6).";
        field {
            name = "rxfifooverflow";
            desc = "Frame count of received frames dropped because of FIFO overflow.";
            sw = r; hw = w;
            reset = 0x0;
        } rxfifooverflow[31:0];
    } GMACN_MMC_RXFIFOOVERFLOW_1 @ 0x41d4;
    reg {
        name = "GMACN_MMC_RXVLANFRAMES_GB";
        desc = "GMACN_MMC_RXVLANFRAMES_GB is the counter of received VLAN frames, good and bad. GMACN_MMC_RXVLANFRAMES_GB (offset 0x01D8+Nx0x4000 (N = 0~1), total reset None; PROVEN: Hi3535 data sheet, PDF page 841, section 5.6).";
        field {
            name = "rxvlanframes_gb";
            desc = "Count of received VLAN frames, including good and bad frames.";
            sw = r; hw = w;
        } rxvlanframes_gb[31:0];
    } GMACN_MMC_RXVLANFRAMES_GB_0 @ 0x1d8;
    reg {
        name = "GMACN_MMC_RXVLANFRAMES_GB";
        desc = "GMACN_MMC_RXVLANFRAMES_GB is the counter of received VLAN frames, good and bad. GMACN_MMC_RXVLANFRAMES_GB (offset 0x01D8+Nx0x4000 (N = 0~1), total reset None; PROVEN: Hi3535 data sheet, PDF page 841, section 5.6).";
        field {
            name = "rxvlanframes_gb";
            desc = "Count of received VLAN frames, including good and bad frames.";
            sw = r; hw = w;
        } rxvlanframes_gb[31:0];
    } GMACN_MMC_RXVLANFRAMES_GB_1 @ 0x41d8;
    reg {
        name = "GMACN_MMC_RXWATCHDOGERROR";
        desc = "GMACN_MMC_RXWATCHDOGERROR is the counter of received frames with a watchdog timeout (frame data longer than 2048 bytes). GMACN_MMC_RXWATCHDOGERROR (offset 0x01DC+Nx0x4000 (N = 0~1), total reset None; PROVEN: Hi3535 data sheet, PDF page 842, section 5.6).";
        field {
            name = "rxwatchdogerror";
            desc = "Frame count of received frames with a watchdog timeout (frame data length exceeding 2048 bytes).";
            sw = r; hw = w;
        } rxwatchdogerror[31:0];
    } GMACN_MMC_RXWATCHDOGERROR_0 @ 0x1dc;
    reg {
        name = "GMACN_MMC_RXWATCHDOGERROR";
        desc = "GMACN_MMC_RXWATCHDOGERROR is the counter of received frames with a watchdog timeout (frame data longer than 2048 bytes). GMACN_MMC_RXWATCHDOGERROR (offset 0x01DC+Nx0x4000 (N = 0~1), total reset None; PROVEN: Hi3535 data sheet, PDF page 842, section 5.6).";
        field {
            name = "rxwatchdogerror";
            desc = "Frame count of received frames with a watchdog timeout (frame data length exceeding 2048 bytes).";
            sw = r; hw = w;
        } rxwatchdogerror[31:0];
    } GMACN_MMC_RXWATCHDOGERROR_1 @ 0x41dc;
    reg {
        name = "GMACN_ADDRY_HIGH";
        desc = "GMACN_ADDRY_HIGH is the register for the upper 16 bits [47:32] of the Y-th (16 to 31) MAC address of GMACn (0 to 1). GMACN_ADDRY_HIGH (offset 0x0800+Yx0x8 (Y = 0~15), total reset 0x0000_FFFF; PROVEN: Hi3535 data sheet, PDF page 818, section 5.6). Registers for Y = 16..31 (offset 0x780 + n x 0x4000 + Y x 0x8; instances 0..15 below are Y = 16..31). Address registers 1-15 (X) and 16-31 (Y) of GMAC n sit at the formula offsets of the data sheet (0x40 + n x 0x4000 + X x 0x8 / 0x780 + n x 0x4000 + Y x 0x8); modelled for GMAC 0 as 15 resp. 16 instances, GMAC 1 is the same layout 0x4000 higher.";
        field {
            name = "ae";
            desc = "AE: address enable.
- 0: When this bit is 0, the address filter module ignores this MAC address;
- 1: When this bit is 1, the address filter module uses this MAC address for perfect filtering.";
            sw = rw; hw = r;
            reset = 0x0;
        } ae[31:31];
        field {
            name = "sa";
            desc = "SA: source address.
- 0: This MAC address is used for comparison with the DA of received frames.
- 1: This MAC address is used for comparison with the SA of received frames.";
            sw = rw; hw = r;
            reset = 0x0;
        } sa[30:30];
        field {
            name = "mbc";
            desc = "MBC: Mask byte control. These bits are the mask control bits for each byte of the MAC address. The meaning of each bit is as follows:
- 0: The GMAC uses this byte for address filtering.
- 1: The GMAC does not use this byte for address filtering. The MAC address byte corresponding to each bit is as follows: bit[29]: byte 6 of the MAC address [47:40]; bit[28]: byte 5 of the MAC address [39:32]; bit[27]: byte 4 of the MAC address [31:24]; bit[26]: byte 3 of the MAC address [23:16]; bit[25]: byte 2 of the MAC address [15:8]; bit[24]: byte 1 of the MAC address [7:0].";
            sw = rw; hw = r;
            reset = 0x0;
        } mbc[29:24];
        field {
            name = "reserved";
            desc = "Reserved.";
            sw = r; hw = w;
            reset = 0x0;
        } reserved_23_16[23:16];
        field {
            name = "mac_addr_h16";
            desc = "A[47:32]: Contains the upper 16 bits [47:32] of the 6-byte MAC address, used for receive frame filtering and for transmitting pause frames.";
            sw = rw; hw = r;
            reset = 0xffff;
        } mac_addr_h16[15:0];
    } GMACN_ADDRY_HIGH_0 @ 0x800;
    reg {
        name = "GMACN_ADDRY_HIGH";
        desc = "GMACN_ADDRY_HIGH is the register for the upper 16 bits [47:32] of the Y-th (16 to 31) MAC address of GMACn (0 to 1). GMACN_ADDRY_HIGH (offset 0x0800+Yx0x8 (Y = 0~15), total reset 0x0000_FFFF; PROVEN: Hi3535 data sheet, PDF page 818, section 5.6). Registers for Y = 16..31 (offset 0x780 + n x 0x4000 + Y x 0x8; instances 0..15 below are Y = 16..31). Address registers 1-15 (X) and 16-31 (Y) of GMAC n sit at the formula offsets of the data sheet (0x40 + n x 0x4000 + X x 0x8 / 0x780 + n x 0x4000 + Y x 0x8); modelled for GMAC 0 as 15 resp. 16 instances, GMAC 1 is the same layout 0x4000 higher.";
        field {
            name = "ae";
            desc = "AE: address enable.
- 0: When this bit is 0, the address filter module ignores this MAC address;
- 1: When this bit is 1, the address filter module uses this MAC address for perfect filtering.";
            sw = rw; hw = r;
            reset = 0x0;
        } ae[31:31];
        field {
            name = "sa";
            desc = "SA: source address.
- 0: This MAC address is used for comparison with the DA of received frames.
- 1: This MAC address is used for comparison with the SA of received frames.";
            sw = rw; hw = r;
            reset = 0x0;
        } sa[30:30];
        field {
            name = "mbc";
            desc = "MBC: Mask byte control. These bits are the mask control bits for each byte of the MAC address. The meaning of each bit is as follows:
- 0: The GMAC uses this byte for address filtering.
- 1: The GMAC does not use this byte for address filtering. The MAC address byte corresponding to each bit is as follows: bit[29]: byte 6 of the MAC address [47:40]; bit[28]: byte 5 of the MAC address [39:32]; bit[27]: byte 4 of the MAC address [31:24]; bit[26]: byte 3 of the MAC address [23:16]; bit[25]: byte 2 of the MAC address [15:8]; bit[24]: byte 1 of the MAC address [7:0].";
            sw = rw; hw = r;
            reset = 0x0;
        } mbc[29:24];
        field {
            name = "reserved";
            desc = "Reserved.";
            sw = r; hw = w;
            reset = 0x0;
        } reserved_23_16[23:16];
        field {
            name = "mac_addr_h16";
            desc = "A[47:32]: Contains the upper 16 bits [47:32] of the 6-byte MAC address, used for receive frame filtering and for transmitting pause frames.";
            sw = rw; hw = r;
            reset = 0xffff;
        } mac_addr_h16[15:0];
    } GMACN_ADDRY_HIGH_1 @ 0x808;
    reg {
        name = "GMACN_ADDRY_HIGH";
        desc = "GMACN_ADDRY_HIGH is the register for the upper 16 bits [47:32] of the Y-th (16 to 31) MAC address of GMACn (0 to 1). GMACN_ADDRY_HIGH (offset 0x0800+Yx0x8 (Y = 0~15), total reset 0x0000_FFFF; PROVEN: Hi3535 data sheet, PDF page 818, section 5.6). Registers for Y = 16..31 (offset 0x780 + n x 0x4000 + Y x 0x8; instances 0..15 below are Y = 16..31). Address registers 1-15 (X) and 16-31 (Y) of GMAC n sit at the formula offsets of the data sheet (0x40 + n x 0x4000 + X x 0x8 / 0x780 + n x 0x4000 + Y x 0x8); modelled for GMAC 0 as 15 resp. 16 instances, GMAC 1 is the same layout 0x4000 higher.";
        field {
            name = "ae";
            desc = "AE: address enable.
- 0: When this bit is 0, the address filter module ignores this MAC address;
- 1: When this bit is 1, the address filter module uses this MAC address for perfect filtering.";
            sw = rw; hw = r;
            reset = 0x0;
        } ae[31:31];
        field {
            name = "sa";
            desc = "SA: source address.
- 0: This MAC address is used for comparison with the DA of received frames.
- 1: This MAC address is used for comparison with the SA of received frames.";
            sw = rw; hw = r;
            reset = 0x0;
        } sa[30:30];
        field {
            name = "mbc";
            desc = "MBC: Mask byte control. These bits are the mask control bits for each byte of the MAC address. The meaning of each bit is as follows:
- 0: The GMAC uses this byte for address filtering.
- 1: The GMAC does not use this byte for address filtering. The MAC address byte corresponding to each bit is as follows: bit[29]: byte 6 of the MAC address [47:40]; bit[28]: byte 5 of the MAC address [39:32]; bit[27]: byte 4 of the MAC address [31:24]; bit[26]: byte 3 of the MAC address [23:16]; bit[25]: byte 2 of the MAC address [15:8]; bit[24]: byte 1 of the MAC address [7:0].";
            sw = rw; hw = r;
            reset = 0x0;
        } mbc[29:24];
        field {
            name = "reserved";
            desc = "Reserved.";
            sw = r; hw = w;
            reset = 0x0;
        } reserved_23_16[23:16];
        field {
            name = "mac_addr_h16";
            desc = "A[47:32]: Contains the upper 16 bits [47:32] of the 6-byte MAC address, used for receive frame filtering and for transmitting pause frames.";
            sw = rw; hw = r;
            reset = 0xffff;
        } mac_addr_h16[15:0];
    } GMACN_ADDRY_HIGH_2 @ 0x810;
    reg {
        name = "GMACN_ADDRY_HIGH";
        desc = "GMACN_ADDRY_HIGH is the register for the upper 16 bits [47:32] of the Y-th (16 to 31) MAC address of GMACn (0 to 1). GMACN_ADDRY_HIGH (offset 0x0800+Yx0x8 (Y = 0~15), total reset 0x0000_FFFF; PROVEN: Hi3535 data sheet, PDF page 818, section 5.6). Registers for Y = 16..31 (offset 0x780 + n x 0x4000 + Y x 0x8; instances 0..15 below are Y = 16..31). Address registers 1-15 (X) and 16-31 (Y) of GMAC n sit at the formula offsets of the data sheet (0x40 + n x 0x4000 + X x 0x8 / 0x780 + n x 0x4000 + Y x 0x8); modelled for GMAC 0 as 15 resp. 16 instances, GMAC 1 is the same layout 0x4000 higher.";
        field {
            name = "ae";
            desc = "AE: address enable.
- 0: When this bit is 0, the address filter module ignores this MAC address;
- 1: When this bit is 1, the address filter module uses this MAC address for perfect filtering.";
            sw = rw; hw = r;
            reset = 0x0;
        } ae[31:31];
        field {
            name = "sa";
            desc = "SA: source address.
- 0: This MAC address is used for comparison with the DA of received frames.
- 1: This MAC address is used for comparison with the SA of received frames.";
            sw = rw; hw = r;
            reset = 0x0;
        } sa[30:30];
        field {
            name = "mbc";
            desc = "MBC: Mask byte control. These bits are the mask control bits for each byte of the MAC address. The meaning of each bit is as follows:
- 0: The GMAC uses this byte for address filtering.
- 1: The GMAC does not use this byte for address filtering. The MAC address byte corresponding to each bit is as follows: bit[29]: byte 6 of the MAC address [47:40]; bit[28]: byte 5 of the MAC address [39:32]; bit[27]: byte 4 of the MAC address [31:24]; bit[26]: byte 3 of the MAC address [23:16]; bit[25]: byte 2 of the MAC address [15:8]; bit[24]: byte 1 of the MAC address [7:0].";
            sw = rw; hw = r;
            reset = 0x0;
        } mbc[29:24];
        field {
            name = "reserved";
            desc = "Reserved.";
            sw = r; hw = w;
            reset = 0x0;
        } reserved_23_16[23:16];
        field {
            name = "mac_addr_h16";
            desc = "A[47:32]: Contains the upper 16 bits [47:32] of the 6-byte MAC address, used for receive frame filtering and for transmitting pause frames.";
            sw = rw; hw = r;
            reset = 0xffff;
        } mac_addr_h16[15:0];
    } GMACN_ADDRY_HIGH_3 @ 0x818;
    reg {
        name = "GMACN_ADDRY_HIGH";
        desc = "GMACN_ADDRY_HIGH is the register for the upper 16 bits [47:32] of the Y-th (16 to 31) MAC address of GMACn (0 to 1). GMACN_ADDRY_HIGH (offset 0x0800+Yx0x8 (Y = 0~15), total reset 0x0000_FFFF; PROVEN: Hi3535 data sheet, PDF page 818, section 5.6). Registers for Y = 16..31 (offset 0x780 + n x 0x4000 + Y x 0x8; instances 0..15 below are Y = 16..31). Address registers 1-15 (X) and 16-31 (Y) of GMAC n sit at the formula offsets of the data sheet (0x40 + n x 0x4000 + X x 0x8 / 0x780 + n x 0x4000 + Y x 0x8); modelled for GMAC 0 as 15 resp. 16 instances, GMAC 1 is the same layout 0x4000 higher.";
        field {
            name = "ae";
            desc = "AE: address enable.
- 0: When this bit is 0, the address filter module ignores this MAC address;
- 1: When this bit is 1, the address filter module uses this MAC address for perfect filtering.";
            sw = rw; hw = r;
            reset = 0x0;
        } ae[31:31];
        field {
            name = "sa";
            desc = "SA: source address.
- 0: This MAC address is used for comparison with the DA of received frames.
- 1: This MAC address is used for comparison with the SA of received frames.";
            sw = rw; hw = r;
            reset = 0x0;
        } sa[30:30];
        field {
            name = "mbc";
            desc = "MBC: Mask byte control. These bits are the mask control bits for each byte of the MAC address. The meaning of each bit is as follows:
- 0: The GMAC uses this byte for address filtering.
- 1: The GMAC does not use this byte for address filtering. The MAC address byte corresponding to each bit is as follows: bit[29]: byte 6 of the MAC address [47:40]; bit[28]: byte 5 of the MAC address [39:32]; bit[27]: byte 4 of the MAC address [31:24]; bit[26]: byte 3 of the MAC address [23:16]; bit[25]: byte 2 of the MAC address [15:8]; bit[24]: byte 1 of the MAC address [7:0].";
            sw = rw; hw = r;
            reset = 0x0;
        } mbc[29:24];
        field {
            name = "reserved";
            desc = "Reserved.";
            sw = r; hw = w;
            reset = 0x0;
        } reserved_23_16[23:16];
        field {
            name = "mac_addr_h16";
            desc = "A[47:32]: Contains the upper 16 bits [47:32] of the 6-byte MAC address, used for receive frame filtering and for transmitting pause frames.";
            sw = rw; hw = r;
            reset = 0xffff;
        } mac_addr_h16[15:0];
    } GMACN_ADDRY_HIGH_4 @ 0x820;
    reg {
        name = "GMACN_ADDRY_HIGH";
        desc = "GMACN_ADDRY_HIGH is the register for the upper 16 bits [47:32] of the Y-th (16 to 31) MAC address of GMACn (0 to 1). GMACN_ADDRY_HIGH (offset 0x0800+Yx0x8 (Y = 0~15), total reset 0x0000_FFFF; PROVEN: Hi3535 data sheet, PDF page 818, section 5.6). Registers for Y = 16..31 (offset 0x780 + n x 0x4000 + Y x 0x8; instances 0..15 below are Y = 16..31). Address registers 1-15 (X) and 16-31 (Y) of GMAC n sit at the formula offsets of the data sheet (0x40 + n x 0x4000 + X x 0x8 / 0x780 + n x 0x4000 + Y x 0x8); modelled for GMAC 0 as 15 resp. 16 instances, GMAC 1 is the same layout 0x4000 higher.";
        field {
            name = "ae";
            desc = "AE: address enable.
- 0: When this bit is 0, the address filter module ignores this MAC address;
- 1: When this bit is 1, the address filter module uses this MAC address for perfect filtering.";
            sw = rw; hw = r;
            reset = 0x0;
        } ae[31:31];
        field {
            name = "sa";
            desc = "SA: source address.
- 0: This MAC address is used for comparison with the DA of received frames.
- 1: This MAC address is used for comparison with the SA of received frames.";
            sw = rw; hw = r;
            reset = 0x0;
        } sa[30:30];
        field {
            name = "mbc";
            desc = "MBC: Mask byte control. These bits are the mask control bits for each byte of the MAC address. The meaning of each bit is as follows:
- 0: The GMAC uses this byte for address filtering.
- 1: The GMAC does not use this byte for address filtering. The MAC address byte corresponding to each bit is as follows: bit[29]: byte 6 of the MAC address [47:40]; bit[28]: byte 5 of the MAC address [39:32]; bit[27]: byte 4 of the MAC address [31:24]; bit[26]: byte 3 of the MAC address [23:16]; bit[25]: byte 2 of the MAC address [15:8]; bit[24]: byte 1 of the MAC address [7:0].";
            sw = rw; hw = r;
            reset = 0x0;
        } mbc[29:24];
        field {
            name = "reserved";
            desc = "Reserved.";
            sw = r; hw = w;
            reset = 0x0;
        } reserved_23_16[23:16];
        field {
            name = "mac_addr_h16";
            desc = "A[47:32]: Contains the upper 16 bits [47:32] of the 6-byte MAC address, used for receive frame filtering and for transmitting pause frames.";
            sw = rw; hw = r;
            reset = 0xffff;
        } mac_addr_h16[15:0];
    } GMACN_ADDRY_HIGH_5 @ 0x828;
    reg {
        name = "GMACN_ADDRY_HIGH";
        desc = "GMACN_ADDRY_HIGH is the register for the upper 16 bits [47:32] of the Y-th (16 to 31) MAC address of GMACn (0 to 1). GMACN_ADDRY_HIGH (offset 0x0800+Yx0x8 (Y = 0~15), total reset 0x0000_FFFF; PROVEN: Hi3535 data sheet, PDF page 818, section 5.6). Registers for Y = 16..31 (offset 0x780 + n x 0x4000 + Y x 0x8; instances 0..15 below are Y = 16..31). Address registers 1-15 (X) and 16-31 (Y) of GMAC n sit at the formula offsets of the data sheet (0x40 + n x 0x4000 + X x 0x8 / 0x780 + n x 0x4000 + Y x 0x8); modelled for GMAC 0 as 15 resp. 16 instances, GMAC 1 is the same layout 0x4000 higher.";
        field {
            name = "ae";
            desc = "AE: address enable.
- 0: When this bit is 0, the address filter module ignores this MAC address;
- 1: When this bit is 1, the address filter module uses this MAC address for perfect filtering.";
            sw = rw; hw = r;
            reset = 0x0;
        } ae[31:31];
        field {
            name = "sa";
            desc = "SA: source address.
- 0: This MAC address is used for comparison with the DA of received frames.
- 1: This MAC address is used for comparison with the SA of received frames.";
            sw = rw; hw = r;
            reset = 0x0;
        } sa[30:30];
        field {
            name = "mbc";
            desc = "MBC: Mask byte control. These bits are the mask control bits for each byte of the MAC address. The meaning of each bit is as follows:
- 0: The GMAC uses this byte for address filtering.
- 1: The GMAC does not use this byte for address filtering. The MAC address byte corresponding to each bit is as follows: bit[29]: byte 6 of the MAC address [47:40]; bit[28]: byte 5 of the MAC address [39:32]; bit[27]: byte 4 of the MAC address [31:24]; bit[26]: byte 3 of the MAC address [23:16]; bit[25]: byte 2 of the MAC address [15:8]; bit[24]: byte 1 of the MAC address [7:0].";
            sw = rw; hw = r;
            reset = 0x0;
        } mbc[29:24];
        field {
            name = "reserved";
            desc = "Reserved.";
            sw = r; hw = w;
            reset = 0x0;
        } reserved_23_16[23:16];
        field {
            name = "mac_addr_h16";
            desc = "A[47:32]: Contains the upper 16 bits [47:32] of the 6-byte MAC address, used for receive frame filtering and for transmitting pause frames.";
            sw = rw; hw = r;
            reset = 0xffff;
        } mac_addr_h16[15:0];
    } GMACN_ADDRY_HIGH_6 @ 0x830;
    reg {
        name = "GMACN_ADDRY_HIGH";
        desc = "GMACN_ADDRY_HIGH is the register for the upper 16 bits [47:32] of the Y-th (16 to 31) MAC address of GMACn (0 to 1). GMACN_ADDRY_HIGH (offset 0x0800+Yx0x8 (Y = 0~15), total reset 0x0000_FFFF; PROVEN: Hi3535 data sheet, PDF page 818, section 5.6). Registers for Y = 16..31 (offset 0x780 + n x 0x4000 + Y x 0x8; instances 0..15 below are Y = 16..31). Address registers 1-15 (X) and 16-31 (Y) of GMAC n sit at the formula offsets of the data sheet (0x40 + n x 0x4000 + X x 0x8 / 0x780 + n x 0x4000 + Y x 0x8); modelled for GMAC 0 as 15 resp. 16 instances, GMAC 1 is the same layout 0x4000 higher.";
        field {
            name = "ae";
            desc = "AE: address enable.
- 0: When this bit is 0, the address filter module ignores this MAC address;
- 1: When this bit is 1, the address filter module uses this MAC address for perfect filtering.";
            sw = rw; hw = r;
            reset = 0x0;
        } ae[31:31];
        field {
            name = "sa";
            desc = "SA: source address.
- 0: This MAC address is used for comparison with the DA of received frames.
- 1: This MAC address is used for comparison with the SA of received frames.";
            sw = rw; hw = r;
            reset = 0x0;
        } sa[30:30];
        field {
            name = "mbc";
            desc = "MBC: Mask byte control. These bits are the mask control bits for each byte of the MAC address. The meaning of each bit is as follows:
- 0: The GMAC uses this byte for address filtering.
- 1: The GMAC does not use this byte for address filtering. The MAC address byte corresponding to each bit is as follows: bit[29]: byte 6 of the MAC address [47:40]; bit[28]: byte 5 of the MAC address [39:32]; bit[27]: byte 4 of the MAC address [31:24]; bit[26]: byte 3 of the MAC address [23:16]; bit[25]: byte 2 of the MAC address [15:8]; bit[24]: byte 1 of the MAC address [7:0].";
            sw = rw; hw = r;
            reset = 0x0;
        } mbc[29:24];
        field {
            name = "reserved";
            desc = "Reserved.";
            sw = r; hw = w;
            reset = 0x0;
        } reserved_23_16[23:16];
        field {
            name = "mac_addr_h16";
            desc = "A[47:32]: Contains the upper 16 bits [47:32] of the 6-byte MAC address, used for receive frame filtering and for transmitting pause frames.";
            sw = rw; hw = r;
            reset = 0xffff;
        } mac_addr_h16[15:0];
    } GMACN_ADDRY_HIGH_7 @ 0x838;
    reg {
        name = "GMACN_ADDRY_HIGH";
        desc = "GMACN_ADDRY_HIGH is the register for the upper 16 bits [47:32] of the Y-th (16 to 31) MAC address of GMACn (0 to 1). GMACN_ADDRY_HIGH (offset 0x0800+Yx0x8 (Y = 0~15), total reset 0x0000_FFFF; PROVEN: Hi3535 data sheet, PDF page 818, section 5.6). Registers for Y = 16..31 (offset 0x780 + n x 0x4000 + Y x 0x8; instances 0..15 below are Y = 16..31). Address registers 1-15 (X) and 16-31 (Y) of GMAC n sit at the formula offsets of the data sheet (0x40 + n x 0x4000 + X x 0x8 / 0x780 + n x 0x4000 + Y x 0x8); modelled for GMAC 0 as 15 resp. 16 instances, GMAC 1 is the same layout 0x4000 higher.";
        field {
            name = "ae";
            desc = "AE: address enable.
- 0: When this bit is 0, the address filter module ignores this MAC address;
- 1: When this bit is 1, the address filter module uses this MAC address for perfect filtering.";
            sw = rw; hw = r;
            reset = 0x0;
        } ae[31:31];
        field {
            name = "sa";
            desc = "SA: source address.
- 0: This MAC address is used for comparison with the DA of received frames.
- 1: This MAC address is used for comparison with the SA of received frames.";
            sw = rw; hw = r;
            reset = 0x0;
        } sa[30:30];
        field {
            name = "mbc";
            desc = "MBC: Mask byte control. These bits are the mask control bits for each byte of the MAC address. The meaning of each bit is as follows:
- 0: The GMAC uses this byte for address filtering.
- 1: The GMAC does not use this byte for address filtering. The MAC address byte corresponding to each bit is as follows: bit[29]: byte 6 of the MAC address [47:40]; bit[28]: byte 5 of the MAC address [39:32]; bit[27]: byte 4 of the MAC address [31:24]; bit[26]: byte 3 of the MAC address [23:16]; bit[25]: byte 2 of the MAC address [15:8]; bit[24]: byte 1 of the MAC address [7:0].";
            sw = rw; hw = r;
            reset = 0x0;
        } mbc[29:24];
        field {
            name = "reserved";
            desc = "Reserved.";
            sw = r; hw = w;
            reset = 0x0;
        } reserved_23_16[23:16];
        field {
            name = "mac_addr_h16";
            desc = "A[47:32]: Contains the upper 16 bits [47:32] of the 6-byte MAC address, used for receive frame filtering and for transmitting pause frames.";
            sw = rw; hw = r;
            reset = 0xffff;
        } mac_addr_h16[15:0];
    } GMACN_ADDRY_HIGH_8 @ 0x840;
    reg {
        name = "GMACN_ADDRY_HIGH";
        desc = "GMACN_ADDRY_HIGH is the register for the upper 16 bits [47:32] of the Y-th (16 to 31) MAC address of GMACn (0 to 1). GMACN_ADDRY_HIGH (offset 0x0800+Yx0x8 (Y = 0~15), total reset 0x0000_FFFF; PROVEN: Hi3535 data sheet, PDF page 818, section 5.6). Registers for Y = 16..31 (offset 0x780 + n x 0x4000 + Y x 0x8; instances 0..15 below are Y = 16..31). Address registers 1-15 (X) and 16-31 (Y) of GMAC n sit at the formula offsets of the data sheet (0x40 + n x 0x4000 + X x 0x8 / 0x780 + n x 0x4000 + Y x 0x8); modelled for GMAC 0 as 15 resp. 16 instances, GMAC 1 is the same layout 0x4000 higher.";
        field {
            name = "ae";
            desc = "AE: address enable.
- 0: When this bit is 0, the address filter module ignores this MAC address;
- 1: When this bit is 1, the address filter module uses this MAC address for perfect filtering.";
            sw = rw; hw = r;
            reset = 0x0;
        } ae[31:31];
        field {
            name = "sa";
            desc = "SA: source address.
- 0: This MAC address is used for comparison with the DA of received frames.
- 1: This MAC address is used for comparison with the SA of received frames.";
            sw = rw; hw = r;
            reset = 0x0;
        } sa[30:30];
        field {
            name = "mbc";
            desc = "MBC: Mask byte control. These bits are the mask control bits for each byte of the MAC address. The meaning of each bit is as follows:
- 0: The GMAC uses this byte for address filtering.
- 1: The GMAC does not use this byte for address filtering. The MAC address byte corresponding to each bit is as follows: bit[29]: byte 6 of the MAC address [47:40]; bit[28]: byte 5 of the MAC address [39:32]; bit[27]: byte 4 of the MAC address [31:24]; bit[26]: byte 3 of the MAC address [23:16]; bit[25]: byte 2 of the MAC address [15:8]; bit[24]: byte 1 of the MAC address [7:0].";
            sw = rw; hw = r;
            reset = 0x0;
        } mbc[29:24];
        field {
            name = "reserved";
            desc = "Reserved.";
            sw = r; hw = w;
            reset = 0x0;
        } reserved_23_16[23:16];
        field {
            name = "mac_addr_h16";
            desc = "A[47:32]: Contains the upper 16 bits [47:32] of the 6-byte MAC address, used for receive frame filtering and for transmitting pause frames.";
            sw = rw; hw = r;
            reset = 0xffff;
        } mac_addr_h16[15:0];
    } GMACN_ADDRY_HIGH_9 @ 0x848;
    reg {
        name = "GMACN_ADDRY_HIGH";
        desc = "GMACN_ADDRY_HIGH is the register for the upper 16 bits [47:32] of the Y-th (16 to 31) MAC address of GMACn (0 to 1). GMACN_ADDRY_HIGH (offset 0x0800+Yx0x8 (Y = 0~15), total reset 0x0000_FFFF; PROVEN: Hi3535 data sheet, PDF page 818, section 5.6). Registers for Y = 16..31 (offset 0x780 + n x 0x4000 + Y x 0x8; instances 0..15 below are Y = 16..31). Address registers 1-15 (X) and 16-31 (Y) of GMAC n sit at the formula offsets of the data sheet (0x40 + n x 0x4000 + X x 0x8 / 0x780 + n x 0x4000 + Y x 0x8); modelled for GMAC 0 as 15 resp. 16 instances, GMAC 1 is the same layout 0x4000 higher.";
        field {
            name = "ae";
            desc = "AE: address enable.
- 0: When this bit is 0, the address filter module ignores this MAC address;
- 1: When this bit is 1, the address filter module uses this MAC address for perfect filtering.";
            sw = rw; hw = r;
            reset = 0x0;
        } ae[31:31];
        field {
            name = "sa";
            desc = "SA: source address.
- 0: This MAC address is used for comparison with the DA of received frames.
- 1: This MAC address is used for comparison with the SA of received frames.";
            sw = rw; hw = r;
            reset = 0x0;
        } sa[30:30];
        field {
            name = "mbc";
            desc = "MBC: Mask byte control. These bits are the mask control bits for each byte of the MAC address. The meaning of each bit is as follows:
- 0: The GMAC uses this byte for address filtering.
- 1: The GMAC does not use this byte for address filtering. The MAC address byte corresponding to each bit is as follows: bit[29]: byte 6 of the MAC address [47:40]; bit[28]: byte 5 of the MAC address [39:32]; bit[27]: byte 4 of the MAC address [31:24]; bit[26]: byte 3 of the MAC address [23:16]; bit[25]: byte 2 of the MAC address [15:8]; bit[24]: byte 1 of the MAC address [7:0].";
            sw = rw; hw = r;
            reset = 0x0;
        } mbc[29:24];
        field {
            name = "reserved";
            desc = "Reserved.";
            sw = r; hw = w;
            reset = 0x0;
        } reserved_23_16[23:16];
        field {
            name = "mac_addr_h16";
            desc = "A[47:32]: Contains the upper 16 bits [47:32] of the 6-byte MAC address, used for receive frame filtering and for transmitting pause frames.";
            sw = rw; hw = r;
            reset = 0xffff;
        } mac_addr_h16[15:0];
    } GMACN_ADDRY_HIGH_10 @ 0x850;
    reg {
        name = "GMACN_ADDRY_HIGH";
        desc = "GMACN_ADDRY_HIGH is the register for the upper 16 bits [47:32] of the Y-th (16 to 31) MAC address of GMACn (0 to 1). GMACN_ADDRY_HIGH (offset 0x0800+Yx0x8 (Y = 0~15), total reset 0x0000_FFFF; PROVEN: Hi3535 data sheet, PDF page 818, section 5.6). Registers for Y = 16..31 (offset 0x780 + n x 0x4000 + Y x 0x8; instances 0..15 below are Y = 16..31). Address registers 1-15 (X) and 16-31 (Y) of GMAC n sit at the formula offsets of the data sheet (0x40 + n x 0x4000 + X x 0x8 / 0x780 + n x 0x4000 + Y x 0x8); modelled for GMAC 0 as 15 resp. 16 instances, GMAC 1 is the same layout 0x4000 higher.";
        field {
            name = "ae";
            desc = "AE: address enable.
- 0: When this bit is 0, the address filter module ignores this MAC address;
- 1: When this bit is 1, the address filter module uses this MAC address for perfect filtering.";
            sw = rw; hw = r;
            reset = 0x0;
        } ae[31:31];
        field {
            name = "sa";
            desc = "SA: source address.
- 0: This MAC address is used for comparison with the DA of received frames.
- 1: This MAC address is used for comparison with the SA of received frames.";
            sw = rw; hw = r;
            reset = 0x0;
        } sa[30:30];
        field {
            name = "mbc";
            desc = "MBC: Mask byte control. These bits are the mask control bits for each byte of the MAC address. The meaning of each bit is as follows:
- 0: The GMAC uses this byte for address filtering.
- 1: The GMAC does not use this byte for address filtering. The MAC address byte corresponding to each bit is as follows: bit[29]: byte 6 of the MAC address [47:40]; bit[28]: byte 5 of the MAC address [39:32]; bit[27]: byte 4 of the MAC address [31:24]; bit[26]: byte 3 of the MAC address [23:16]; bit[25]: byte 2 of the MAC address [15:8]; bit[24]: byte 1 of the MAC address [7:0].";
            sw = rw; hw = r;
            reset = 0x0;
        } mbc[29:24];
        field {
            name = "reserved";
            desc = "Reserved.";
            sw = r; hw = w;
            reset = 0x0;
        } reserved_23_16[23:16];
        field {
            name = "mac_addr_h16";
            desc = "A[47:32]: Contains the upper 16 bits [47:32] of the 6-byte MAC address, used for receive frame filtering and for transmitting pause frames.";
            sw = rw; hw = r;
            reset = 0xffff;
        } mac_addr_h16[15:0];
    } GMACN_ADDRY_HIGH_11 @ 0x858;
    reg {
        name = "GMACN_ADDRY_HIGH";
        desc = "GMACN_ADDRY_HIGH is the register for the upper 16 bits [47:32] of the Y-th (16 to 31) MAC address of GMACn (0 to 1). GMACN_ADDRY_HIGH (offset 0x0800+Yx0x8 (Y = 0~15), total reset 0x0000_FFFF; PROVEN: Hi3535 data sheet, PDF page 818, section 5.6). Registers for Y = 16..31 (offset 0x780 + n x 0x4000 + Y x 0x8; instances 0..15 below are Y = 16..31). Address registers 1-15 (X) and 16-31 (Y) of GMAC n sit at the formula offsets of the data sheet (0x40 + n x 0x4000 + X x 0x8 / 0x780 + n x 0x4000 + Y x 0x8); modelled for GMAC 0 as 15 resp. 16 instances, GMAC 1 is the same layout 0x4000 higher.";
        field {
            name = "ae";
            desc = "AE: address enable.
- 0: When this bit is 0, the address filter module ignores this MAC address;
- 1: When this bit is 1, the address filter module uses this MAC address for perfect filtering.";
            sw = rw; hw = r;
            reset = 0x0;
        } ae[31:31];
        field {
            name = "sa";
            desc = "SA: source address.
- 0: This MAC address is used for comparison with the DA of received frames.
- 1: This MAC address is used for comparison with the SA of received frames.";
            sw = rw; hw = r;
            reset = 0x0;
        } sa[30:30];
        field {
            name = "mbc";
            desc = "MBC: Mask byte control. These bits are the mask control bits for each byte of the MAC address. The meaning of each bit is as follows:
- 0: The GMAC uses this byte for address filtering.
- 1: The GMAC does not use this byte for address filtering. The MAC address byte corresponding to each bit is as follows: bit[29]: byte 6 of the MAC address [47:40]; bit[28]: byte 5 of the MAC address [39:32]; bit[27]: byte 4 of the MAC address [31:24]; bit[26]: byte 3 of the MAC address [23:16]; bit[25]: byte 2 of the MAC address [15:8]; bit[24]: byte 1 of the MAC address [7:0].";
            sw = rw; hw = r;
            reset = 0x0;
        } mbc[29:24];
        field {
            name = "reserved";
            desc = "Reserved.";
            sw = r; hw = w;
            reset = 0x0;
        } reserved_23_16[23:16];
        field {
            name = "mac_addr_h16";
            desc = "A[47:32]: Contains the upper 16 bits [47:32] of the 6-byte MAC address, used for receive frame filtering and for transmitting pause frames.";
            sw = rw; hw = r;
            reset = 0xffff;
        } mac_addr_h16[15:0];
    } GMACN_ADDRY_HIGH_12 @ 0x860;
    reg {
        name = "GMACN_ADDRY_HIGH";
        desc = "GMACN_ADDRY_HIGH is the register for the upper 16 bits [47:32] of the Y-th (16 to 31) MAC address of GMACn (0 to 1). GMACN_ADDRY_HIGH (offset 0x0800+Yx0x8 (Y = 0~15), total reset 0x0000_FFFF; PROVEN: Hi3535 data sheet, PDF page 818, section 5.6). Registers for Y = 16..31 (offset 0x780 + n x 0x4000 + Y x 0x8; instances 0..15 below are Y = 16..31). Address registers 1-15 (X) and 16-31 (Y) of GMAC n sit at the formula offsets of the data sheet (0x40 + n x 0x4000 + X x 0x8 / 0x780 + n x 0x4000 + Y x 0x8); modelled for GMAC 0 as 15 resp. 16 instances, GMAC 1 is the same layout 0x4000 higher.";
        field {
            name = "ae";
            desc = "AE: address enable.
- 0: When this bit is 0, the address filter module ignores this MAC address;
- 1: When this bit is 1, the address filter module uses this MAC address for perfect filtering.";
            sw = rw; hw = r;
            reset = 0x0;
        } ae[31:31];
        field {
            name = "sa";
            desc = "SA: source address.
- 0: This MAC address is used for comparison with the DA of received frames.
- 1: This MAC address is used for comparison with the SA of received frames.";
            sw = rw; hw = r;
            reset = 0x0;
        } sa[30:30];
        field {
            name = "mbc";
            desc = "MBC: Mask byte control. These bits are the mask control bits for each byte of the MAC address. The meaning of each bit is as follows:
- 0: The GMAC uses this byte for address filtering.
- 1: The GMAC does not use this byte for address filtering. The MAC address byte corresponding to each bit is as follows: bit[29]: byte 6 of the MAC address [47:40]; bit[28]: byte 5 of the MAC address [39:32]; bit[27]: byte 4 of the MAC address [31:24]; bit[26]: byte 3 of the MAC address [23:16]; bit[25]: byte 2 of the MAC address [15:8]; bit[24]: byte 1 of the MAC address [7:0].";
            sw = rw; hw = r;
            reset = 0x0;
        } mbc[29:24];
        field {
            name = "reserved";
            desc = "Reserved.";
            sw = r; hw = w;
            reset = 0x0;
        } reserved_23_16[23:16];
        field {
            name = "mac_addr_h16";
            desc = "A[47:32]: Contains the upper 16 bits [47:32] of the 6-byte MAC address, used for receive frame filtering and for transmitting pause frames.";
            sw = rw; hw = r;
            reset = 0xffff;
        } mac_addr_h16[15:0];
    } GMACN_ADDRY_HIGH_13 @ 0x868;
    reg {
        name = "GMACN_ADDRY_HIGH";
        desc = "GMACN_ADDRY_HIGH is the register for the upper 16 bits [47:32] of the Y-th (16 to 31) MAC address of GMACn (0 to 1). GMACN_ADDRY_HIGH (offset 0x0800+Yx0x8 (Y = 0~15), total reset 0x0000_FFFF; PROVEN: Hi3535 data sheet, PDF page 818, section 5.6). Registers for Y = 16..31 (offset 0x780 + n x 0x4000 + Y x 0x8; instances 0..15 below are Y = 16..31). Address registers 1-15 (X) and 16-31 (Y) of GMAC n sit at the formula offsets of the data sheet (0x40 + n x 0x4000 + X x 0x8 / 0x780 + n x 0x4000 + Y x 0x8); modelled for GMAC 0 as 15 resp. 16 instances, GMAC 1 is the same layout 0x4000 higher.";
        field {
            name = "ae";
            desc = "AE: address enable.
- 0: When this bit is 0, the address filter module ignores this MAC address;
- 1: When this bit is 1, the address filter module uses this MAC address for perfect filtering.";
            sw = rw; hw = r;
            reset = 0x0;
        } ae[31:31];
        field {
            name = "sa";
            desc = "SA: source address.
- 0: This MAC address is used for comparison with the DA of received frames.
- 1: This MAC address is used for comparison with the SA of received frames.";
            sw = rw; hw = r;
            reset = 0x0;
        } sa[30:30];
        field {
            name = "mbc";
            desc = "MBC: Mask byte control. These bits are the mask control bits for each byte of the MAC address. The meaning of each bit is as follows:
- 0: The GMAC uses this byte for address filtering.
- 1: The GMAC does not use this byte for address filtering. The MAC address byte corresponding to each bit is as follows: bit[29]: byte 6 of the MAC address [47:40]; bit[28]: byte 5 of the MAC address [39:32]; bit[27]: byte 4 of the MAC address [31:24]; bit[26]: byte 3 of the MAC address [23:16]; bit[25]: byte 2 of the MAC address [15:8]; bit[24]: byte 1 of the MAC address [7:0].";
            sw = rw; hw = r;
            reset = 0x0;
        } mbc[29:24];
        field {
            name = "reserved";
            desc = "Reserved.";
            sw = r; hw = w;
            reset = 0x0;
        } reserved_23_16[23:16];
        field {
            name = "mac_addr_h16";
            desc = "A[47:32]: Contains the upper 16 bits [47:32] of the 6-byte MAC address, used for receive frame filtering and for transmitting pause frames.";
            sw = rw; hw = r;
            reset = 0xffff;
        } mac_addr_h16[15:0];
    } GMACN_ADDRY_HIGH_14 @ 0x870;
    reg {
        name = "GMACN_ADDRY_HIGH";
        desc = "GMACN_ADDRY_HIGH is the register for the upper 16 bits [47:32] of the Y-th (16 to 31) MAC address of GMACn (0 to 1). GMACN_ADDRY_HIGH (offset 0x0800+Yx0x8 (Y = 0~15), total reset 0x0000_FFFF; PROVEN: Hi3535 data sheet, PDF page 818, section 5.6). Registers for Y = 16..31 (offset 0x780 + n x 0x4000 + Y x 0x8; instances 0..15 below are Y = 16..31). Address registers 1-15 (X) and 16-31 (Y) of GMAC n sit at the formula offsets of the data sheet (0x40 + n x 0x4000 + X x 0x8 / 0x780 + n x 0x4000 + Y x 0x8); modelled for GMAC 0 as 15 resp. 16 instances, GMAC 1 is the same layout 0x4000 higher.";
        field {
            name = "ae";
            desc = "AE: address enable.
- 0: When this bit is 0, the address filter module ignores this MAC address;
- 1: When this bit is 1, the address filter module uses this MAC address for perfect filtering.";
            sw = rw; hw = r;
            reset = 0x0;
        } ae[31:31];
        field {
            name = "sa";
            desc = "SA: source address.
- 0: This MAC address is used for comparison with the DA of received frames.
- 1: This MAC address is used for comparison with the SA of received frames.";
            sw = rw; hw = r;
            reset = 0x0;
        } sa[30:30];
        field {
            name = "mbc";
            desc = "MBC: Mask byte control. These bits are the mask control bits for each byte of the MAC address. The meaning of each bit is as follows:
- 0: The GMAC uses this byte for address filtering.
- 1: The GMAC does not use this byte for address filtering. The MAC address byte corresponding to each bit is as follows: bit[29]: byte 6 of the MAC address [47:40]; bit[28]: byte 5 of the MAC address [39:32]; bit[27]: byte 4 of the MAC address [31:24]; bit[26]: byte 3 of the MAC address [23:16]; bit[25]: byte 2 of the MAC address [15:8]; bit[24]: byte 1 of the MAC address [7:0].";
            sw = rw; hw = r;
            reset = 0x0;
        } mbc[29:24];
        field {
            name = "reserved";
            desc = "Reserved.";
            sw = r; hw = w;
            reset = 0x0;
        } reserved_23_16[23:16];
        field {
            name = "mac_addr_h16";
            desc = "A[47:32]: Contains the upper 16 bits [47:32] of the 6-byte MAC address, used for receive frame filtering and for transmitting pause frames.";
            sw = rw; hw = r;
            reset = 0xffff;
        } mac_addr_h16[15:0];
    } GMACN_ADDRY_HIGH_15 @ 0x878;
    reg {
        name = "GMACN_ADDRY_LOW";
        desc = "GMACN_ADDRY_LOW is the register holding the lower 32 bits [31:0] of the Y-th (16 to 31) MAC address of GMACn (0 to 1). GMACN_ADDRY_LOW (offset 0x0804+Yx0x8 (Y = 0~15), total reset 0xFFFF_FFFF; PROVEN: Hi3535 data sheet, PDF page 819, section 5.6). Registers for Y = 16..31 (offset 0x784 + n x 0x4000 + Y x 0x8; instances 0..15 below are Y = 16..31). Address registers 1-15 (X) and 16-31 (Y) of GMAC n sit at the formula offsets of the data sheet (0x40 + n x 0x4000 + X x 0x8 / 0x780 + n x 0x4000 + Y x 0x8); modelled for GMAC 0 as 15 resp. 16 instances, GMAC 1 is the same layout 0x4000 higher.";
        field {
            name = "a_31_0";
            desc = "A[31:0]: Contains the lower 32 bits [31:0] of the 6-byte MAC address, used for receive frame filtering and for sending pause frames.";
            sw = rw; hw = r;
            reset = 0xffffffff;
        } a_31_0[31:0];
    } GMACN_ADDRY_LOW_0 @ 0x804;
    reg {
        name = "GMACN_ADDRY_LOW";
        desc = "GMACN_ADDRY_LOW is the register holding the lower 32 bits [31:0] of the Y-th (16 to 31) MAC address of GMACn (0 to 1). GMACN_ADDRY_LOW (offset 0x0804+Yx0x8 (Y = 0~15), total reset 0xFFFF_FFFF; PROVEN: Hi3535 data sheet, PDF page 819, section 5.6). Registers for Y = 16..31 (offset 0x784 + n x 0x4000 + Y x 0x8; instances 0..15 below are Y = 16..31). Address registers 1-15 (X) and 16-31 (Y) of GMAC n sit at the formula offsets of the data sheet (0x40 + n x 0x4000 + X x 0x8 / 0x780 + n x 0x4000 + Y x 0x8); modelled for GMAC 0 as 15 resp. 16 instances, GMAC 1 is the same layout 0x4000 higher.";
        field {
            name = "a_31_0";
            desc = "A[31:0]: Contains the lower 32 bits [31:0] of the 6-byte MAC address, used for receive frame filtering and for sending pause frames.";
            sw = rw; hw = r;
            reset = 0xffffffff;
        } a_31_0[31:0];
    } GMACN_ADDRY_LOW_1 @ 0x80c;
    reg {
        name = "GMACN_ADDRY_LOW";
        desc = "GMACN_ADDRY_LOW is the register holding the lower 32 bits [31:0] of the Y-th (16 to 31) MAC address of GMACn (0 to 1). GMACN_ADDRY_LOW (offset 0x0804+Yx0x8 (Y = 0~15), total reset 0xFFFF_FFFF; PROVEN: Hi3535 data sheet, PDF page 819, section 5.6). Registers for Y = 16..31 (offset 0x784 + n x 0x4000 + Y x 0x8; instances 0..15 below are Y = 16..31). Address registers 1-15 (X) and 16-31 (Y) of GMAC n sit at the formula offsets of the data sheet (0x40 + n x 0x4000 + X x 0x8 / 0x780 + n x 0x4000 + Y x 0x8); modelled for GMAC 0 as 15 resp. 16 instances, GMAC 1 is the same layout 0x4000 higher.";
        field {
            name = "a_31_0";
            desc = "A[31:0]: Contains the lower 32 bits [31:0] of the 6-byte MAC address, used for receive frame filtering and for sending pause frames.";
            sw = rw; hw = r;
            reset = 0xffffffff;
        } a_31_0[31:0];
    } GMACN_ADDRY_LOW_2 @ 0x814;
    reg {
        name = "GMACN_ADDRY_LOW";
        desc = "GMACN_ADDRY_LOW is the register holding the lower 32 bits [31:0] of the Y-th (16 to 31) MAC address of GMACn (0 to 1). GMACN_ADDRY_LOW (offset 0x0804+Yx0x8 (Y = 0~15), total reset 0xFFFF_FFFF; PROVEN: Hi3535 data sheet, PDF page 819, section 5.6). Registers for Y = 16..31 (offset 0x784 + n x 0x4000 + Y x 0x8; instances 0..15 below are Y = 16..31). Address registers 1-15 (X) and 16-31 (Y) of GMAC n sit at the formula offsets of the data sheet (0x40 + n x 0x4000 + X x 0x8 / 0x780 + n x 0x4000 + Y x 0x8); modelled for GMAC 0 as 15 resp. 16 instances, GMAC 1 is the same layout 0x4000 higher.";
        field {
            name = "a_31_0";
            desc = "A[31:0]: Contains the lower 32 bits [31:0] of the 6-byte MAC address, used for receive frame filtering and for sending pause frames.";
            sw = rw; hw = r;
            reset = 0xffffffff;
        } a_31_0[31:0];
    } GMACN_ADDRY_LOW_3 @ 0x81c;
    reg {
        name = "GMACN_ADDRY_LOW";
        desc = "GMACN_ADDRY_LOW is the register holding the lower 32 bits [31:0] of the Y-th (16 to 31) MAC address of GMACn (0 to 1). GMACN_ADDRY_LOW (offset 0x0804+Yx0x8 (Y = 0~15), total reset 0xFFFF_FFFF; PROVEN: Hi3535 data sheet, PDF page 819, section 5.6). Registers for Y = 16..31 (offset 0x784 + n x 0x4000 + Y x 0x8; instances 0..15 below are Y = 16..31). Address registers 1-15 (X) and 16-31 (Y) of GMAC n sit at the formula offsets of the data sheet (0x40 + n x 0x4000 + X x 0x8 / 0x780 + n x 0x4000 + Y x 0x8); modelled for GMAC 0 as 15 resp. 16 instances, GMAC 1 is the same layout 0x4000 higher.";
        field {
            name = "a_31_0";
            desc = "A[31:0]: Contains the lower 32 bits [31:0] of the 6-byte MAC address, used for receive frame filtering and for sending pause frames.";
            sw = rw; hw = r;
            reset = 0xffffffff;
        } a_31_0[31:0];
    } GMACN_ADDRY_LOW_4 @ 0x824;
    reg {
        name = "GMACN_ADDRY_LOW";
        desc = "GMACN_ADDRY_LOW is the register holding the lower 32 bits [31:0] of the Y-th (16 to 31) MAC address of GMACn (0 to 1). GMACN_ADDRY_LOW (offset 0x0804+Yx0x8 (Y = 0~15), total reset 0xFFFF_FFFF; PROVEN: Hi3535 data sheet, PDF page 819, section 5.6). Registers for Y = 16..31 (offset 0x784 + n x 0x4000 + Y x 0x8; instances 0..15 below are Y = 16..31). Address registers 1-15 (X) and 16-31 (Y) of GMAC n sit at the formula offsets of the data sheet (0x40 + n x 0x4000 + X x 0x8 / 0x780 + n x 0x4000 + Y x 0x8); modelled for GMAC 0 as 15 resp. 16 instances, GMAC 1 is the same layout 0x4000 higher.";
        field {
            name = "a_31_0";
            desc = "A[31:0]: Contains the lower 32 bits [31:0] of the 6-byte MAC address, used for receive frame filtering and for sending pause frames.";
            sw = rw; hw = r;
            reset = 0xffffffff;
        } a_31_0[31:0];
    } GMACN_ADDRY_LOW_5 @ 0x82c;
    reg {
        name = "GMACN_ADDRY_LOW";
        desc = "GMACN_ADDRY_LOW is the register holding the lower 32 bits [31:0] of the Y-th (16 to 31) MAC address of GMACn (0 to 1). GMACN_ADDRY_LOW (offset 0x0804+Yx0x8 (Y = 0~15), total reset 0xFFFF_FFFF; PROVEN: Hi3535 data sheet, PDF page 819, section 5.6). Registers for Y = 16..31 (offset 0x784 + n x 0x4000 + Y x 0x8; instances 0..15 below are Y = 16..31). Address registers 1-15 (X) and 16-31 (Y) of GMAC n sit at the formula offsets of the data sheet (0x40 + n x 0x4000 + X x 0x8 / 0x780 + n x 0x4000 + Y x 0x8); modelled for GMAC 0 as 15 resp. 16 instances, GMAC 1 is the same layout 0x4000 higher.";
        field {
            name = "a_31_0";
            desc = "A[31:0]: Contains the lower 32 bits [31:0] of the 6-byte MAC address, used for receive frame filtering and for sending pause frames.";
            sw = rw; hw = r;
            reset = 0xffffffff;
        } a_31_0[31:0];
    } GMACN_ADDRY_LOW_6 @ 0x834;
    reg {
        name = "GMACN_ADDRY_LOW";
        desc = "GMACN_ADDRY_LOW is the register holding the lower 32 bits [31:0] of the Y-th (16 to 31) MAC address of GMACn (0 to 1). GMACN_ADDRY_LOW (offset 0x0804+Yx0x8 (Y = 0~15), total reset 0xFFFF_FFFF; PROVEN: Hi3535 data sheet, PDF page 819, section 5.6). Registers for Y = 16..31 (offset 0x784 + n x 0x4000 + Y x 0x8; instances 0..15 below are Y = 16..31). Address registers 1-15 (X) and 16-31 (Y) of GMAC n sit at the formula offsets of the data sheet (0x40 + n x 0x4000 + X x 0x8 / 0x780 + n x 0x4000 + Y x 0x8); modelled for GMAC 0 as 15 resp. 16 instances, GMAC 1 is the same layout 0x4000 higher.";
        field {
            name = "a_31_0";
            desc = "A[31:0]: Contains the lower 32 bits [31:0] of the 6-byte MAC address, used for receive frame filtering and for sending pause frames.";
            sw = rw; hw = r;
            reset = 0xffffffff;
        } a_31_0[31:0];
    } GMACN_ADDRY_LOW_7 @ 0x83c;
    reg {
        name = "GMACN_ADDRY_LOW";
        desc = "GMACN_ADDRY_LOW is the register holding the lower 32 bits [31:0] of the Y-th (16 to 31) MAC address of GMACn (0 to 1). GMACN_ADDRY_LOW (offset 0x0804+Yx0x8 (Y = 0~15), total reset 0xFFFF_FFFF; PROVEN: Hi3535 data sheet, PDF page 819, section 5.6). Registers for Y = 16..31 (offset 0x784 + n x 0x4000 + Y x 0x8; instances 0..15 below are Y = 16..31). Address registers 1-15 (X) and 16-31 (Y) of GMAC n sit at the formula offsets of the data sheet (0x40 + n x 0x4000 + X x 0x8 / 0x780 + n x 0x4000 + Y x 0x8); modelled for GMAC 0 as 15 resp. 16 instances, GMAC 1 is the same layout 0x4000 higher.";
        field {
            name = "a_31_0";
            desc = "A[31:0]: Contains the lower 32 bits [31:0] of the 6-byte MAC address, used for receive frame filtering and for sending pause frames.";
            sw = rw; hw = r;
            reset = 0xffffffff;
        } a_31_0[31:0];
    } GMACN_ADDRY_LOW_8 @ 0x844;
    reg {
        name = "GMACN_ADDRY_LOW";
        desc = "GMACN_ADDRY_LOW is the register holding the lower 32 bits [31:0] of the Y-th (16 to 31) MAC address of GMACn (0 to 1). GMACN_ADDRY_LOW (offset 0x0804+Yx0x8 (Y = 0~15), total reset 0xFFFF_FFFF; PROVEN: Hi3535 data sheet, PDF page 819, section 5.6). Registers for Y = 16..31 (offset 0x784 + n x 0x4000 + Y x 0x8; instances 0..15 below are Y = 16..31). Address registers 1-15 (X) and 16-31 (Y) of GMAC n sit at the formula offsets of the data sheet (0x40 + n x 0x4000 + X x 0x8 / 0x780 + n x 0x4000 + Y x 0x8); modelled for GMAC 0 as 15 resp. 16 instances, GMAC 1 is the same layout 0x4000 higher.";
        field {
            name = "a_31_0";
            desc = "A[31:0]: Contains the lower 32 bits [31:0] of the 6-byte MAC address, used for receive frame filtering and for sending pause frames.";
            sw = rw; hw = r;
            reset = 0xffffffff;
        } a_31_0[31:0];
    } GMACN_ADDRY_LOW_9 @ 0x84c;
    reg {
        name = "GMACN_ADDRY_LOW";
        desc = "GMACN_ADDRY_LOW is the register holding the lower 32 bits [31:0] of the Y-th (16 to 31) MAC address of GMACn (0 to 1). GMACN_ADDRY_LOW (offset 0x0804+Yx0x8 (Y = 0~15), total reset 0xFFFF_FFFF; PROVEN: Hi3535 data sheet, PDF page 819, section 5.6). Registers for Y = 16..31 (offset 0x784 + n x 0x4000 + Y x 0x8; instances 0..15 below are Y = 16..31). Address registers 1-15 (X) and 16-31 (Y) of GMAC n sit at the formula offsets of the data sheet (0x40 + n x 0x4000 + X x 0x8 / 0x780 + n x 0x4000 + Y x 0x8); modelled for GMAC 0 as 15 resp. 16 instances, GMAC 1 is the same layout 0x4000 higher.";
        field {
            name = "a_31_0";
            desc = "A[31:0]: Contains the lower 32 bits [31:0] of the 6-byte MAC address, used for receive frame filtering and for sending pause frames.";
            sw = rw; hw = r;
            reset = 0xffffffff;
        } a_31_0[31:0];
    } GMACN_ADDRY_LOW_10 @ 0x854;
    reg {
        name = "GMACN_ADDRY_LOW";
        desc = "GMACN_ADDRY_LOW is the register holding the lower 32 bits [31:0] of the Y-th (16 to 31) MAC address of GMACn (0 to 1). GMACN_ADDRY_LOW (offset 0x0804+Yx0x8 (Y = 0~15), total reset 0xFFFF_FFFF; PROVEN: Hi3535 data sheet, PDF page 819, section 5.6). Registers for Y = 16..31 (offset 0x784 + n x 0x4000 + Y x 0x8; instances 0..15 below are Y = 16..31). Address registers 1-15 (X) and 16-31 (Y) of GMAC n sit at the formula offsets of the data sheet (0x40 + n x 0x4000 + X x 0x8 / 0x780 + n x 0x4000 + Y x 0x8); modelled for GMAC 0 as 15 resp. 16 instances, GMAC 1 is the same layout 0x4000 higher.";
        field {
            name = "a_31_0";
            desc = "A[31:0]: Contains the lower 32 bits [31:0] of the 6-byte MAC address, used for receive frame filtering and for sending pause frames.";
            sw = rw; hw = r;
            reset = 0xffffffff;
        } a_31_0[31:0];
    } GMACN_ADDRY_LOW_11 @ 0x85c;
    reg {
        name = "GMACN_ADDRY_LOW";
        desc = "GMACN_ADDRY_LOW is the register holding the lower 32 bits [31:0] of the Y-th (16 to 31) MAC address of GMACn (0 to 1). GMACN_ADDRY_LOW (offset 0x0804+Yx0x8 (Y = 0~15), total reset 0xFFFF_FFFF; PROVEN: Hi3535 data sheet, PDF page 819, section 5.6). Registers for Y = 16..31 (offset 0x784 + n x 0x4000 + Y x 0x8; instances 0..15 below are Y = 16..31). Address registers 1-15 (X) and 16-31 (Y) of GMAC n sit at the formula offsets of the data sheet (0x40 + n x 0x4000 + X x 0x8 / 0x780 + n x 0x4000 + Y x 0x8); modelled for GMAC 0 as 15 resp. 16 instances, GMAC 1 is the same layout 0x4000 higher.";
        field {
            name = "a_31_0";
            desc = "A[31:0]: Contains the lower 32 bits [31:0] of the 6-byte MAC address, used for receive frame filtering and for sending pause frames.";
            sw = rw; hw = r;
            reset = 0xffffffff;
        } a_31_0[31:0];
    } GMACN_ADDRY_LOW_12 @ 0x864;
    reg {
        name = "GMACN_ADDRY_LOW";
        desc = "GMACN_ADDRY_LOW is the register holding the lower 32 bits [31:0] of the Y-th (16 to 31) MAC address of GMACn (0 to 1). GMACN_ADDRY_LOW (offset 0x0804+Yx0x8 (Y = 0~15), total reset 0xFFFF_FFFF; PROVEN: Hi3535 data sheet, PDF page 819, section 5.6). Registers for Y = 16..31 (offset 0x784 + n x 0x4000 + Y x 0x8; instances 0..15 below are Y = 16..31). Address registers 1-15 (X) and 16-31 (Y) of GMAC n sit at the formula offsets of the data sheet (0x40 + n x 0x4000 + X x 0x8 / 0x780 + n x 0x4000 + Y x 0x8); modelled for GMAC 0 as 15 resp. 16 instances, GMAC 1 is the same layout 0x4000 higher.";
        field {
            name = "a_31_0";
            desc = "A[31:0]: Contains the lower 32 bits [31:0] of the 6-byte MAC address, used for receive frame filtering and for sending pause frames.";
            sw = rw; hw = r;
            reset = 0xffffffff;
        } a_31_0[31:0];
    } GMACN_ADDRY_LOW_13 @ 0x86c;
    reg {
        name = "GMACN_ADDRY_LOW";
        desc = "GMACN_ADDRY_LOW is the register holding the lower 32 bits [31:0] of the Y-th (16 to 31) MAC address of GMACn (0 to 1). GMACN_ADDRY_LOW (offset 0x0804+Yx0x8 (Y = 0~15), total reset 0xFFFF_FFFF; PROVEN: Hi3535 data sheet, PDF page 819, section 5.6). Registers for Y = 16..31 (offset 0x784 + n x 0x4000 + Y x 0x8; instances 0..15 below are Y = 16..31). Address registers 1-15 (X) and 16-31 (Y) of GMAC n sit at the formula offsets of the data sheet (0x40 + n x 0x4000 + X x 0x8 / 0x780 + n x 0x4000 + Y x 0x8); modelled for GMAC 0 as 15 resp. 16 instances, GMAC 1 is the same layout 0x4000 higher.";
        field {
            name = "a_31_0";
            desc = "A[31:0]: Contains the lower 32 bits [31:0] of the 6-byte MAC address, used for receive frame filtering and for sending pause frames.";
            sw = rw; hw = r;
            reset = 0xffffffff;
        } a_31_0[31:0];
    } GMACN_ADDRY_LOW_14 @ 0x874;
    reg {
        name = "GMACN_ADDRY_LOW";
        desc = "GMACN_ADDRY_LOW is the register holding the lower 32 bits [31:0] of the Y-th (16 to 31) MAC address of GMACn (0 to 1). GMACN_ADDRY_LOW (offset 0x0804+Yx0x8 (Y = 0~15), total reset 0xFFFF_FFFF; PROVEN: Hi3535 data sheet, PDF page 819, section 5.6). Registers for Y = 16..31 (offset 0x784 + n x 0x4000 + Y x 0x8; instances 0..15 below are Y = 16..31). Address registers 1-15 (X) and 16-31 (Y) of GMAC n sit at the formula offsets of the data sheet (0x40 + n x 0x4000 + X x 0x8 / 0x780 + n x 0x4000 + Y x 0x8); modelled for GMAC 0 as 15 resp. 16 instances, GMAC 1 is the same layout 0x4000 higher.";
        field {
            name = "a_31_0";
            desc = "A[31:0]: Contains the lower 32 bits [31:0] of the 6-byte MAC address, used for receive frame filtering and for sending pause frames.";
            sw = rw; hw = r;
            reset = 0xffffffff;
        } a_31_0[31:0];
    } GMACN_ADDRY_LOW_15 @ 0x87c;
    reg {
        name = "DMAP_BUS_MODE";
        desc = "DMAP_BUS_MODE is the bus mode register. It specifies the bus operation mode of DMAp (0 to 2). DMAP_BUS_MODE (offset 0x1000+Px0x100 (P = 0~2), total reset 0x0002_0101; PROVEN: Hi3535 data sheet, PDF page 842, section 5.6).";
        field {
            name = "reserved";
            desc = "Reserved.";
            sw = r; hw = w;
            reset = 0x0;
        } reserved_31_26[31:26];
        field {
            name = "aal";
            desc = "AAL: address-aligned beats.
- 0: Beats are not address-aligned;
- 1: Beats are address-aligned. When FB is 1, the AXI interface generates all addresses aligned to the start address LS burst; if FB is 0, the first address burst generated by the AXI interface is not aligned, but all subsequent addresses are aligned to the first address burst.";
            sw = rw; hw = r;
            reset = 0x0;
        } aal[25:25];
        field {
            name = "pblx8";
            desc = "pblx8: 8xPBL mode.
- 0: Not 8xPBL mode.
- 1: 8xPBL mode. When this bit is 1, the PBL value is determined by 8 times the product of bits [22:17] and bits [13:8]. The possible DMA transfers then include 8, 16, 32, 64, 128, and 256 burst operations.";
            sw = rw; hw = r;
            reset = 0x0;
        } pblx8[24:24];
        field {
            name = "usp";
            desc = "USP: use separate PBL.
- 0: Do not use separate PBL. TxDMA and RxDMA use bits [13:8] as the PBL;
- 1: Use separate PBL. Bits [22:17] are used as the RxDMA PBL and bits [13:8] are used as the TxDMA PBL.";
            sw = rw; hw = r;
            reset = 0x0;
        } usp[23:23];
        field {
            name = "rpbl";
            desc = "RPBL: RxDMA PBL. Indicates the maximum number of beats in a single RxDMA transaction, that is, the maximum burst length of a single block read or write operation. Each RxDMA burst always attempts to use the value determined by PBL. The selectable values are 1, 2, 4, 8, 16, and 32; other values may cause undefined behavior. When USP is set to 1, RxPBL is used only for RxDMA operations.";
            sw = rw; hw = r;
            reset = 0x1;
        } rpbl[22:17];
        field {
            name = "fb";
            desc = "FB: fixed burst mode. This bit controls whether the AXI master uses fixed burst mode.
- 0: Fixed burst mode is not used. The AXI can then use SINGLE or INCR burst operations;
- 1: Fixed burst mode is used.";
            sw = rw; hw = r;
            reset = 0x0;
        } fb[16:16];
        field {
            name = "reserved";
            desc = "Reserved.";
            sw = r; hw = w;
            reset = 0x0;
        } reserved_15_14[15:14];
        field {
            name = "pbl";
            desc = "PBL: programmable burst length. Indicates the maximum number of beats in a single DMA transaction, that is, the maximum burst length of a single module read or write operation. Each DMA burst always tries to execute with the value determined by PBL. The selectable values are 1, 2, 4, 8, 16 and 32; other values may cause undefined behavior. When USP is set to 1, PBL applies only to TxDMA operation. If operations longer than 32 bursts are needed, set 8xpbl. For example, for a 64-burst operation, set 8xpbl to 1 and pbl to 8.";
            sw = rw; hw = r;
            reset = 0x1;
        } pbl[13:8];
        field {
            name = "reserved";
            desc = "Reserved.";
            sw = r; hw = w;
            reset = 0x0;
        } reserved_7_7[7:7];
        field {
            name = "dsl";
            desc = "DSL: descriptor skip length. This field determines the number of words to skip between two non-chained descriptors. The length starts at the first byte of the current descriptor and ends at the first byte of the next adjacent descriptor. If the value is 0, ring mode is assumed.";
            sw = rw; hw = r;
            reset = 0x0;
        } dsl[6:2];
        field {
            name = "reserved";
            desc = "Reserved.";
            sw = r; hw = w;
            reset = 0x0;
        } reserved_1_1[1:1];
        field {
            name = "swr";
            desc = "SWR: soft reset.
- 0: Do not perform a soft reset;
- 1: Perform a soft reset. During a soft reset, the DMA controller resets the entire GMAC registers and logic. This bit is cleared automatically when the reset completes. No register may be written before the reset completes. (data sheet access type RWSC)";
            sw = rw; hw = r;
            reset = 0x1;
        } swr[0:0];
    } DMAP_BUS_MODE_0 @ 0x1000;
    reg {
        name = "DMAP_BUS_MODE";
        desc = "DMAP_BUS_MODE is the bus mode register. It specifies the bus operation mode of DMAp (0 to 2). DMAP_BUS_MODE (offset 0x1000+Px0x100 (P = 0~2), total reset 0x0002_0101; PROVEN: Hi3535 data sheet, PDF page 842, section 5.6).";
        field {
            name = "reserved";
            desc = "Reserved.";
            sw = r; hw = w;
            reset = 0x0;
        } reserved_31_26[31:26];
        field {
            name = "aal";
            desc = "AAL: address-aligned beats.
- 0: Beats are not address-aligned;
- 1: Beats are address-aligned. When FB is 1, the AXI interface generates all addresses aligned to the start address LS burst; if FB is 0, the first address burst generated by the AXI interface is not aligned, but all subsequent addresses are aligned to the first address burst.";
            sw = rw; hw = r;
            reset = 0x0;
        } aal[25:25];
        field {
            name = "pblx8";
            desc = "pblx8: 8xPBL mode.
- 0: Not 8xPBL mode.
- 1: 8xPBL mode. When this bit is 1, the PBL value is determined by 8 times the product of bits [22:17] and bits [13:8]. The possible DMA transfers then include 8, 16, 32, 64, 128, and 256 burst operations.";
            sw = rw; hw = r;
            reset = 0x0;
        } pblx8[24:24];
        field {
            name = "usp";
            desc = "USP: use separate PBL.
- 0: Do not use separate PBL. TxDMA and RxDMA use bits [13:8] as the PBL;
- 1: Use separate PBL. Bits [22:17] are used as the RxDMA PBL and bits [13:8] are used as the TxDMA PBL.";
            sw = rw; hw = r;
            reset = 0x0;
        } usp[23:23];
        field {
            name = "rpbl";
            desc = "RPBL: RxDMA PBL. Indicates the maximum number of beats in a single RxDMA transaction, that is, the maximum burst length of a single block read or write operation. Each RxDMA burst always attempts to use the value determined by PBL. The selectable values are 1, 2, 4, 8, 16, and 32; other values may cause undefined behavior. When USP is set to 1, RxPBL is used only for RxDMA operations.";
            sw = rw; hw = r;
            reset = 0x1;
        } rpbl[22:17];
        field {
            name = "fb";
            desc = "FB: fixed burst mode. This bit controls whether the AXI master uses fixed burst mode.
- 0: Fixed burst mode is not used. The AXI can then use SINGLE or INCR burst operations;
- 1: Fixed burst mode is used.";
            sw = rw; hw = r;
            reset = 0x0;
        } fb[16:16];
        field {
            name = "reserved";
            desc = "Reserved.";
            sw = r; hw = w;
            reset = 0x0;
        } reserved_15_14[15:14];
        field {
            name = "pbl";
            desc = "PBL: programmable burst length. Indicates the maximum number of beats in a single DMA transaction, that is, the maximum burst length of a single module read or write operation. Each DMA burst always tries to execute with the value determined by PBL. The selectable values are 1, 2, 4, 8, 16 and 32; other values may cause undefined behavior. When USP is set to 1, PBL applies only to TxDMA operation. If operations longer than 32 bursts are needed, set 8xpbl. For example, for a 64-burst operation, set 8xpbl to 1 and pbl to 8.";
            sw = rw; hw = r;
            reset = 0x1;
        } pbl[13:8];
        field {
            name = "reserved";
            desc = "Reserved.";
            sw = r; hw = w;
            reset = 0x0;
        } reserved_7_7[7:7];
        field {
            name = "dsl";
            desc = "DSL: descriptor skip length. This field determines the number of words to skip between two non-chained descriptors. The length starts at the first byte of the current descriptor and ends at the first byte of the next adjacent descriptor. If the value is 0, ring mode is assumed.";
            sw = rw; hw = r;
            reset = 0x0;
        } dsl[6:2];
        field {
            name = "reserved";
            desc = "Reserved.";
            sw = r; hw = w;
            reset = 0x0;
        } reserved_1_1[1:1];
        field {
            name = "swr";
            desc = "SWR: soft reset.
- 0: Do not perform a soft reset;
- 1: Perform a soft reset. During a soft reset, the DMA controller resets the entire GMAC registers and logic. This bit is cleared automatically when the reset completes. No register may be written before the reset completes. (data sheet access type RWSC)";
            sw = rw; hw = r;
            reset = 0x1;
        } swr[0:0];
    } DMAP_BUS_MODE_1 @ 0x1100;
    reg {
        name = "DMAP_BUS_MODE";
        desc = "DMAP_BUS_MODE is the bus mode register. It specifies the bus operation mode of DMAp (0 to 2). DMAP_BUS_MODE (offset 0x1000+Px0x100 (P = 0~2), total reset 0x0002_0101; PROVEN: Hi3535 data sheet, PDF page 842, section 5.6).";
        field {
            name = "reserved";
            desc = "Reserved.";
            sw = r; hw = w;
            reset = 0x0;
        } reserved_31_26[31:26];
        field {
            name = "aal";
            desc = "AAL: address-aligned beats.
- 0: Beats are not address-aligned;
- 1: Beats are address-aligned. When FB is 1, the AXI interface generates all addresses aligned to the start address LS burst; if FB is 0, the first address burst generated by the AXI interface is not aligned, but all subsequent addresses are aligned to the first address burst.";
            sw = rw; hw = r;
            reset = 0x0;
        } aal[25:25];
        field {
            name = "pblx8";
            desc = "pblx8: 8xPBL mode.
- 0: Not 8xPBL mode.
- 1: 8xPBL mode. When this bit is 1, the PBL value is determined by 8 times the product of bits [22:17] and bits [13:8]. The possible DMA transfers then include 8, 16, 32, 64, 128, and 256 burst operations.";
            sw = rw; hw = r;
            reset = 0x0;
        } pblx8[24:24];
        field {
            name = "usp";
            desc = "USP: use separate PBL.
- 0: Do not use separate PBL. TxDMA and RxDMA use bits [13:8] as the PBL;
- 1: Use separate PBL. Bits [22:17] are used as the RxDMA PBL and bits [13:8] are used as the TxDMA PBL.";
            sw = rw; hw = r;
            reset = 0x0;
        } usp[23:23];
        field {
            name = "rpbl";
            desc = "RPBL: RxDMA PBL. Indicates the maximum number of beats in a single RxDMA transaction, that is, the maximum burst length of a single block read or write operation. Each RxDMA burst always attempts to use the value determined by PBL. The selectable values are 1, 2, 4, 8, 16, and 32; other values may cause undefined behavior. When USP is set to 1, RxPBL is used only for RxDMA operations.";
            sw = rw; hw = r;
            reset = 0x1;
        } rpbl[22:17];
        field {
            name = "fb";
            desc = "FB: fixed burst mode. This bit controls whether the AXI master uses fixed burst mode.
- 0: Fixed burst mode is not used. The AXI can then use SINGLE or INCR burst operations;
- 1: Fixed burst mode is used.";
            sw = rw; hw = r;
            reset = 0x0;
        } fb[16:16];
        field {
            name = "reserved";
            desc = "Reserved.";
            sw = r; hw = w;
            reset = 0x0;
        } reserved_15_14[15:14];
        field {
            name = "pbl";
            desc = "PBL: programmable burst length. Indicates the maximum number of beats in a single DMA transaction, that is, the maximum burst length of a single module read or write operation. Each DMA burst always tries to execute with the value determined by PBL. The selectable values are 1, 2, 4, 8, 16 and 32; other values may cause undefined behavior. When USP is set to 1, PBL applies only to TxDMA operation. If operations longer than 32 bursts are needed, set 8xpbl. For example, for a 64-burst operation, set 8xpbl to 1 and pbl to 8.";
            sw = rw; hw = r;
            reset = 0x1;
        } pbl[13:8];
        field {
            name = "reserved";
            desc = "Reserved.";
            sw = r; hw = w;
            reset = 0x0;
        } reserved_7_7[7:7];
        field {
            name = "dsl";
            desc = "DSL: descriptor skip length. This field determines the number of words to skip between two non-chained descriptors. The length starts at the first byte of the current descriptor and ends at the first byte of the next adjacent descriptor. If the value is 0, ring mode is assumed.";
            sw = rw; hw = r;
            reset = 0x0;
        } dsl[6:2];
        field {
            name = "reserved";
            desc = "Reserved.";
            sw = r; hw = w;
            reset = 0x0;
        } reserved_1_1[1:1];
        field {
            name = "swr";
            desc = "SWR: soft reset.
- 0: Do not perform a soft reset;
- 1: Perform a soft reset. During a soft reset, the DMA controller resets the entire GMAC registers and logic. This bit is cleared automatically when the reset completes. No register may be written before the reset completes. (data sheet access type RWSC)";
            sw = rw; hw = r;
            reset = 0x1;
        } swr[0:0];
    } DMAP_BUS_MODE_2 @ 0x1200;
    reg {
        name = "DMAP_XMT_POLL_DEMAND";
        desc = "DMAP_XMT_POLL_DEMAND is the transmit poll demand register. It enables the TxDMA to check whether the current descriptor belongs to the DMA. This command wakes up a TxDMA in the suspended state. The TxDMA usually enters the suspended state because of a FIFO underflow or no available transmit descriptor. Once the TxDMA starts fetching descriptors from host memory again, this register can be written at any time. DMAP_XMT_POLL_DEMAND (offset 0x1004+Px0x100 (P = 0~2), total reset 0x0000_0000; PROVEN: Hi3535 data sheet, PDF page 844, section 5.6).";
        field {
            name = "tpd";
            desc = "TPD: transmit poll demand. When any value is written to this register, the DMA reads the current transmit descriptor address. If the current descriptor is unavailable (own bit is 0), the transmit state machine enters the suspended state; otherwise, if the current descriptor is available, the transmit state machine resumes. (data sheet access type ROWT)";
            sw = rw; hw = r;
            reset = 0x0;
        } tpd[31:0];
    } DMAP_XMT_POLL_DEMAND_0 @ 0x1004;
    reg {
        name = "DMAP_XMT_POLL_DEMAND";
        desc = "DMAP_XMT_POLL_DEMAND is the transmit poll demand register. It enables the TxDMA to check whether the current descriptor belongs to the DMA. This command wakes up a TxDMA in the suspended state. The TxDMA usually enters the suspended state because of a FIFO underflow or no available transmit descriptor. Once the TxDMA starts fetching descriptors from host memory again, this register can be written at any time. DMAP_XMT_POLL_DEMAND (offset 0x1004+Px0x100 (P = 0~2), total reset 0x0000_0000; PROVEN: Hi3535 data sheet, PDF page 844, section 5.6).";
        field {
            name = "tpd";
            desc = "TPD: transmit poll demand. When any value is written to this register, the DMA reads the current transmit descriptor address. If the current descriptor is unavailable (own bit is 0), the transmit state machine enters the suspended state; otherwise, if the current descriptor is available, the transmit state machine resumes. (data sheet access type ROWT)";
            sw = rw; hw = r;
            reset = 0x0;
        } tpd[31:0];
    } DMAP_XMT_POLL_DEMAND_1 @ 0x1104;
    reg {
        name = "DMAP_XMT_POLL_DEMAND";
        desc = "DMAP_XMT_POLL_DEMAND is the transmit poll demand register. It enables the TxDMA to check whether the current descriptor belongs to the DMA. This command wakes up a TxDMA in the suspended state. The TxDMA usually enters the suspended state because of a FIFO underflow or no available transmit descriptor. Once the TxDMA starts fetching descriptors from host memory again, this register can be written at any time. DMAP_XMT_POLL_DEMAND (offset 0x1004+Px0x100 (P = 0~2), total reset 0x0000_0000; PROVEN: Hi3535 data sheet, PDF page 844, section 5.6).";
        field {
            name = "tpd";
            desc = "TPD: transmit poll demand. When any value is written to this register, the DMA reads the current transmit descriptor address. If the current descriptor is unavailable (own bit is 0), the transmit state machine enters the suspended state; otherwise, if the current descriptor is available, the transmit state machine resumes. (data sheet access type ROWT)";
            sw = rw; hw = r;
            reset = 0x0;
        } tpd[31:0];
    } DMAP_XMT_POLL_DEMAND_2 @ 0x1204;
    reg {
        name = "DMAP_RCV_POLL_DEMAND";
        desc = "DMAP_RCV_POLL_DEMAND is the receive poll demand register. Enables the RxDMA to check whether the current descriptor belongs to the DMA. This command is used to wake up an RxDMA in the suspended state. The RxDMA normally enters the suspended state due to FIFO underflow or no available receive descriptor. DMAP_RCV_POLL_DEMAND (offset 0x1008+Px0x100 (P = 0~2), total reset 0x0000_0000; PROVEN: Hi3535 data sheet, PDF page 845, section 5.6).";
        field {
            name = "rpd";
            desc = "RPD: receive poll demand. When any value is written to this register, the DMA reads the current receive descriptor address. If the current descriptor is unavailable (own bit is 0), the receive state machine enters the suspended state; otherwise, if the current descriptor is available, the receive state machine enters the active state. (data sheet access type ROWT)";
            sw = rw; hw = r;
            reset = 0x0;
        } rpd[31:0];
    } DMAP_RCV_POLL_DEMAND_0 @ 0x1008;
    reg {
        name = "DMAP_RCV_POLL_DEMAND";
        desc = "DMAP_RCV_POLL_DEMAND is the receive poll demand register. Enables the RxDMA to check whether the current descriptor belongs to the DMA. This command is used to wake up an RxDMA in the suspended state. The RxDMA normally enters the suspended state due to FIFO underflow or no available receive descriptor. DMAP_RCV_POLL_DEMAND (offset 0x1008+Px0x100 (P = 0~2), total reset 0x0000_0000; PROVEN: Hi3535 data sheet, PDF page 845, section 5.6).";
        field {
            name = "rpd";
            desc = "RPD: receive poll demand. When any value is written to this register, the DMA reads the current receive descriptor address. If the current descriptor is unavailable (own bit is 0), the receive state machine enters the suspended state; otherwise, if the current descriptor is available, the receive state machine enters the active state. (data sheet access type ROWT)";
            sw = rw; hw = r;
            reset = 0x0;
        } rpd[31:0];
    } DMAP_RCV_POLL_DEMAND_1 @ 0x1108;
    reg {
        name = "DMAP_RCV_POLL_DEMAND";
        desc = "DMAP_RCV_POLL_DEMAND is the receive poll demand register. Enables the RxDMA to check whether the current descriptor belongs to the DMA. This command is used to wake up an RxDMA in the suspended state. The RxDMA normally enters the suspended state due to FIFO underflow or no available receive descriptor. DMAP_RCV_POLL_DEMAND (offset 0x1008+Px0x100 (P = 0~2), total reset 0x0000_0000; PROVEN: Hi3535 data sheet, PDF page 845, section 5.6).";
        field {
            name = "rpd";
            desc = "RPD: receive poll demand. When any value is written to this register, the DMA reads the current receive descriptor address. If the current descriptor is unavailable (own bit is 0), the receive state machine enters the suspended state; otherwise, if the current descriptor is available, the receive state machine enters the active state. (data sheet access type ROWT)";
            sw = rw; hw = r;
            reset = 0x0;
        } rpd[31:0];
    } DMAP_RCV_POLL_DEMAND_2 @ 0x1208;
    reg {
        name = "DMAP_RCV_BASE_ADDR";
        desc = "DMAP_RCV_BASE_ADDR is the receive descriptor list address register. It indicates the start of the receive descriptor list. This register may be changed only while reception is stopped and before the receive start command is issued. DMAP_RCV_BASE_ADDR (offset 0x100C+Px0x100 (P = 0~2), total reset 0x0000_0000; PROVEN: Hi3535 data sheet, PDF page 845, section 5.6).";
        field {
            name = "rba";
            desc = "Start of the receive list. This field contains the base address of the first descriptor of the receive descriptor list.";
            sw = rw; hw = r;
            reset = 0x0;
        } rba[31:0];
    } DMAP_RCV_BASE_ADDR_0 @ 0x100c;
    reg {
        name = "DMAP_RCV_BASE_ADDR";
        desc = "DMAP_RCV_BASE_ADDR is the receive descriptor list address register. It indicates the start of the receive descriptor list. This register may be changed only while reception is stopped and before the receive start command is issued. DMAP_RCV_BASE_ADDR (offset 0x100C+Px0x100 (P = 0~2), total reset 0x0000_0000; PROVEN: Hi3535 data sheet, PDF page 845, section 5.6).";
        field {
            name = "rba";
            desc = "Start of the receive list. This field contains the base address of the first descriptor of the receive descriptor list.";
            sw = rw; hw = r;
            reset = 0x0;
        } rba[31:0];
    } DMAP_RCV_BASE_ADDR_1 @ 0x110c;
    reg {
        name = "DMAP_RCV_BASE_ADDR";
        desc = "DMAP_RCV_BASE_ADDR is the receive descriptor list address register. It indicates the start of the receive descriptor list. This register may be changed only while reception is stopped and before the receive start command is issued. DMAP_RCV_BASE_ADDR (offset 0x100C+Px0x100 (P = 0~2), total reset 0x0000_0000; PROVEN: Hi3535 data sheet, PDF page 845, section 5.6).";
        field {
            name = "rba";
            desc = "Start of the receive list. This field contains the base address of the first descriptor of the receive descriptor list.";
            sw = rw; hw = r;
            reset = 0x0;
        } rba[31:0];
    } DMAP_RCV_BASE_ADDR_2 @ 0x120c;
    reg {
        name = "DMAP_TX_BASE_ADDR";
        desc = "DMAP_TX_BASE_ADDR is the transmit descriptor list address register. It indicates the start of the transmit descriptor list. This register may be changed only when transmission is stopped and before the transmit start command is issued. DMAP_TX_BASE_ADDR (offset 0x1010+Px0x100 (P = 0~2), total reset 0x0000_0000; PROVEN: Hi3535 data sheet, PDF page 846, section 5.6).";
        field {
            name = "tba";
            desc = "Start of the transmit list. This field holds the base address of the first descriptor of the transmit descriptor list.";
            sw = rw; hw = r;
            reset = 0x0;
        } tba[31:0];
    } DMAP_TX_BASE_ADDR_0 @ 0x1010;
    reg {
        name = "DMAP_TX_BASE_ADDR";
        desc = "DMAP_TX_BASE_ADDR is the transmit descriptor list address register. It indicates the start of the transmit descriptor list. This register may be changed only when transmission is stopped and before the transmit start command is issued. DMAP_TX_BASE_ADDR (offset 0x1010+Px0x100 (P = 0~2), total reset 0x0000_0000; PROVEN: Hi3535 data sheet, PDF page 846, section 5.6).";
        field {
            name = "tba";
            desc = "Start of the transmit list. This field holds the base address of the first descriptor of the transmit descriptor list.";
            sw = rw; hw = r;
            reset = 0x0;
        } tba[31:0];
    } DMAP_TX_BASE_ADDR_1 @ 0x1110;
    reg {
        name = "DMAP_TX_BASE_ADDR";
        desc = "DMAP_TX_BASE_ADDR is the transmit descriptor list address register. It indicates the start of the transmit descriptor list. This register may be changed only when transmission is stopped and before the transmit start command is issued. DMAP_TX_BASE_ADDR (offset 0x1010+Px0x100 (P = 0~2), total reset 0x0000_0000; PROVEN: Hi3535 data sheet, PDF page 846, section 5.6).";
        field {
            name = "tba";
            desc = "Start of the transmit list. This field holds the base address of the first descriptor of the transmit descriptor list.";
            sw = rw; hw = r;
            reset = 0x0;
        } tba[31:0];
    } DMAP_TX_BASE_ADDR_2 @ 0x1210;
    reg {
        name = "DMAP_STATUS";
        desc = "DMAP_STATUS is the status register. It holds all status information that the DMA reports to the host. Software reads this register by interrupt service or by polling. Most bits of this register can cause interrupts. DMAP_STATUS is not clear-on-read; DMAP_STATUS[16:0] is cleared by writing 1, and writing 0 has no effect. These bits can be masked by operating the DMAP_CONTROL register. DMAP_STATUS (offset 0x1014+Px0x100 (P = 0~2), total reset 0x0000_0000; PROVEN: Hi3535 data sheet, PDF page 846, section 5.6).";
        field {
            name = "reserved";
            desc = "Reserved.";
            sw = r; hw = w;
            reset = 0x0;
        } reserved_31_28[31:28];
        field {
            name = "gmi";
            desc = "GMI: GMAC MMC interrupt. This bit reflects interrupt events of the MMC module. Software must read the corresponding registers in the GMAC to determine the interrupt source and clear the interrupt.
- 0: No GMAC MMC interrupt generated;
- 1: GMAC MMC interrupt generated.";
            sw = r; hw = w;
            reset = 0x0;
        } gmi[27:27];
        field {
            name = "gli";
            desc = "GLI: GMAC line interface interrupt. This bit reflects the interrupt event of the PCS module in the GMAC. Software must read the corresponding registers in the GMAC to find the interrupt source and clear the interrupt.
- 0: No GMAC PCS interrupt generated;
- 1: GMAC PCS interrupt generated.";
            sw = r; hw = w;
            reset = 0x0;
        } gli[26:26];
        field {
            name = "eb";
            desc = "EB: Error bits. These bits indicate the type of error that caused a bus error. They are valid only when bit 13 (FBI) is 1, and they do not generate an interrupt. This field does not generate an interrupt. bit[23]:
- 0: Error occurred during RxDMA data transfer;
- 1: Error occurred during TxDMA data transfer. bit[24]:
- 0: Error occurred during a write operation;
- 1: Error occurred during a read operation. bit[25]:
- 0: Error occurred during a data buffer access;
- 1: Error occurred during a descriptor access.";
            sw = r; hw = w;
            reset = 0x0;
        } eb[25:23];
        field {
            name = "ts";
            desc = "TS: transmit process state. These bits indicate the state of the TxDMA; they do not generate interrupts.
- 000: Stopped. A reset or stop command was received.
- 001: Running. Fetching the transmit descriptor.
- 010: Running. Waiting for status information.
- 011: Running. Reading the packet from host memory and writing it to the

TxFIFO.
- 100: TIME_STAMP write state.
- 101: Reserved.
- 110: Suspended. No transmit descriptor is available or the TxFIFO underflowed.
- 111: Writing back the transmit descriptor.";
            sw = r; hw = w;
            reset = 0x0;
        } ts[22:20];
        field {
            name = "rs";
            desc = "RS: receive process state. These bits indicate the state of the RxDMA; they do not generate interrupts.
- 000: Stopped. A reset or stop command was received;
- 001: Running. Fetching the receive descriptor;
- 010: Reserved;
- 011: Running. Waiting for a receive packet;
- 100: Suspended. No receive descriptor available;
- 101: Running. Writing back the receive descriptor;
- 110: TIME_STAMP write state;
- 111: Running. Writing the receive packet to host memory.";
            sw = r; hw = w;
            reset = 0x0;
        } rs[19:17];
        field {
            name = "nis";
            desc = "NIS: Normal interrupt summary. This bit is the logical OR of the following interrupt bits. DMAp_STATUS[0], DMAp_STATUS[2], DMAp_STATUS[6], DMAp_STATUS[14]. Only unmasked interrupts affect this bit. Each time an interrupt event sets this bit to 1, it must be cleared. (data sheet access type RWC)";
            sw = rw; hw = rw; onwrite = woclr;
            reset = 0x0;
        } nis[16:16];
        field {
            name = "ais";
            desc = "AIS: Abnormal interrupt summary. This bit is the logical OR of the following interrupt bits. DMAp_STATUS[1], DMAp_STATUS[3], DMAp_STATUS[4] DMAp_STATUS[5], DMAp_STATUS[7], DMAp_STATUS[8] DMAp_STATUS[9], DMAp_STATUS[10], DMAp_STATUS[13] Only interrupts that are not masked affect this bit. After each interrupt event sets this bit to 1, this bit must be cleared. (data sheet access type RWC)";
            sw = rw; hw = rw; onwrite = woclr;
            reset = 0x0;
        } ais[15:15];
        field {
            name = "eri";
            desc = "ERI: early receive interrupt.
- 0: No early receive interrupt generated;
- 1: Early receive interrupt generated.
Indicates that the RxDMA has filled the first data buffer of the receive descriptor. This interrupt is cleared automatically by DMAp_STATUS[6]. (data sheet access type RWC)";
            sw = rw; hw = rw; onwrite = woclr;
            reset = 0x0;
        } eri[14:14];
        field {
            name = "fbi";
            desc = "FBI: Fatal bus error interrupt.
- 0: No fatal bus error interrupt generated.
- 1: Fatal bus error interrupt generated. Indicates that a fatal bus error occurred; see bits [25:23]. When this bit is set,

the DMA stops all bus accesses. (data sheet access type RWC)";
            sw = rw; hw = rw; onwrite = woclr;
            reset = 0x0;
        } fbi[13:13];
        field {
            name = "reserved";
            desc = "Reserved.";
            sw = r; hw = w;
            reset = 0x0;
        } reserved_12_11[12:11];
        field {
            name = "eti";
            desc = "ETI: Early transmit interrupt.
- 0: No early transmit interrupt generated;
- 1: Early transmit interrupt generated. This bit indicates that the frame to be transmitted has been written to the TxFIFO. (data sheet access type RWC)";
            sw = rw; hw = rw; onwrite = woclr;
            reset = 0x0;
        } eti[10:10];
        field {
            name = "rwt";
            desc = "RWT: Receive watchdog timeout.
- 0: No receive watchdog timeout occurred.
- 1: A receive watchdog timeout occurred. This bit is set to 1 when the received frame length exceeds 2048 bytes. (data sheet access type RWC)";
            sw = rw; hw = rw; onwrite = woclr;
            reset = 0x0;
        } rwt[9:9];
        field {
            name = "rps";
            desc = "RPS: receive process stopped.
- 0: Receive process has not stopped;
- 1: Receive process stopped.
This bit indicates that the receive state machine entered the stopped state. (data sheet access type RWC)";
            sw = rw; hw = rw; onwrite = woclr;
            reset = 0x0;
        } rps[8:8];
        field {
            name = "ru";
            desc = "RU: receive buffer unavailable.
- 0: No receive buffer unavailable condition occurred;
- 1: A receive buffer unavailable condition occurred.
This bit indicates that the next descriptor in the receive queue is owned by the host and cannot be fetched. The receive process then enters the suspended state. The host must configure the next available descriptor and send a poll demand command to the RxDMA; otherwise this bit stays set. (data sheet access type RWC)";
            sw = rw; hw = rw; onwrite = woclr;
            reset = 0x0;
        } ru[7:7];
        field {
            name = "ri";
            desc = "RI: Receive interrupt.
- 0: No receive interrupt generated;
- 1: Receive interrupt generated. This bit indicates that frame reception is complete. The frame status information has been written to the descriptor, and the receive process is still running. (data sheet access type RWC)";
            sw = rw; hw = rw; onwrite = woclr;
            reset = 0x0;
        } ri[6:6];
        field {
            name = "unf";
            desc = "UNF: transmit underflow.
- 0: No transmit underflow occurred;
- 1: Transmit underflow occurred. This bit indicates that a TxFIFO underflow occurred during frame transmission. The transmit process enters the suspended state, and the underflow error bit in the transmit descriptor is also set to 1. (data sheet access type RWC)";
            sw = rw; hw = rw; onwrite = woclr;
            reset = 0x0;
        } unf[5:5];
        field {
            name = "ovf";
            desc = "OVF: receive overflow.
- 0: No receive overflow occurred;
- 1: Receive overflow occurred.
This bit indicates that an RxFIFO overflow occurred during frame reception. If part of the data has already been written to the host buffer, the overflow error bit in the receive descriptor is also set to 1. (data sheet access type RWC)";
            sw = rw; hw = rw; onwrite = woclr;
            reset = 0x0;
        } ovf[4:4];
        field {
            name = "tjt";
            desc = "TJT: transmit jabber timeout.
- 0: No transmit jabber timeout occurred;
- 1: Transmit jabber timeout occurred. This bit indicates that the transmit jabber timer expired; the transmit process is then canceled and enters the stopped state, and the jabber timeout bit of the corresponding transmit descriptor is also set to 1. (data sheet access type RWC)";
            sw = rw; hw = rw; onwrite = woclr;
            reset = 0x0;
        } tjt[3:3];
        field {
            name = "tu";
            desc = "TU: Transmit buffer unavailable.
- 0: No transmit buffer unavailable condition occurred.
- 1: A transmit buffer unavailable condition occurred. This bit indicates that the next descriptor in the transmit queue is owned by the host and cannot be fetched. The transmit process enters the suspended state. If the host has new data to transmit, it must configure the next available descriptor and send a poll demand command to the TxDMA. (data sheet access type RWC)";
            sw = rw; hw = rw; onwrite = woclr;
            reset = 0x0;
        } tu[2:2];
        field {
            name = "tps";
            desc = "TPS: transmit process stopped.
- 0: Transmit process stop did not occur;
- 1: Transmit process stop occurred. This bit indicates that the transmit state machine entered the stopped state. (data sheet access type RWC)";
            sw = rw; hw = rw; onwrite = woclr;
            reset = 0x0;
        } tps[1:1];
        field {
            name = "ti";
            desc = "TI: transmit interrupt.
- 0: No transmit interrupt generated;
- 1: Transmit interrupt generated.
This bit indicates that transmission of a frame is complete. The frame status information has been written to the descriptor, and the transmit process remains in the running state. (data sheet access type RWC)";
            sw = rw; hw = rw; onwrite = woclr;
            reset = 0x0;
        } ti[0:0];
    } DMAP_STATUS_0 @ 0x1014;
    reg {
        name = "DMAP_STATUS";
        desc = "DMAP_STATUS is the status register. It holds all status information that the DMA reports to the host. Software reads this register by interrupt service or by polling. Most bits of this register can cause interrupts. DMAP_STATUS is not clear-on-read; DMAP_STATUS[16:0] is cleared by writing 1, and writing 0 has no effect. These bits can be masked by operating the DMAP_CONTROL register. DMAP_STATUS (offset 0x1014+Px0x100 (P = 0~2), total reset 0x0000_0000; PROVEN: Hi3535 data sheet, PDF page 846, section 5.6).";
        field {
            name = "reserved";
            desc = "Reserved.";
            sw = r; hw = w;
            reset = 0x0;
        } reserved_31_28[31:28];
        field {
            name = "gmi";
            desc = "GMI: GMAC MMC interrupt. This bit reflects interrupt events of the MMC module. Software must read the corresponding registers in the GMAC to determine the interrupt source and clear the interrupt.
- 0: No GMAC MMC interrupt generated;
- 1: GMAC MMC interrupt generated.";
            sw = r; hw = w;
            reset = 0x0;
        } gmi[27:27];
        field {
            name = "gli";
            desc = "GLI: GMAC line interface interrupt. This bit reflects the interrupt event of the PCS module in the GMAC. Software must read the corresponding registers in the GMAC to find the interrupt source and clear the interrupt.
- 0: No GMAC PCS interrupt generated;
- 1: GMAC PCS interrupt generated.";
            sw = r; hw = w;
            reset = 0x0;
        } gli[26:26];
        field {
            name = "eb";
            desc = "EB: Error bits. These bits indicate the type of error that caused a bus error. They are valid only when bit 13 (FBI) is 1, and they do not generate an interrupt. This field does not generate an interrupt. bit[23]:
- 0: Error occurred during RxDMA data transfer;
- 1: Error occurred during TxDMA data transfer. bit[24]:
- 0: Error occurred during a write operation;
- 1: Error occurred during a read operation. bit[25]:
- 0: Error occurred during a data buffer access;
- 1: Error occurred during a descriptor access.";
            sw = r; hw = w;
            reset = 0x0;
        } eb[25:23];
        field {
            name = "ts";
            desc = "TS: transmit process state. These bits indicate the state of the TxDMA; they do not generate interrupts.
- 000: Stopped. A reset or stop command was received.
- 001: Running. Fetching the transmit descriptor.
- 010: Running. Waiting for status information.
- 011: Running. Reading the packet from host memory and writing it to the

TxFIFO.
- 100: TIME_STAMP write state.
- 101: Reserved.
- 110: Suspended. No transmit descriptor is available or the TxFIFO underflowed.
- 111: Writing back the transmit descriptor.";
            sw = r; hw = w;
            reset = 0x0;
        } ts[22:20];
        field {
            name = "rs";
            desc = "RS: receive process state. These bits indicate the state of the RxDMA; they do not generate interrupts.
- 000: Stopped. A reset or stop command was received;
- 001: Running. Fetching the receive descriptor;
- 010: Reserved;
- 011: Running. Waiting for a receive packet;
- 100: Suspended. No receive descriptor available;
- 101: Running. Writing back the receive descriptor;
- 110: TIME_STAMP write state;
- 111: Running. Writing the receive packet to host memory.";
            sw = r; hw = w;
            reset = 0x0;
        } rs[19:17];
        field {
            name = "nis";
            desc = "NIS: Normal interrupt summary. This bit is the logical OR of the following interrupt bits. DMAp_STATUS[0], DMAp_STATUS[2], DMAp_STATUS[6], DMAp_STATUS[14]. Only unmasked interrupts affect this bit. Each time an interrupt event sets this bit to 1, it must be cleared. (data sheet access type RWC)";
            sw = rw; hw = rw; onwrite = woclr;
            reset = 0x0;
        } nis[16:16];
        field {
            name = "ais";
            desc = "AIS: Abnormal interrupt summary. This bit is the logical OR of the following interrupt bits. DMAp_STATUS[1], DMAp_STATUS[3], DMAp_STATUS[4] DMAp_STATUS[5], DMAp_STATUS[7], DMAp_STATUS[8] DMAp_STATUS[9], DMAp_STATUS[10], DMAp_STATUS[13] Only interrupts that are not masked affect this bit. After each interrupt event sets this bit to 1, this bit must be cleared. (data sheet access type RWC)";
            sw = rw; hw = rw; onwrite = woclr;
            reset = 0x0;
        } ais[15:15];
        field {
            name = "eri";
            desc = "ERI: early receive interrupt.
- 0: No early receive interrupt generated;
- 1: Early receive interrupt generated.
Indicates that the RxDMA has filled the first data buffer of the receive descriptor. This interrupt is cleared automatically by DMAp_STATUS[6]. (data sheet access type RWC)";
            sw = rw; hw = rw; onwrite = woclr;
            reset = 0x0;
        } eri[14:14];
        field {
            name = "fbi";
            desc = "FBI: Fatal bus error interrupt.
- 0: No fatal bus error interrupt generated.
- 1: Fatal bus error interrupt generated. Indicates that a fatal bus error occurred; see bits [25:23]. When this bit is set,

the DMA stops all bus accesses. (data sheet access type RWC)";
            sw = rw; hw = rw; onwrite = woclr;
            reset = 0x0;
        } fbi[13:13];
        field {
            name = "reserved";
            desc = "Reserved.";
            sw = r; hw = w;
            reset = 0x0;
        } reserved_12_11[12:11];
        field {
            name = "eti";
            desc = "ETI: Early transmit interrupt.
- 0: No early transmit interrupt generated;
- 1: Early transmit interrupt generated. This bit indicates that the frame to be transmitted has been written to the TxFIFO. (data sheet access type RWC)";
            sw = rw; hw = rw; onwrite = woclr;
            reset = 0x0;
        } eti[10:10];
        field {
            name = "rwt";
            desc = "RWT: Receive watchdog timeout.
- 0: No receive watchdog timeout occurred.
- 1: A receive watchdog timeout occurred. This bit is set to 1 when the received frame length exceeds 2048 bytes. (data sheet access type RWC)";
            sw = rw; hw = rw; onwrite = woclr;
            reset = 0x0;
        } rwt[9:9];
        field {
            name = "rps";
            desc = "RPS: receive process stopped.
- 0: Receive process has not stopped;
- 1: Receive process stopped.
This bit indicates that the receive state machine entered the stopped state. (data sheet access type RWC)";
            sw = rw; hw = rw; onwrite = woclr;
            reset = 0x0;
        } rps[8:8];
        field {
            name = "ru";
            desc = "RU: receive buffer unavailable.
- 0: No receive buffer unavailable condition occurred;
- 1: A receive buffer unavailable condition occurred.
This bit indicates that the next descriptor in the receive queue is owned by the host and cannot be fetched. The receive process then enters the suspended state. The host must configure the next available descriptor and send a poll demand command to the RxDMA; otherwise this bit stays set. (data sheet access type RWC)";
            sw = rw; hw = rw; onwrite = woclr;
            reset = 0x0;
        } ru[7:7];
        field {
            name = "ri";
            desc = "RI: Receive interrupt.
- 0: No receive interrupt generated;
- 1: Receive interrupt generated. This bit indicates that frame reception is complete. The frame status information has been written to the descriptor, and the receive process is still running. (data sheet access type RWC)";
            sw = rw; hw = rw; onwrite = woclr;
            reset = 0x0;
        } ri[6:6];
        field {
            name = "unf";
            desc = "UNF: transmit underflow.
- 0: No transmit underflow occurred;
- 1: Transmit underflow occurred. This bit indicates that a TxFIFO underflow occurred during frame transmission. The transmit process enters the suspended state, and the underflow error bit in the transmit descriptor is also set to 1. (data sheet access type RWC)";
            sw = rw; hw = rw; onwrite = woclr;
            reset = 0x0;
        } unf[5:5];
        field {
            name = "ovf";
            desc = "OVF: receive overflow.
- 0: No receive overflow occurred;
- 1: Receive overflow occurred.
This bit indicates that an RxFIFO overflow occurred during frame reception. If part of the data has already been written to the host buffer, the overflow error bit in the receive descriptor is also set to 1. (data sheet access type RWC)";
            sw = rw; hw = rw; onwrite = woclr;
            reset = 0x0;
        } ovf[4:4];
        field {
            name = "tjt";
            desc = "TJT: transmit jabber timeout.
- 0: No transmit jabber timeout occurred;
- 1: Transmit jabber timeout occurred. This bit indicates that the transmit jabber timer expired; the transmit process is then canceled and enters the stopped state, and the jabber timeout bit of the corresponding transmit descriptor is also set to 1. (data sheet access type RWC)";
            sw = rw; hw = rw; onwrite = woclr;
            reset = 0x0;
        } tjt[3:3];
        field {
            name = "tu";
            desc = "TU: Transmit buffer unavailable.
- 0: No transmit buffer unavailable condition occurred.
- 1: A transmit buffer unavailable condition occurred. This bit indicates that the next descriptor in the transmit queue is owned by the host and cannot be fetched. The transmit process enters the suspended state. If the host has new data to transmit, it must configure the next available descriptor and send a poll demand command to the TxDMA. (data sheet access type RWC)";
            sw = rw; hw = rw; onwrite = woclr;
            reset = 0x0;
        } tu[2:2];
        field {
            name = "tps";
            desc = "TPS: transmit process stopped.
- 0: Transmit process stop did not occur;
- 1: Transmit process stop occurred. This bit indicates that the transmit state machine entered the stopped state. (data sheet access type RWC)";
            sw = rw; hw = rw; onwrite = woclr;
            reset = 0x0;
        } tps[1:1];
        field {
            name = "ti";
            desc = "TI: transmit interrupt.
- 0: No transmit interrupt generated;
- 1: Transmit interrupt generated.
This bit indicates that transmission of a frame is complete. The frame status information has been written to the descriptor, and the transmit process remains in the running state. (data sheet access type RWC)";
            sw = rw; hw = rw; onwrite = woclr;
            reset = 0x0;
        } ti[0:0];
    } DMAP_STATUS_1 @ 0x1114;
    reg {
        name = "DMAP_STATUS";
        desc = "DMAP_STATUS is the status register. It holds all status information that the DMA reports to the host. Software reads this register by interrupt service or by polling. Most bits of this register can cause interrupts. DMAP_STATUS is not clear-on-read; DMAP_STATUS[16:0] is cleared by writing 1, and writing 0 has no effect. These bits can be masked by operating the DMAP_CONTROL register. DMAP_STATUS (offset 0x1014+Px0x100 (P = 0~2), total reset 0x0000_0000; PROVEN: Hi3535 data sheet, PDF page 846, section 5.6).";
        field {
            name = "reserved";
            desc = "Reserved.";
            sw = r; hw = w;
            reset = 0x0;
        } reserved_31_28[31:28];
        field {
            name = "gmi";
            desc = "GMI: GMAC MMC interrupt. This bit reflects interrupt events of the MMC module. Software must read the corresponding registers in the GMAC to determine the interrupt source and clear the interrupt.
- 0: No GMAC MMC interrupt generated;
- 1: GMAC MMC interrupt generated.";
            sw = r; hw = w;
            reset = 0x0;
        } gmi[27:27];
        field {
            name = "gli";
            desc = "GLI: GMAC line interface interrupt. This bit reflects the interrupt event of the PCS module in the GMAC. Software must read the corresponding registers in the GMAC to find the interrupt source and clear the interrupt.
- 0: No GMAC PCS interrupt generated;
- 1: GMAC PCS interrupt generated.";
            sw = r; hw = w;
            reset = 0x0;
        } gli[26:26];
        field {
            name = "eb";
            desc = "EB: Error bits. These bits indicate the type of error that caused a bus error. They are valid only when bit 13 (FBI) is 1, and they do not generate an interrupt. This field does not generate an interrupt. bit[23]:
- 0: Error occurred during RxDMA data transfer;
- 1: Error occurred during TxDMA data transfer. bit[24]:
- 0: Error occurred during a write operation;
- 1: Error occurred during a read operation. bit[25]:
- 0: Error occurred during a data buffer access;
- 1: Error occurred during a descriptor access.";
            sw = r; hw = w;
            reset = 0x0;
        } eb[25:23];
        field {
            name = "ts";
            desc = "TS: transmit process state. These bits indicate the state of the TxDMA; they do not generate interrupts.
- 000: Stopped. A reset or stop command was received.
- 001: Running. Fetching the transmit descriptor.
- 010: Running. Waiting for status information.
- 011: Running. Reading the packet from host memory and writing it to the

TxFIFO.
- 100: TIME_STAMP write state.
- 101: Reserved.
- 110: Suspended. No transmit descriptor is available or the TxFIFO underflowed.
- 111: Writing back the transmit descriptor.";
            sw = r; hw = w;
            reset = 0x0;
        } ts[22:20];
        field {
            name = "rs";
            desc = "RS: receive process state. These bits indicate the state of the RxDMA; they do not generate interrupts.
- 000: Stopped. A reset or stop command was received;
- 001: Running. Fetching the receive descriptor;
- 010: Reserved;
- 011: Running. Waiting for a receive packet;
- 100: Suspended. No receive descriptor available;
- 101: Running. Writing back the receive descriptor;
- 110: TIME_STAMP write state;
- 111: Running. Writing the receive packet to host memory.";
            sw = r; hw = w;
            reset = 0x0;
        } rs[19:17];
        field {
            name = "nis";
            desc = "NIS: Normal interrupt summary. This bit is the logical OR of the following interrupt bits. DMAp_STATUS[0], DMAp_STATUS[2], DMAp_STATUS[6], DMAp_STATUS[14]. Only unmasked interrupts affect this bit. Each time an interrupt event sets this bit to 1, it must be cleared. (data sheet access type RWC)";
            sw = rw; hw = rw; onwrite = woclr;
            reset = 0x0;
        } nis[16:16];
        field {
            name = "ais";
            desc = "AIS: Abnormal interrupt summary. This bit is the logical OR of the following interrupt bits. DMAp_STATUS[1], DMAp_STATUS[3], DMAp_STATUS[4] DMAp_STATUS[5], DMAp_STATUS[7], DMAp_STATUS[8] DMAp_STATUS[9], DMAp_STATUS[10], DMAp_STATUS[13] Only interrupts that are not masked affect this bit. After each interrupt event sets this bit to 1, this bit must be cleared. (data sheet access type RWC)";
            sw = rw; hw = rw; onwrite = woclr;
            reset = 0x0;
        } ais[15:15];
        field {
            name = "eri";
            desc = "ERI: early receive interrupt.
- 0: No early receive interrupt generated;
- 1: Early receive interrupt generated.
Indicates that the RxDMA has filled the first data buffer of the receive descriptor. This interrupt is cleared automatically by DMAp_STATUS[6]. (data sheet access type RWC)";
            sw = rw; hw = rw; onwrite = woclr;
            reset = 0x0;
        } eri[14:14];
        field {
            name = "fbi";
            desc = "FBI: Fatal bus error interrupt.
- 0: No fatal bus error interrupt generated.
- 1: Fatal bus error interrupt generated. Indicates that a fatal bus error occurred; see bits [25:23]. When this bit is set,

the DMA stops all bus accesses. (data sheet access type RWC)";
            sw = rw; hw = rw; onwrite = woclr;
            reset = 0x0;
        } fbi[13:13];
        field {
            name = "reserved";
            desc = "Reserved.";
            sw = r; hw = w;
            reset = 0x0;
        } reserved_12_11[12:11];
        field {
            name = "eti";
            desc = "ETI: Early transmit interrupt.
- 0: No early transmit interrupt generated;
- 1: Early transmit interrupt generated. This bit indicates that the frame to be transmitted has been written to the TxFIFO. (data sheet access type RWC)";
            sw = rw; hw = rw; onwrite = woclr;
            reset = 0x0;
        } eti[10:10];
        field {
            name = "rwt";
            desc = "RWT: Receive watchdog timeout.
- 0: No receive watchdog timeout occurred.
- 1: A receive watchdog timeout occurred. This bit is set to 1 when the received frame length exceeds 2048 bytes. (data sheet access type RWC)";
            sw = rw; hw = rw; onwrite = woclr;
            reset = 0x0;
        } rwt[9:9];
        field {
            name = "rps";
            desc = "RPS: receive process stopped.
- 0: Receive process has not stopped;
- 1: Receive process stopped.
This bit indicates that the receive state machine entered the stopped state. (data sheet access type RWC)";
            sw = rw; hw = rw; onwrite = woclr;
            reset = 0x0;
        } rps[8:8];
        field {
            name = "ru";
            desc = "RU: receive buffer unavailable.
- 0: No receive buffer unavailable condition occurred;
- 1: A receive buffer unavailable condition occurred.
This bit indicates that the next descriptor in the receive queue is owned by the host and cannot be fetched. The receive process then enters the suspended state. The host must configure the next available descriptor and send a poll demand command to the RxDMA; otherwise this bit stays set. (data sheet access type RWC)";
            sw = rw; hw = rw; onwrite = woclr;
            reset = 0x0;
        } ru[7:7];
        field {
            name = "ri";
            desc = "RI: Receive interrupt.
- 0: No receive interrupt generated;
- 1: Receive interrupt generated. This bit indicates that frame reception is complete. The frame status information has been written to the descriptor, and the receive process is still running. (data sheet access type RWC)";
            sw = rw; hw = rw; onwrite = woclr;
            reset = 0x0;
        } ri[6:6];
        field {
            name = "unf";
            desc = "UNF: transmit underflow.
- 0: No transmit underflow occurred;
- 1: Transmit underflow occurred. This bit indicates that a TxFIFO underflow occurred during frame transmission. The transmit process enters the suspended state, and the underflow error bit in the transmit descriptor is also set to 1. (data sheet access type RWC)";
            sw = rw; hw = rw; onwrite = woclr;
            reset = 0x0;
        } unf[5:5];
        field {
            name = "ovf";
            desc = "OVF: receive overflow.
- 0: No receive overflow occurred;
- 1: Receive overflow occurred.
This bit indicates that an RxFIFO overflow occurred during frame reception. If part of the data has already been written to the host buffer, the overflow error bit in the receive descriptor is also set to 1. (data sheet access type RWC)";
            sw = rw; hw = rw; onwrite = woclr;
            reset = 0x0;
        } ovf[4:4];
        field {
            name = "tjt";
            desc = "TJT: transmit jabber timeout.
- 0: No transmit jabber timeout occurred;
- 1: Transmit jabber timeout occurred. This bit indicates that the transmit jabber timer expired; the transmit process is then canceled and enters the stopped state, and the jabber timeout bit of the corresponding transmit descriptor is also set to 1. (data sheet access type RWC)";
            sw = rw; hw = rw; onwrite = woclr;
            reset = 0x0;
        } tjt[3:3];
        field {
            name = "tu";
            desc = "TU: Transmit buffer unavailable.
- 0: No transmit buffer unavailable condition occurred.
- 1: A transmit buffer unavailable condition occurred. This bit indicates that the next descriptor in the transmit queue is owned by the host and cannot be fetched. The transmit process enters the suspended state. If the host has new data to transmit, it must configure the next available descriptor and send a poll demand command to the TxDMA. (data sheet access type RWC)";
            sw = rw; hw = rw; onwrite = woclr;
            reset = 0x0;
        } tu[2:2];
        field {
            name = "tps";
            desc = "TPS: transmit process stopped.
- 0: Transmit process stop did not occur;
- 1: Transmit process stop occurred. This bit indicates that the transmit state machine entered the stopped state. (data sheet access type RWC)";
            sw = rw; hw = rw; onwrite = woclr;
            reset = 0x0;
        } tps[1:1];
        field {
            name = "ti";
            desc = "TI: transmit interrupt.
- 0: No transmit interrupt generated;
- 1: Transmit interrupt generated.
This bit indicates that transmission of a frame is complete. The frame status information has been written to the descriptor, and the transmit process remains in the running state. (data sheet access type RWC)";
            sw = rw; hw = rw; onwrite = woclr;
            reset = 0x0;
        } ti[0:0];
    } DMAP_STATUS_2 @ 0x1214;
    reg {
        name = "DMAP_CONTROL";
        desc = "DMAP_CONTROL is the operation mode register of DMAp (0 to 2). It specifies the receive and transmit operation modes and commands. This register should be the last register written during DMA initialization. DMAP_CONTROL (offset 0x1018+Px0x100 (P = 0~2), total reset 0x0000_0000; PROVEN: Hi3535 data sheet, PDF page 850, section 5.6).";
        field {
            name = "reserved";
            desc = "Reserved.";
            sw = r; hw = w;
            reset = 0x0;
        } reserved_31_26[31:26];
        field {
            name = "rsf";
            desc = "RSF: receive store and forward.
- 0: Receive store and forward is not performed. The RxFIFO decides whether to forward according to the FIFO threshold.
- 1: Receive store and forward is performed. The RxFIFO forwards a frame upward only after it has received the complete frame.";
            sw = rw; hw = r;
            reset = 0x0;
        } rsf[25:25];
        field {
            name = "dff";
            desc = "DFF: Disable flushing of received frames.
- 0: Enable flushing of received frames. When this bit is 0, the RxDMA flushes any frame if the receive descriptor or receive buffer is unavailable;
- 1: Disable flushing of received frames. When this bit is 1, the RxDMA does not flush any frame because of an unavailable receive descriptor or receive buffer.";
            sw = rw; hw = r;
            reset = 0x0;
        } dff[24:24];
        field {
            name = "rfa2";
            desc = "RFA[2]: high bit of the flow control activation threshold.
- 0: When this bit is 0, the flow control threshold is set according to RFA;
- 1: When this bit is 1, the flow control activation threshold is determined jointly by this bit and RFA. The activation threshold varies with {rfa2,rfa[1:0]} as follows:
- 100: Full minus 5 KB;
- 101: Full minus 6 KB;
- 110: Full minus 7 KB;
- 111: Reserved.";
            sw = rw; hw = r;
            reset = 0x0;
        } rfa2[23:23];
        field {
            name = "rfd2";
            desc = "RFD[2]: upper bit of the flow control deactivation threshold.
- 0: When this bit is 0, the flow control deactivation threshold is set according to RFD.
- 1: When this bit is 1, the flow control deactivation threshold is determined jointly by this bit and RFD. The deactivation threshold varies with {rfd2,rfd[1:0]} as follows:
- 100: Full minus 5 KB;
- 101: Full minus 6 KB;
- 110: Full minus 7 KB;
- 111: Reserved.";
            sw = rw; hw = r;
            reset = 0x0;
        } rfd2[22:22];
        field {
            name = "tsf";
            desc = "TSF: transmit store and forward.
- 0: Transmit store and forward is not performed. The TxFIFO decides whether to forward based on the FIFO threshold;
- 1: Transmit store and forward is performed. The TxFIFO forwards a frame to the MAC only after receiving the complete frame.";
            sw = rw; hw = r;
            reset = 0x0;
        } tsf[21:21];
        field {
            name = "ftf";
            desc = "FTF: flush TxFIFO.
- 0: Do not flush the TxFIFO.
- 1: Flush the TxFIFO. When this bit is set to 1, all control logic of the TxFIFO is reset and the data in the TxFIFO is lost. This bit is cleared automatically after the flush completes. During the flush, the operation mode register cannot be written. Data already accepted by the GMAC transmitter is not flushed. This operation causes

FIFO underflow and the sending of runt frames. (data sheet access type RWC)";
            sw = rw; hw = rw; onwrite = woclr;
            reset = 0x0;
        } ftf[20:20];
        field {
            name = "reserved";
            desc = "Reserved.";
            sw = r; hw = w;
            reset = 0x0;
        } reserved_19_17[19:17];
        field {
            name = "ttc";
            desc = "TTC: Transmit threshold control. Controls the TxFIFO threshold for starting the TxDMA. When the number of bytes in the RxFIFO is greater than or equal to this threshold, the TxDMA is started for processing. This bit is valid only when TSF is 0.
- 000: 64;
- 001: 128;
- 010: 192;
- 011: 256;
- 100: 40;
- 101: 32;
- 110: 24;
- 111: 16.";
            sw = rw; hw = r;
            reset = 0x0;
        } ttc[16:14];
        field {
            name = "st";
            desc = "ST: start/stop transmission command.
- 1: When this bit is 1, the transmit process enters the running state. The DMA tries to fetch a descriptor from the transmit queue. The descriptor is fetched from the DMAp_XMT_BASE_ADDR register or from the position saved when the transmit state machine last stopped. If no descriptor is available, the TxDMA enters the suspended state and transmit buffer unavailable (DMAp_STATUS[2]) is set to 1. Note that when this bit is set to 1, it takes effect only when transmission is stopped, and it works correctly only after the DMAp_XMT_BASE_ADDR configuration has taken effect.
- 0: When this bit is 0, the TxDMA stops operation after the current frame is processed. The position of the next descriptor in the queue is saved and becomes the current position when the transmit process restarts. Setting this bit to 0 is effective only when the transmit process is in the running or suspended state.";
            sw = rw; hw = r;
            reset = 0x0;
        } st[13:13];
        field {
            name = "rfd";
            desc = "RFD: threshold for deactivating flow control (in both HD and FD). These bits control the RxFIFO fill level below which flow control is deactivated after it has been activated.
- 00: Full minus 1 KB;
- 01: Full minus 2 KB;
- 10: Full minus 3 KB;
- 11: Full minus 4 KB.
The above is valid only after flow control is activated and when the RxFIFO depth exceeds 4KB. If the RxFIFO depth exceeds 8KB, RFD[2] in bit 22 can determine additional deactivation thresholds.";
            sw = rw; hw = r;
            reset = 0x0;
        } rfd[12:11];
        field {
            name = "rfa";
            desc = "RFA: Threshold for activating flow control (in both HD and FD). These bits control the start of flow control when the RxFIFO fill level exceeds this threshold.
- 00: Full minus 1 KB;
- 01: Full minus 2 KB;
- 10: Full minus 3 KB;
- 11: Full minus 4 KB. The above is valid only when EFC is set to 1 and the RxFIFO depth exceeds 4 KB. If the RxFIFO depth exceeds 8 KB, RFA[2] in bit 23 can determine further flow control thresholds.";
            sw = rw; hw = r;
            reset = 0x0;
        } rfa[10:9];
        field {
            name = "efc";
            desc = "EFC: enable hardware flow control.
- 0: Hardware flow control disabled.
- 1: Hardware flow control enabled. The hardware implements flow control depending on how full or empty the FIFO is.";
            sw = rw; hw = r;
            reset = 0x0;
        } efc[8:8];
        field {
            name = "fef";
            desc = "FEF: forward error frames.
- 0: When this bit is 0, the RxFIFO drops all frames with errors (including CRC errors, collision errors, gmii_er, oversize frames, watchdog timeout, overflow, and so on). However, in threshold mode, a frame cannot be dropped if its start pointer has already been obtained by the receive controller;
- 1: When this bit is 1, all frames except runt frames are forwarded to the DMA. Frames with FIFO overflow errors are still dropped.";
            sw = rw; hw = r;
            reset = 0x0;
        } fef[7:7];
        field {
            name = "fuf";
            desc = "FUF: forward undersized good frames.
- 0: When this bit is 0, the RxFIFO drops all undersized frames smaller than the receive threshold;
- 1: When this bit is 1, the RxFIFO forwards all error-free frames shorter than 64 bytes (including padding bytes and CRC).";
            sw = rw; hw = r;
            reset = 0x0;
        } fuf[6:6];
        field {
            name = "reserved";
            desc = "Reserved.";
            sw = r; hw = w;
            reset = 0x0;
        } reserved_5_5[5:5];
        field {
            name = "rtc";
            desc = "RTC: Receive threshold control. Controls the RxFIFO threshold for starting the RxDMA. When the number of bytes in the RxFIFO is greater than or equal to this threshold, the RxDMA is started for processing. This bit is valid only when RSF is 0.
- 00: 64;
- 01: 32;
- 10: 96;
- 11: 128.";
            sw = rw; hw = r;
            reset = 0x0;
        } rtc[4:3];
        field {
            name = "osf";
            desc = "OSF: operate on second frame.
- 0: Do not operate on the second frame;
- 1: Operate on the second frame. The DMA can then start processing the second frame before obtaining the status of the previous frame.";
            sw = rw; hw = r;
            reset = 0x0;
        } osf[2:2];
        field {
            name = "sr";
            desc = "SR: start/stop receive.
- 0: When this bit is 0, the RxDMA stops operating after the current frame has been processed. The position of the next descriptor in the receive queue is saved and becomes the current position when the receive process is restarted. Setting this bit to 0 is effective only when the receive process is in the running or suspended state.
- 1: When this bit is 1, the receive process enters the running state. The DMA tries to fetch descriptors from the receive queue and processes incoming frames. Descriptors are fetched from the

DMAp_RCV_BASE_ADDR register or from the position saved when the receive state machine last stopped. If no descriptor is available, the receive DMA enters the suspended state and receive buffer unavailable (DMAp_STATUS[7]) is set to 1. Note that setting this bit to 1 takes effect only when reception is stopped, and it works correctly only after the DMAp_RCV_BASE_ADDR configuration has taken effect.";
            sw = rw; hw = r;
            reset = 0x0;
        } sr[1:1];
        field {
            name = "reserved";
            desc = "Reserved.";
            sw = r; hw = w;
            reset = 0x0;
        } reserved_0_0[0:0];
    } DMAP_CONTROL_0 @ 0x1018;
    reg {
        name = "DMAP_CONTROL";
        desc = "DMAP_CONTROL is the operation mode register of DMAp (0 to 2). It specifies the receive and transmit operation modes and commands. This register should be the last register written during DMA initialization. DMAP_CONTROL (offset 0x1018+Px0x100 (P = 0~2), total reset 0x0000_0000; PROVEN: Hi3535 data sheet, PDF page 850, section 5.6).";
        field {
            name = "reserved";
            desc = "Reserved.";
            sw = r; hw = w;
            reset = 0x0;
        } reserved_31_26[31:26];
        field {
            name = "rsf";
            desc = "RSF: receive store and forward.
- 0: Receive store and forward is not performed. The RxFIFO decides whether to forward according to the FIFO threshold.
- 1: Receive store and forward is performed. The RxFIFO forwards a frame upward only after it has received the complete frame.";
            sw = rw; hw = r;
            reset = 0x0;
        } rsf[25:25];
        field {
            name = "dff";
            desc = "DFF: Disable flushing of received frames.
- 0: Enable flushing of received frames. When this bit is 0, the RxDMA flushes any frame if the receive descriptor or receive buffer is unavailable;
- 1: Disable flushing of received frames. When this bit is 1, the RxDMA does not flush any frame because of an unavailable receive descriptor or receive buffer.";
            sw = rw; hw = r;
            reset = 0x0;
        } dff[24:24];
        field {
            name = "rfa2";
            desc = "RFA[2]: high bit of the flow control activation threshold.
- 0: When this bit is 0, the flow control threshold is set according to RFA;
- 1: When this bit is 1, the flow control activation threshold is determined jointly by this bit and RFA. The activation threshold varies with {rfa2,rfa[1:0]} as follows:
- 100: Full minus 5 KB;
- 101: Full minus 6 KB;
- 110: Full minus 7 KB;
- 111: Reserved.";
            sw = rw; hw = r;
            reset = 0x0;
        } rfa2[23:23];
        field {
            name = "rfd2";
            desc = "RFD[2]: upper bit of the flow control deactivation threshold.
- 0: When this bit is 0, the flow control deactivation threshold is set according to RFD.
- 1: When this bit is 1, the flow control deactivation threshold is determined jointly by this bit and RFD. The deactivation threshold varies with {rfd2,rfd[1:0]} as follows:
- 100: Full minus 5 KB;
- 101: Full minus 6 KB;
- 110: Full minus 7 KB;
- 111: Reserved.";
            sw = rw; hw = r;
            reset = 0x0;
        } rfd2[22:22];
        field {
            name = "tsf";
            desc = "TSF: transmit store and forward.
- 0: Transmit store and forward is not performed. The TxFIFO decides whether to forward based on the FIFO threshold;
- 1: Transmit store and forward is performed. The TxFIFO forwards a frame to the MAC only after receiving the complete frame.";
            sw = rw; hw = r;
            reset = 0x0;
        } tsf[21:21];
        field {
            name = "ftf";
            desc = "FTF: flush TxFIFO.
- 0: Do not flush the TxFIFO.
- 1: Flush the TxFIFO. When this bit is set to 1, all control logic of the TxFIFO is reset and the data in the TxFIFO is lost. This bit is cleared automatically after the flush completes. During the flush, the operation mode register cannot be written. Data already accepted by the GMAC transmitter is not flushed. This operation causes

FIFO underflow and the sending of runt frames. (data sheet access type RWC)";
            sw = rw; hw = rw; onwrite = woclr;
            reset = 0x0;
        } ftf[20:20];
        field {
            name = "reserved";
            desc = "Reserved.";
            sw = r; hw = w;
            reset = 0x0;
        } reserved_19_17[19:17];
        field {
            name = "ttc";
            desc = "TTC: Transmit threshold control. Controls the TxFIFO threshold for starting the TxDMA. When the number of bytes in the RxFIFO is greater than or equal to this threshold, the TxDMA is started for processing. This bit is valid only when TSF is 0.
- 000: 64;
- 001: 128;
- 010: 192;
- 011: 256;
- 100: 40;
- 101: 32;
- 110: 24;
- 111: 16.";
            sw = rw; hw = r;
            reset = 0x0;
        } ttc[16:14];
        field {
            name = "st";
            desc = "ST: start/stop transmission command.
- 1: When this bit is 1, the transmit process enters the running state. The DMA tries to fetch a descriptor from the transmit queue. The descriptor is fetched from the DMAp_XMT_BASE_ADDR register or from the position saved when the transmit state machine last stopped. If no descriptor is available, the TxDMA enters the suspended state and transmit buffer unavailable (DMAp_STATUS[2]) is set to 1. Note that when this bit is set to 1, it takes effect only when transmission is stopped, and it works correctly only after the DMAp_XMT_BASE_ADDR configuration has taken effect.
- 0: When this bit is 0, the TxDMA stops operation after the current frame is processed. The position of the next descriptor in the queue is saved and becomes the current position when the transmit process restarts. Setting this bit to 0 is effective only when the transmit process is in the running or suspended state.";
            sw = rw; hw = r;
            reset = 0x0;
        } st[13:13];
        field {
            name = "rfd";
            desc = "RFD: threshold for deactivating flow control (in both HD and FD). These bits control the RxFIFO fill level below which flow control is deactivated after it has been activated.
- 00: Full minus 1 KB;
- 01: Full minus 2 KB;
- 10: Full minus 3 KB;
- 11: Full minus 4 KB.
The above is valid only after flow control is activated and when the RxFIFO depth exceeds 4KB. If the RxFIFO depth exceeds 8KB, RFD[2] in bit 22 can determine additional deactivation thresholds.";
            sw = rw; hw = r;
            reset = 0x0;
        } rfd[12:11];
        field {
            name = "rfa";
            desc = "RFA: Threshold for activating flow control (in both HD and FD). These bits control the start of flow control when the RxFIFO fill level exceeds this threshold.
- 00: Full minus 1 KB;
- 01: Full minus 2 KB;
- 10: Full minus 3 KB;
- 11: Full minus 4 KB. The above is valid only when EFC is set to 1 and the RxFIFO depth exceeds 4 KB. If the RxFIFO depth exceeds 8 KB, RFA[2] in bit 23 can determine further flow control thresholds.";
            sw = rw; hw = r;
            reset = 0x0;
        } rfa[10:9];
        field {
            name = "efc";
            desc = "EFC: enable hardware flow control.
- 0: Hardware flow control disabled.
- 1: Hardware flow control enabled. The hardware implements flow control depending on how full or empty the FIFO is.";
            sw = rw; hw = r;
            reset = 0x0;
        } efc[8:8];
        field {
            name = "fef";
            desc = "FEF: forward error frames.
- 0: When this bit is 0, the RxFIFO drops all frames with errors (including CRC errors, collision errors, gmii_er, oversize frames, watchdog timeout, overflow, and so on). However, in threshold mode, a frame cannot be dropped if its start pointer has already been obtained by the receive controller;
- 1: When this bit is 1, all frames except runt frames are forwarded to the DMA. Frames with FIFO overflow errors are still dropped.";
            sw = rw; hw = r;
            reset = 0x0;
        } fef[7:7];
        field {
            name = "fuf";
            desc = "FUF: forward undersized good frames.
- 0: When this bit is 0, the RxFIFO drops all undersized frames smaller than the receive threshold;
- 1: When this bit is 1, the RxFIFO forwards all error-free frames shorter than 64 bytes (including padding bytes and CRC).";
            sw = rw; hw = r;
            reset = 0x0;
        } fuf[6:6];
        field {
            name = "reserved";
            desc = "Reserved.";
            sw = r; hw = w;
            reset = 0x0;
        } reserved_5_5[5:5];
        field {
            name = "rtc";
            desc = "RTC: Receive threshold control. Controls the RxFIFO threshold for starting the RxDMA. When the number of bytes in the RxFIFO is greater than or equal to this threshold, the RxDMA is started for processing. This bit is valid only when RSF is 0.
- 00: 64;
- 01: 32;
- 10: 96;
- 11: 128.";
            sw = rw; hw = r;
            reset = 0x0;
        } rtc[4:3];
        field {
            name = "osf";
            desc = "OSF: operate on second frame.
- 0: Do not operate on the second frame;
- 1: Operate on the second frame. The DMA can then start processing the second frame before obtaining the status of the previous frame.";
            sw = rw; hw = r;
            reset = 0x0;
        } osf[2:2];
        field {
            name = "sr";
            desc = "SR: start/stop receive.
- 0: When this bit is 0, the RxDMA stops operating after the current frame has been processed. The position of the next descriptor in the receive queue is saved and becomes the current position when the receive process is restarted. Setting this bit to 0 is effective only when the receive process is in the running or suspended state.
- 1: When this bit is 1, the receive process enters the running state. The DMA tries to fetch descriptors from the receive queue and processes incoming frames. Descriptors are fetched from the

DMAp_RCV_BASE_ADDR register or from the position saved when the receive state machine last stopped. If no descriptor is available, the receive DMA enters the suspended state and receive buffer unavailable (DMAp_STATUS[7]) is set to 1. Note that setting this bit to 1 takes effect only when reception is stopped, and it works correctly only after the DMAp_RCV_BASE_ADDR configuration has taken effect.";
            sw = rw; hw = r;
            reset = 0x0;
        } sr[1:1];
        field {
            name = "reserved";
            desc = "Reserved.";
            sw = r; hw = w;
            reset = 0x0;
        } reserved_0_0[0:0];
    } DMAP_CONTROL_1 @ 0x1118;
    reg {
        name = "DMAP_CONTROL";
        desc = "DMAP_CONTROL is the operation mode register of DMAp (0 to 2). It specifies the receive and transmit operation modes and commands. This register should be the last register written during DMA initialization. DMAP_CONTROL (offset 0x1018+Px0x100 (P = 0~2), total reset 0x0000_0000; PROVEN: Hi3535 data sheet, PDF page 850, section 5.6).";
        field {
            name = "reserved";
            desc = "Reserved.";
            sw = r; hw = w;
            reset = 0x0;
        } reserved_31_26[31:26];
        field {
            name = "rsf";
            desc = "RSF: receive store and forward.
- 0: Receive store and forward is not performed. The RxFIFO decides whether to forward according to the FIFO threshold.
- 1: Receive store and forward is performed. The RxFIFO forwards a frame upward only after it has received the complete frame.";
            sw = rw; hw = r;
            reset = 0x0;
        } rsf[25:25];
        field {
            name = "dff";
            desc = "DFF: Disable flushing of received frames.
- 0: Enable flushing of received frames. When this bit is 0, the RxDMA flushes any frame if the receive descriptor or receive buffer is unavailable;
- 1: Disable flushing of received frames. When this bit is 1, the RxDMA does not flush any frame because of an unavailable receive descriptor or receive buffer.";
            sw = rw; hw = r;
            reset = 0x0;
        } dff[24:24];
        field {
            name = "rfa2";
            desc = "RFA[2]: high bit of the flow control activation threshold.
- 0: When this bit is 0, the flow control threshold is set according to RFA;
- 1: When this bit is 1, the flow control activation threshold is determined jointly by this bit and RFA. The activation threshold varies with {rfa2,rfa[1:0]} as follows:
- 100: Full minus 5 KB;
- 101: Full minus 6 KB;
- 110: Full minus 7 KB;
- 111: Reserved.";
            sw = rw; hw = r;
            reset = 0x0;
        } rfa2[23:23];
        field {
            name = "rfd2";
            desc = "RFD[2]: upper bit of the flow control deactivation threshold.
- 0: When this bit is 0, the flow control deactivation threshold is set according to RFD.
- 1: When this bit is 1, the flow control deactivation threshold is determined jointly by this bit and RFD. The deactivation threshold varies with {rfd2,rfd[1:0]} as follows:
- 100: Full minus 5 KB;
- 101: Full minus 6 KB;
- 110: Full minus 7 KB;
- 111: Reserved.";
            sw = rw; hw = r;
            reset = 0x0;
        } rfd2[22:22];
        field {
            name = "tsf";
            desc = "TSF: transmit store and forward.
- 0: Transmit store and forward is not performed. The TxFIFO decides whether to forward based on the FIFO threshold;
- 1: Transmit store and forward is performed. The TxFIFO forwards a frame to the MAC only after receiving the complete frame.";
            sw = rw; hw = r;
            reset = 0x0;
        } tsf[21:21];
        field {
            name = "ftf";
            desc = "FTF: flush TxFIFO.
- 0: Do not flush the TxFIFO.
- 1: Flush the TxFIFO. When this bit is set to 1, all control logic of the TxFIFO is reset and the data in the TxFIFO is lost. This bit is cleared automatically after the flush completes. During the flush, the operation mode register cannot be written. Data already accepted by the GMAC transmitter is not flushed. This operation causes

FIFO underflow and the sending of runt frames. (data sheet access type RWC)";
            sw = rw; hw = rw; onwrite = woclr;
            reset = 0x0;
        } ftf[20:20];
        field {
            name = "reserved";
            desc = "Reserved.";
            sw = r; hw = w;
            reset = 0x0;
        } reserved_19_17[19:17];
        field {
            name = "ttc";
            desc = "TTC: Transmit threshold control. Controls the TxFIFO threshold for starting the TxDMA. When the number of bytes in the RxFIFO is greater than or equal to this threshold, the TxDMA is started for processing. This bit is valid only when TSF is 0.
- 000: 64;
- 001: 128;
- 010: 192;
- 011: 256;
- 100: 40;
- 101: 32;
- 110: 24;
- 111: 16.";
            sw = rw; hw = r;
            reset = 0x0;
        } ttc[16:14];
        field {
            name = "st";
            desc = "ST: start/stop transmission command.
- 1: When this bit is 1, the transmit process enters the running state. The DMA tries to fetch a descriptor from the transmit queue. The descriptor is fetched from the DMAp_XMT_BASE_ADDR register or from the position saved when the transmit state machine last stopped. If no descriptor is available, the TxDMA enters the suspended state and transmit buffer unavailable (DMAp_STATUS[2]) is set to 1. Note that when this bit is set to 1, it takes effect only when transmission is stopped, and it works correctly only after the DMAp_XMT_BASE_ADDR configuration has taken effect.
- 0: When this bit is 0, the TxDMA stops operation after the current frame is processed. The position of the next descriptor in the queue is saved and becomes the current position when the transmit process restarts. Setting this bit to 0 is effective only when the transmit process is in the running or suspended state.";
            sw = rw; hw = r;
            reset = 0x0;
        } st[13:13];
        field {
            name = "rfd";
            desc = "RFD: threshold for deactivating flow control (in both HD and FD). These bits control the RxFIFO fill level below which flow control is deactivated after it has been activated.
- 00: Full minus 1 KB;
- 01: Full minus 2 KB;
- 10: Full minus 3 KB;
- 11: Full minus 4 KB.
The above is valid only after flow control is activated and when the RxFIFO depth exceeds 4KB. If the RxFIFO depth exceeds 8KB, RFD[2] in bit 22 can determine additional deactivation thresholds.";
            sw = rw; hw = r;
            reset = 0x0;
        } rfd[12:11];
        field {
            name = "rfa";
            desc = "RFA: Threshold for activating flow control (in both HD and FD). These bits control the start of flow control when the RxFIFO fill level exceeds this threshold.
- 00: Full minus 1 KB;
- 01: Full minus 2 KB;
- 10: Full minus 3 KB;
- 11: Full minus 4 KB. The above is valid only when EFC is set to 1 and the RxFIFO depth exceeds 4 KB. If the RxFIFO depth exceeds 8 KB, RFA[2] in bit 23 can determine further flow control thresholds.";
            sw = rw; hw = r;
            reset = 0x0;
        } rfa[10:9];
        field {
            name = "efc";
            desc = "EFC: enable hardware flow control.
- 0: Hardware flow control disabled.
- 1: Hardware flow control enabled. The hardware implements flow control depending on how full or empty the FIFO is.";
            sw = rw; hw = r;
            reset = 0x0;
        } efc[8:8];
        field {
            name = "fef";
            desc = "FEF: forward error frames.
- 0: When this bit is 0, the RxFIFO drops all frames with errors (including CRC errors, collision errors, gmii_er, oversize frames, watchdog timeout, overflow, and so on). However, in threshold mode, a frame cannot be dropped if its start pointer has already been obtained by the receive controller;
- 1: When this bit is 1, all frames except runt frames are forwarded to the DMA. Frames with FIFO overflow errors are still dropped.";
            sw = rw; hw = r;
            reset = 0x0;
        } fef[7:7];
        field {
            name = "fuf";
            desc = "FUF: forward undersized good frames.
- 0: When this bit is 0, the RxFIFO drops all undersized frames smaller than the receive threshold;
- 1: When this bit is 1, the RxFIFO forwards all error-free frames shorter than 64 bytes (including padding bytes and CRC).";
            sw = rw; hw = r;
            reset = 0x0;
        } fuf[6:6];
        field {
            name = "reserved";
            desc = "Reserved.";
            sw = r; hw = w;
            reset = 0x0;
        } reserved_5_5[5:5];
        field {
            name = "rtc";
            desc = "RTC: Receive threshold control. Controls the RxFIFO threshold for starting the RxDMA. When the number of bytes in the RxFIFO is greater than or equal to this threshold, the RxDMA is started for processing. This bit is valid only when RSF is 0.
- 00: 64;
- 01: 32;
- 10: 96;
- 11: 128.";
            sw = rw; hw = r;
            reset = 0x0;
        } rtc[4:3];
        field {
            name = "osf";
            desc = "OSF: operate on second frame.
- 0: Do not operate on the second frame;
- 1: Operate on the second frame. The DMA can then start processing the second frame before obtaining the status of the previous frame.";
            sw = rw; hw = r;
            reset = 0x0;
        } osf[2:2];
        field {
            name = "sr";
            desc = "SR: start/stop receive.
- 0: When this bit is 0, the RxDMA stops operating after the current frame has been processed. The position of the next descriptor in the receive queue is saved and becomes the current position when the receive process is restarted. Setting this bit to 0 is effective only when the receive process is in the running or suspended state.
- 1: When this bit is 1, the receive process enters the running state. The DMA tries to fetch descriptors from the receive queue and processes incoming frames. Descriptors are fetched from the

DMAp_RCV_BASE_ADDR register or from the position saved when the receive state machine last stopped. If no descriptor is available, the receive DMA enters the suspended state and receive buffer unavailable (DMAp_STATUS[7]) is set to 1. Note that setting this bit to 1 takes effect only when reception is stopped, and it works correctly only after the DMAp_RCV_BASE_ADDR configuration has taken effect.";
            sw = rw; hw = r;
            reset = 0x0;
        } sr[1:1];
        field {
            name = "reserved";
            desc = "Reserved.";
            sw = r; hw = w;
            reset = 0x0;
        } reserved_0_0[0:0];
    } DMAP_CONTROL_2 @ 0x1218;
    reg {
        name = "DMAP_INTR_ENA";
        desc = "DMAP_INTR_ENA is the interrupt enable register of DMAp (0 to 2). It enables the interrupts reported by DMAp_STATUS. After a soft reset or hard reset,. DMAP_INTR_ENA (offset 0x101C+Px0x100 (P = 0~2), total reset 0x0000_0000; PROVEN: Hi3535 data sheet, PDF page 854, section 5.6).";
        field {
            name = "reserved";
            desc = "Reserved.";
            sw = r; hw = w;
            reset = 0x0;
        } reserved_31_17[31:17];
        field {
            name = "nie";
            desc = "NIE: normal interrupt summary enable.
- 0: Disable the normal interrupt summary;
- 1: Enable the normal interrupt summary. The normal interrupts enabled by this bit are: DMAp_STATUS[0], DMAp_STATUS[2], DMAp_STATUS[6], DMAp_STATUS[14]";
            sw = rw; hw = r;
            reset = 0x0;
        } nie[16:16];
        field {
            name = "aie";
            desc = "AIE: abnormal interrupt summary enable.
- 0: Disable the abnormal interrupt summary;
- 1: Enable the abnormal interrupt summary. The abnormal interrupts enabled by this bit are: DMAp_STATUS[1], DMAp_STATUS[3], DMAp_STATUS[4], DMAp_STATUS[5], DMAp_STATUS[7], DMAp_STATUS[8], DMAp_STATUS[9], DMAp_STATUS[10], DMAp_STATUS[13]";
            sw = rw; hw = r;
            reset = 0x0;
        } aie[15:15];
        field {
            name = "ere";
            desc = "ERE: early receive interrupt enable.
- 0: Early receive interrupt disabled;
- 1: Early receive interrupt enabled when the normal interrupt summary enable is 1.";
            sw = rw; hw = r;
            reset = 0x0;
        } ere[14:14];
        field {
            name = "fbe";
            desc = "FBE: fatal bus error enable.
- 0: Fatal bus error disabled;
- 1: Fatal bus error enabled when the abnormal interrupt summary enable is 1.";
            sw = rw; hw = r;
            reset = 0x0;
        } fbe[13:13];
        field {
            name = "reserved";
            desc = "Reserved.";
            sw = r; hw = w;
            reset = 0x0;
        } reserved_12_11[12:11];
        field {
            name = "ete";
            desc = "ETE: Early transmit interrupt enable.
- 0: Early transmit interrupt disabled.
- 1: Early transmit interrupt enabled when the abnormal interrupt summary enable is 1.";
            sw = rw; hw = r;
            reset = 0x0;
        } ete[10:10];
        field {
            name = "rwe";
            desc = "RWE: receive watchdog timeout enable.
- 0: Receive watchdog timeout disabled.
- 1: Receive watchdog timeout enabled when the abnormal interrupt summary enable is 1.";
            sw = rw; hw = r;
            reset = 0x0;
        } rwe[9:9];
        field {
            name = "rse";
            desc = "RSE: Receive stopped enable.
- 0: Receive stopped interrupt disabled.
- 1: Receive stopped interrupt enabled when the abnormal interrupt summary enable is 1.";
            sw = rw; hw = r;
            reset = 0x0;
        } rse[8:8];
        field {
            name = "rue";
            desc = "RUE: receive buffer unavailable enable.
- 0: Disable receive buffer unavailable;
- 1: When the abnormal interrupt summary enable is 1, enable receive buffer unavailable.";
            sw = rw; hw = r;
            reset = 0x0;
        } rue[7:7];
        field {
            name = "rie";
            desc = "RIE: receive interrupt enable.
- 0: Receive interrupt disabled;
- 1: Receive interrupt enabled when the normal interrupt summary enable is 1.";
            sw = rw; hw = r;
            reset = 0x0;
        } rie[6:6];
        field {
            name = "une";
            desc = "UNE: Underflow interrupt enable.
- 0: Underflow interrupt disabled;
- 1: Underflow interrupt enabled when the abnormal interrupt summary enable is 1.";
            sw = rw; hw = r;
            reset = 0x0;
        } une[5:5];
        field {
            name = "ove";
            desc = "OVE: Overflow interrupt enable.
- 0: Overflow interrupt disabled.
- 1: Overflow interrupt enabled when the abnormal interrupt summary enable is 1.";
            sw = rw; hw = r;
            reset = 0x0;
        } ove[4:4];
        field {
            name = "tje";
            desc = "TJE: transmit jabber timeout enable.
- 0: Transmit jabber timeout disabled.
- 1: Transmit jabber timeout enabled when the abnormal interrupt summary enable is 1.";
            sw = rw; hw = r;
            reset = 0x0;
        } tje[3:3];
        field {
            name = "tue";
            desc = "TUE: transmit buffer unavailable enable.
- 0: Disable transmit buffer unavailable;
- 1: When the normal interrupt summary enable is 1, enable transmit buffer unavailable.";
            sw = rw; hw = r;
            reset = 0x0;
        } tue[2:2];
        field {
            name = "tse";
            desc = "TSE: Transmit stop enable.
- 0: Transmit stop disabled;
- 1: Transmit stop enabled when the abnormal interrupt summary enable is 6.";
            sw = rw; hw = r;
            reset = 0x0;
        } tse[1:1];
        field {
            name = "tie";
            desc = "TIE: Transmit interrupt enable.
- 0: Transmit interrupt disabled;
- 1: Transmit interrupt enabled when the normal interrupt summary enable is 1.";
            sw = rw; hw = r;
            reset = 0x0;
        } tie[0:0];
    } DMAP_INTR_ENA_0 @ 0x101c;
    reg {
        name = "DMAP_INTR_ENA";
        desc = "DMAP_INTR_ENA is the interrupt enable register of DMAp (0 to 2). It enables the interrupts reported by DMAp_STATUS. After a soft reset or hard reset,. DMAP_INTR_ENA (offset 0x101C+Px0x100 (P = 0~2), total reset 0x0000_0000; PROVEN: Hi3535 data sheet, PDF page 854, section 5.6).";
        field {
            name = "reserved";
            desc = "Reserved.";
            sw = r; hw = w;
            reset = 0x0;
        } reserved_31_17[31:17];
        field {
            name = "nie";
            desc = "NIE: normal interrupt summary enable.
- 0: Disable the normal interrupt summary;
- 1: Enable the normal interrupt summary. The normal interrupts enabled by this bit are: DMAp_STATUS[0], DMAp_STATUS[2], DMAp_STATUS[6], DMAp_STATUS[14]";
            sw = rw; hw = r;
            reset = 0x0;
        } nie[16:16];
        field {
            name = "aie";
            desc = "AIE: abnormal interrupt summary enable.
- 0: Disable the abnormal interrupt summary;
- 1: Enable the abnormal interrupt summary. The abnormal interrupts enabled by this bit are: DMAp_STATUS[1], DMAp_STATUS[3], DMAp_STATUS[4], DMAp_STATUS[5], DMAp_STATUS[7], DMAp_STATUS[8], DMAp_STATUS[9], DMAp_STATUS[10], DMAp_STATUS[13]";
            sw = rw; hw = r;
            reset = 0x0;
        } aie[15:15];
        field {
            name = "ere";
            desc = "ERE: early receive interrupt enable.
- 0: Early receive interrupt disabled;
- 1: Early receive interrupt enabled when the normal interrupt summary enable is 1.";
            sw = rw; hw = r;
            reset = 0x0;
        } ere[14:14];
        field {
            name = "fbe";
            desc = "FBE: fatal bus error enable.
- 0: Fatal bus error disabled;
- 1: Fatal bus error enabled when the abnormal interrupt summary enable is 1.";
            sw = rw; hw = r;
            reset = 0x0;
        } fbe[13:13];
        field {
            name = "reserved";
            desc = "Reserved.";
            sw = r; hw = w;
            reset = 0x0;
        } reserved_12_11[12:11];
        field {
            name = "ete";
            desc = "ETE: Early transmit interrupt enable.
- 0: Early transmit interrupt disabled.
- 1: Early transmit interrupt enabled when the abnormal interrupt summary enable is 1.";
            sw = rw; hw = r;
            reset = 0x0;
        } ete[10:10];
        field {
            name = "rwe";
            desc = "RWE: receive watchdog timeout enable.
- 0: Receive watchdog timeout disabled.
- 1: Receive watchdog timeout enabled when the abnormal interrupt summary enable is 1.";
            sw = rw; hw = r;
            reset = 0x0;
        } rwe[9:9];
        field {
            name = "rse";
            desc = "RSE: Receive stopped enable.
- 0: Receive stopped interrupt disabled.
- 1: Receive stopped interrupt enabled when the abnormal interrupt summary enable is 1.";
            sw = rw; hw = r;
            reset = 0x0;
        } rse[8:8];
        field {
            name = "rue";
            desc = "RUE: receive buffer unavailable enable.
- 0: Disable receive buffer unavailable;
- 1: When the abnormal interrupt summary enable is 1, enable receive buffer unavailable.";
            sw = rw; hw = r;
            reset = 0x0;
        } rue[7:7];
        field {
            name = "rie";
            desc = "RIE: receive interrupt enable.
- 0: Receive interrupt disabled;
- 1: Receive interrupt enabled when the normal interrupt summary enable is 1.";
            sw = rw; hw = r;
            reset = 0x0;
        } rie[6:6];
        field {
            name = "une";
            desc = "UNE: Underflow interrupt enable.
- 0: Underflow interrupt disabled;
- 1: Underflow interrupt enabled when the abnormal interrupt summary enable is 1.";
            sw = rw; hw = r;
            reset = 0x0;
        } une[5:5];
        field {
            name = "ove";
            desc = "OVE: Overflow interrupt enable.
- 0: Overflow interrupt disabled.
- 1: Overflow interrupt enabled when the abnormal interrupt summary enable is 1.";
            sw = rw; hw = r;
            reset = 0x0;
        } ove[4:4];
        field {
            name = "tje";
            desc = "TJE: transmit jabber timeout enable.
- 0: Transmit jabber timeout disabled.
- 1: Transmit jabber timeout enabled when the abnormal interrupt summary enable is 1.";
            sw = rw; hw = r;
            reset = 0x0;
        } tje[3:3];
        field {
            name = "tue";
            desc = "TUE: transmit buffer unavailable enable.
- 0: Disable transmit buffer unavailable;
- 1: When the normal interrupt summary enable is 1, enable transmit buffer unavailable.";
            sw = rw; hw = r;
            reset = 0x0;
        } tue[2:2];
        field {
            name = "tse";
            desc = "TSE: Transmit stop enable.
- 0: Transmit stop disabled;
- 1: Transmit stop enabled when the abnormal interrupt summary enable is 6.";
            sw = rw; hw = r;
            reset = 0x0;
        } tse[1:1];
        field {
            name = "tie";
            desc = "TIE: Transmit interrupt enable.
- 0: Transmit interrupt disabled;
- 1: Transmit interrupt enabled when the normal interrupt summary enable is 1.";
            sw = rw; hw = r;
            reset = 0x0;
        } tie[0:0];
    } DMAP_INTR_ENA_1 @ 0x111c;
    reg {
        name = "DMAP_INTR_ENA";
        desc = "DMAP_INTR_ENA is the interrupt enable register of DMAp (0 to 2). It enables the interrupts reported by DMAp_STATUS. After a soft reset or hard reset,. DMAP_INTR_ENA (offset 0x101C+Px0x100 (P = 0~2), total reset 0x0000_0000; PROVEN: Hi3535 data sheet, PDF page 854, section 5.6).";
        field {
            name = "reserved";
            desc = "Reserved.";
            sw = r; hw = w;
            reset = 0x0;
        } reserved_31_17[31:17];
        field {
            name = "nie";
            desc = "NIE: normal interrupt summary enable.
- 0: Disable the normal interrupt summary;
- 1: Enable the normal interrupt summary. The normal interrupts enabled by this bit are: DMAp_STATUS[0], DMAp_STATUS[2], DMAp_STATUS[6], DMAp_STATUS[14]";
            sw = rw; hw = r;
            reset = 0x0;
        } nie[16:16];
        field {
            name = "aie";
            desc = "AIE: abnormal interrupt summary enable.
- 0: Disable the abnormal interrupt summary;
- 1: Enable the abnormal interrupt summary. The abnormal interrupts enabled by this bit are: DMAp_STATUS[1], DMAp_STATUS[3], DMAp_STATUS[4], DMAp_STATUS[5], DMAp_STATUS[7], DMAp_STATUS[8], DMAp_STATUS[9], DMAp_STATUS[10], DMAp_STATUS[13]";
            sw = rw; hw = r;
            reset = 0x0;
        } aie[15:15];
        field {
            name = "ere";
            desc = "ERE: early receive interrupt enable.
- 0: Early receive interrupt disabled;
- 1: Early receive interrupt enabled when the normal interrupt summary enable is 1.";
            sw = rw; hw = r;
            reset = 0x0;
        } ere[14:14];
        field {
            name = "fbe";
            desc = "FBE: fatal bus error enable.
- 0: Fatal bus error disabled;
- 1: Fatal bus error enabled when the abnormal interrupt summary enable is 1.";
            sw = rw; hw = r;
            reset = 0x0;
        } fbe[13:13];
        field {
            name = "reserved";
            desc = "Reserved.";
            sw = r; hw = w;
            reset = 0x0;
        } reserved_12_11[12:11];
        field {
            name = "ete";
            desc = "ETE: Early transmit interrupt enable.
- 0: Early transmit interrupt disabled.
- 1: Early transmit interrupt enabled when the abnormal interrupt summary enable is 1.";
            sw = rw; hw = r;
            reset = 0x0;
        } ete[10:10];
        field {
            name = "rwe";
            desc = "RWE: receive watchdog timeout enable.
- 0: Receive watchdog timeout disabled.
- 1: Receive watchdog timeout enabled when the abnormal interrupt summary enable is 1.";
            sw = rw; hw = r;
            reset = 0x0;
        } rwe[9:9];
        field {
            name = "rse";
            desc = "RSE: Receive stopped enable.
- 0: Receive stopped interrupt disabled.
- 1: Receive stopped interrupt enabled when the abnormal interrupt summary enable is 1.";
            sw = rw; hw = r;
            reset = 0x0;
        } rse[8:8];
        field {
            name = "rue";
            desc = "RUE: receive buffer unavailable enable.
- 0: Disable receive buffer unavailable;
- 1: When the abnormal interrupt summary enable is 1, enable receive buffer unavailable.";
            sw = rw; hw = r;
            reset = 0x0;
        } rue[7:7];
        field {
            name = "rie";
            desc = "RIE: receive interrupt enable.
- 0: Receive interrupt disabled;
- 1: Receive interrupt enabled when the normal interrupt summary enable is 1.";
            sw = rw; hw = r;
            reset = 0x0;
        } rie[6:6];
        field {
            name = "une";
            desc = "UNE: Underflow interrupt enable.
- 0: Underflow interrupt disabled;
- 1: Underflow interrupt enabled when the abnormal interrupt summary enable is 1.";
            sw = rw; hw = r;
            reset = 0x0;
        } une[5:5];
        field {
            name = "ove";
            desc = "OVE: Overflow interrupt enable.
- 0: Overflow interrupt disabled.
- 1: Overflow interrupt enabled when the abnormal interrupt summary enable is 1.";
            sw = rw; hw = r;
            reset = 0x0;
        } ove[4:4];
        field {
            name = "tje";
            desc = "TJE: transmit jabber timeout enable.
- 0: Transmit jabber timeout disabled.
- 1: Transmit jabber timeout enabled when the abnormal interrupt summary enable is 1.";
            sw = rw; hw = r;
            reset = 0x0;
        } tje[3:3];
        field {
            name = "tue";
            desc = "TUE: transmit buffer unavailable enable.
- 0: Disable transmit buffer unavailable;
- 1: When the normal interrupt summary enable is 1, enable transmit buffer unavailable.";
            sw = rw; hw = r;
            reset = 0x0;
        } tue[2:2];
        field {
            name = "tse";
            desc = "TSE: Transmit stop enable.
- 0: Transmit stop disabled;
- 1: Transmit stop enabled when the abnormal interrupt summary enable is 6.";
            sw = rw; hw = r;
            reset = 0x0;
        } tse[1:1];
        field {
            name = "tie";
            desc = "TIE: Transmit interrupt enable.
- 0: Transmit interrupt disabled;
- 1: Transmit interrupt enabled when the normal interrupt summary enable is 1.";
            sw = rw; hw = r;
            reset = 0x0;
        } tie[0:0];
    } DMAP_INTR_ENA_2 @ 0x121c;
    reg {
        name = "DMAP_MISSED_FRAME_CTR";
        desc = "DMAP_MISSED_FRAME_CTR is the register of the two counters contained in DMAp (0 to 2) that track frames dropped during reception. This register holds the current values of the two counters, which are the dropped frame counts caused by the host receive buffer being unavailable and by FIFO overflow, respectively. DMAP_MISSED_FRAME_CTR (offset 0x1020+Px0x100 (P = 0~2), total reset 0x0000_0000; PROVEN: Hi3535 data sheet, PDF page 856, section 5.6).";
        field {
            name = "reserved";
            desc = "Reserved.";
            sw = r; hw = w;
            reset = 0x0;
        } reserved_31_29[31:29];
        field {
            name = "ob_fifo_overflow_cnt";
            desc = "Overflow indication signal of the FIFO overflow counter. (data sheet access type RC)";
            sw = r; hw = w; onread = rclr;
            reset = 0x0;
        } ob_fifo_overflow_cnt[28:28];
        field {
            name = "app_miss_frms";
            desc = "Indicates the number of frames discarded by the application. The counter increments by 1 each time the mtl_rxoverflow_o signal goes high; it is cleared when the counter is read and mci_be_i[2] is 1. (data sheet access type RC)";
            sw = r; hw = w; onread = rclr;
            reset = 0x0;
        } app_miss_frms[27:17];
        field {
            name = "ob_miss_frms_cnt";
            desc = "Overflow indication signal of the dropped frame counter. (data sheet access type RC)";
            sw = r; hw = w; onread = rclr;
            reset = 0x0;
        } ob_miss_frms_cnt[16:16];
        field {
            name = "ctrl_miss_frms";
            desc = "Indicates the number of frames dropped by the GMAC because no host receive buffer was available. The counter increments by 1 each time the DMA drops a received frame, and is cleared when the counter is read while mci_be_i[0] is 1. (data sheet access type RC)";
            sw = r; hw = w; onread = rclr;
            reset = 0x0;
        } ctrl_miss_frms[15:0];
    } DMAP_MISSED_FRAME_CTR_0 @ 0x1020;
    reg {
        name = "DMAP_MISSED_FRAME_CTR";
        desc = "DMAP_MISSED_FRAME_CTR is the register of the two counters contained in DMAp (0 to 2) that track frames dropped during reception. This register holds the current values of the two counters, which are the dropped frame counts caused by the host receive buffer being unavailable and by FIFO overflow, respectively. DMAP_MISSED_FRAME_CTR (offset 0x1020+Px0x100 (P = 0~2), total reset 0x0000_0000; PROVEN: Hi3535 data sheet, PDF page 856, section 5.6).";
        field {
            name = "reserved";
            desc = "Reserved.";
            sw = r; hw = w;
            reset = 0x0;
        } reserved_31_29[31:29];
        field {
            name = "ob_fifo_overflow_cnt";
            desc = "Overflow indication signal of the FIFO overflow counter. (data sheet access type RC)";
            sw = r; hw = w; onread = rclr;
            reset = 0x0;
        } ob_fifo_overflow_cnt[28:28];
        field {
            name = "app_miss_frms";
            desc = "Indicates the number of frames discarded by the application. The counter increments by 1 each time the mtl_rxoverflow_o signal goes high; it is cleared when the counter is read and mci_be_i[2] is 1. (data sheet access type RC)";
            sw = r; hw = w; onread = rclr;
            reset = 0x0;
        } app_miss_frms[27:17];
        field {
            name = "ob_miss_frms_cnt";
            desc = "Overflow indication signal of the dropped frame counter. (data sheet access type RC)";
            sw = r; hw = w; onread = rclr;
            reset = 0x0;
        } ob_miss_frms_cnt[16:16];
        field {
            name = "ctrl_miss_frms";
            desc = "Indicates the number of frames dropped by the GMAC because no host receive buffer was available. The counter increments by 1 each time the DMA drops a received frame, and is cleared when the counter is read while mci_be_i[0] is 1. (data sheet access type RC)";
            sw = r; hw = w; onread = rclr;
            reset = 0x0;
        } ctrl_miss_frms[15:0];
    } DMAP_MISSED_FRAME_CTR_1 @ 0x1120;
    reg {
        name = "DMAP_MISSED_FRAME_CTR";
        desc = "DMAP_MISSED_FRAME_CTR is the register of the two counters contained in DMAp (0 to 2) that track frames dropped during reception. This register holds the current values of the two counters, which are the dropped frame counts caused by the host receive buffer being unavailable and by FIFO overflow, respectively. DMAP_MISSED_FRAME_CTR (offset 0x1020+Px0x100 (P = 0~2), total reset 0x0000_0000; PROVEN: Hi3535 data sheet, PDF page 856, section 5.6).";
        field {
            name = "reserved";
            desc = "Reserved.";
            sw = r; hw = w;
            reset = 0x0;
        } reserved_31_29[31:29];
        field {
            name = "ob_fifo_overflow_cnt";
            desc = "Overflow indication signal of the FIFO overflow counter. (data sheet access type RC)";
            sw = r; hw = w; onread = rclr;
            reset = 0x0;
        } ob_fifo_overflow_cnt[28:28];
        field {
            name = "app_miss_frms";
            desc = "Indicates the number of frames discarded by the application. The counter increments by 1 each time the mtl_rxoverflow_o signal goes high; it is cleared when the counter is read and mci_be_i[2] is 1. (data sheet access type RC)";
            sw = r; hw = w; onread = rclr;
            reset = 0x0;
        } app_miss_frms[27:17];
        field {
            name = "ob_miss_frms_cnt";
            desc = "Overflow indication signal of the dropped frame counter. (data sheet access type RC)";
            sw = r; hw = w; onread = rclr;
            reset = 0x0;
        } ob_miss_frms_cnt[16:16];
        field {
            name = "ctrl_miss_frms";
            desc = "Indicates the number of frames dropped by the GMAC because no host receive buffer was available. The counter increments by 1 each time the DMA drops a received frame, and is cleared when the counter is read while mci_be_i[0] is 1. (data sheet access type RC)";
            sw = r; hw = w; onread = rclr;
            reset = 0x0;
        } ctrl_miss_frms[15:0];
    } DMAP_MISSED_FRAME_CTR_2 @ 0x1220;
    reg {
        name = "DMAP_CUR_TX_BUF_ADDR";
        desc = "DMAP_CUR_TX_BUF_ADDR is the current host transmit buffer address register of DMAp (0 to 2). It indicates the transmit buffer address that the DMA is reading. DMAP_CUR_TX_BUF_ADDR (offset 0x1050+Px0x100 (P = 0~2), total reset 0x0000_0000; PROVEN: Hi3535 data sheet, PDF page 857, section 5.6).";
        field {
            name = "curr_tx_buf_addr";
            desc = "Current host transmit buffer address register, indicating the transmit buffer address the DMA is currently reading.";
            sw = r; hw = w;
            reset = 0x0;
        } curr_tx_buf_addr[31:0];
    } DMAP_CUR_TX_BUF_ADDR_0 @ 0x1050;
    reg {
        name = "DMAP_CUR_TX_BUF_ADDR";
        desc = "DMAP_CUR_TX_BUF_ADDR is the current host transmit buffer address register of DMAp (0 to 2). It indicates the transmit buffer address that the DMA is reading. DMAP_CUR_TX_BUF_ADDR (offset 0x1050+Px0x100 (P = 0~2), total reset 0x0000_0000; PROVEN: Hi3535 data sheet, PDF page 857, section 5.6).";
        field {
            name = "curr_tx_buf_addr";
            desc = "Current host transmit buffer address register, indicating the transmit buffer address the DMA is currently reading.";
            sw = r; hw = w;
            reset = 0x0;
        } curr_tx_buf_addr[31:0];
    } DMAP_CUR_TX_BUF_ADDR_1 @ 0x1150;
    reg {
        name = "DMAP_CUR_TX_BUF_ADDR";
        desc = "DMAP_CUR_TX_BUF_ADDR is the current host transmit buffer address register of DMAp (0 to 2). It indicates the transmit buffer address that the DMA is reading. DMAP_CUR_TX_BUF_ADDR (offset 0x1050+Px0x100 (P = 0~2), total reset 0x0000_0000; PROVEN: Hi3535 data sheet, PDF page 857, section 5.6).";
        field {
            name = "curr_tx_buf_addr";
            desc = "Current host transmit buffer address register, indicating the transmit buffer address the DMA is currently reading.";
            sw = r; hw = w;
            reset = 0x0;
        } curr_tx_buf_addr[31:0];
    } DMAP_CUR_TX_BUF_ADDR_2 @ 0x1250;
    reg {
        name = "DMAP_CUR_RX_BUF_ADDR";
        desc = "DMAP_CUR_RX_BUF_ADDR is the DMAp (0 to 2) current host receive buffer address register. Indicates the receive buffer address the DMA is currently reading. DMAP_CUR_RX_BUF_ADDR (offset 0x1054+Px0x100 (P = 0~2), total reset 0x0000_0000; PROVEN: Hi3535 data sheet, PDF page 857, section 5.6).";
        field {
            name = "curr_rx_buff_addr";
            desc = "Current host receive buffer address register, indicating the receive buffer address that the DMA is reading.";
            sw = r; hw = w;
            reset = 0x0;
        } curr_rx_buff_addr[31:0];
    } DMAP_CUR_RX_BUF_ADDR_0 @ 0x1054;
    reg {
        name = "DMAP_CUR_RX_BUF_ADDR";
        desc = "DMAP_CUR_RX_BUF_ADDR is the DMAp (0 to 2) current host receive buffer address register. Indicates the receive buffer address the DMA is currently reading. DMAP_CUR_RX_BUF_ADDR (offset 0x1054+Px0x100 (P = 0~2), total reset 0x0000_0000; PROVEN: Hi3535 data sheet, PDF page 857, section 5.6).";
        field {
            name = "curr_rx_buff_addr";
            desc = "Current host receive buffer address register, indicating the receive buffer address that the DMA is reading.";
            sw = r; hw = w;
            reset = 0x0;
        } curr_rx_buff_addr[31:0];
    } DMAP_CUR_RX_BUF_ADDR_1 @ 0x1154;
    reg {
        name = "DMAP_CUR_RX_BUF_ADDR";
        desc = "DMAP_CUR_RX_BUF_ADDR is the DMAp (0 to 2) current host receive buffer address register. Indicates the receive buffer address the DMA is currently reading. DMAP_CUR_RX_BUF_ADDR (offset 0x1054+Px0x100 (P = 0~2), total reset 0x0000_0000; PROVEN: Hi3535 data sheet, PDF page 857, section 5.6).";
        field {
            name = "curr_rx_buff_addr";
            desc = "Current host receive buffer address register, indicating the receive buffer address that the DMA is reading.";
            sw = r; hw = w;
            reset = 0x0;
        } curr_rx_buff_addr[31:0];
    } DMAP_CUR_RX_BUF_ADDR_2 @ 0x1254;
    reg {
        name = "CT_LOCAL_MACADDR0_U16";
        desc = "CT_LOCAL_MACADDR0_U16 is the register for the upper 16 bits of the GMAC0 local MAC address. CT_LOCAL_MACADDR0_U16 (offset 0x8100, total reset 0x0000_0000; PROVEN: Hi3535 data sheet, PDF page 858, section 5.6).";
        field {
            name = "reserved";
            desc = "Reserved.";
            sw = r; hw = w;
            reset = 0x0;
        } reserved_31_16[31:16];
        field {
            name = "mac0_addr_u16";
            desc = "High 16 bits [47:32] of the local MAC address of GMAC0.";
            sw = rw; hw = r;
            reset = 0x0;
        } mac0_addr_u16[15:0];
    } CT_LOCAL_MACADDR0_U16 @ 0x8100;
    reg {
        name = "CT_LOCAL_MACADDR0_L32";
        desc = "CT_LOCAL_MACADDR0_L32 is the register holding the low 32 bits of the local MAC address of GMAC0. CT_LOCAL_MACADDR0_L32 (offset 0x8104, total reset 0x0000_0000; PROVEN: Hi3535 data sheet, PDF page 858, section 5.6).";
        field {
            name = "mac0_addr_l32";
            desc = "Low 32 bits [31:0] of the local MAC address of GMAC0.";
            sw = rw; hw = r;
            reset = 0x0;
        } mac0_addr_l32[31:0];
    } CT_LOCAL_MACADDR0_L32 @ 0x8104;
    reg {
        name = "CT_LOCAL_IPADDR0";
        desc = "CT_LOCAL_IPADDR0 is the GMAC0 local IP address register. CT_LOCAL_IPADDR0 (offset 0x8108, total reset 0x0000_0000; PROVEN: Hi3535 data sheet, PDF page 859, section 5.6).";
        field {
            name = "mac0_ip_addr";
            desc = "IP address of GMAC0, 32 bits [31:0].";
            sw = rw; hw = r;
            reset = 0x0;
        } mac0_ip_addr[31:0];
    } CT_LOCAL_IPADDR0 @ 0x8108;
    reg {
        name = "TOE_CTRL";
        desc = "TOE_CTRL is the register for the maximum number of retransmissions allowed by the TOE and the timer reset value. TOE_CTRL (offset 0x814C, total reset 0x2625_A0FF; PROVEN: Hi3535 data sheet, PDF page 859, section 5.6).";
        field {
            name = "timer_rst_val";
            desc = "Number of system clock cycles that make up 1 ms (the reset value assumes the system runs at 156.25MHz).";
            sw = rw; hw = r;
            reset = 0x2625a;
        } timer_rst_val[31:12];
        field {
            name = "num_retries";
            desc = "Maximum number of retransmissions allowed.";
            sw = rw; hw = r;
            reset = 0xff;
        } num_retries[11:0];
    } TOE_CTRL @ 0x814c;
    reg {
        name = "CT_LOCAL_MACADDR1_U16";
        desc = "CT_LOCAL_MACADDR1_U16 is the register for the upper 16 bits of the local MAC address of GMAC1. CT_LOCAL_MACADDR1_U16 (offset 0x8154, total reset 0x0000_0000; PROVEN: Hi3535 data sheet, PDF page 859, section 5.6).";
        field {
            name = "reserved";
            desc = "Reserved.";
            sw = r; hw = w;
            reset = 0x0;
        } reserved_31_16[31:16];
        field {
            name = "mac1_addr_u16";
            desc = "High 16 bits [47:32] of the local MAC address of GMAC1.";
            sw = rw; hw = r;
            reset = 0x0;
        } mac1_addr_u16[15:0];
    } CT_LOCAL_MACADDR1_U16 @ 0x8154;
    reg {
        name = "CT_LOCAL_MACADDR1_L32";
        desc = "CT_LOCAL_MACADDR1_L32 is the register for the lower 32 bits of the local MAC address of GMAC1. CT_LOCAL_MACADDR1_L32 (offset 0x8158, total reset 0x0000_0000; PROVEN: Hi3535 data sheet, PDF page 860, section 5.6).";
        field {
            name = "mac1_addr_l32";
            desc = "Lower 32 bits [31:0] of the local MAC address of GMAC1.";
            sw = rw; hw = r;
            reset = 0x0;
        } mac1_addr_l32[31:0];
    } CT_LOCAL_MACADDR1_L32 @ 0x8158;
    reg {
        name = "CT_LOCAL_IPADDR1";
        desc = "CT_LOCAL_IPADDR1 is the local IP address register of GMAC1. CT_LOCAL_IPADDR1 (offset 0x815C, total reset 0x0000_0000; PROVEN: Hi3535 data sheet, PDF page 860, section 5.6).";
        field {
            name = "mac1_ip_addr";
            desc = "IP address of GMAC1, 32 bits [31:0].";
            sw = rw; hw = r;
            reset = 0x0;
        } mac1_ip_addr[31:0];
    } CT_LOCAL_IPADDR1 @ 0x815c;
    reg {
        name = "TNK_INTR_STAT";
        desc = "TNK_INTR_STAT is the interrupt status register. TNK_INTR_STAT (offset 0x9000, total reset 0x0000_0000; PROVEN: Hi3535 data sheet, PDF page 861, section 5.6).";
        field {
            name = "reserved";
            desc = "Reserved.";
            sw = r; hw = w;
            reset = 0x0;
        } reserved_31_8[31:8];
        field {
            name = "toe_int";
            desc = "Interrupt from the TOE.";
            sw = r; hw = w;
            reset = 0x0;
        } toe_int[7:7];
        field {
            name = "gmac1_int";
            desc = "All interrupts from GMAC1.";
            sw = r; hw = w;
            reset = 0x0;
        } gmac1_int[6:6];
        field {
            name = "gmac0_int";
            desc = "All interrupts from GMAC0.";
            sw = r; hw = w;
            reset = 0x0;
        } gmac0_int[5:5];
        field {
            name = "dma_ch2_int";
            desc = "All interrupts from DMA2.";
            sw = r; hw = w;
            reset = 0x0;
        } dma_ch2_int[4:4];
        field {
            name = "dma_ch1_int";
            desc = "All interrupts from DMA1.";
            sw = r; hw = w;
            reset = 0x0;
        } dma_ch1_int[3:3];
        field {
            name = "dma_ch0_int";
            desc = "All interrupts from DMA0.";
            sw = r; hw = w;
            reset = 0x0;
        } dma_ch0_int[2:2];
        field {
            name = "dma_ttx_err_int";
            desc = "Interrupt generated by an error detected by the TOE transmit DMA.";
            sw = r; hw = w;
            reset = 0x0;
        } dma_ttx_err_int[1:1];
        field {
            name = "dma_ttx_ack_int";
            desc = "Interrupt generated when the TOE detects that one or more descriptors can be reclaimed by software because the peer ACK was returned.";
            sw = r; hw = w;
            reset = 0x0;
        } dma_ttx_ack_int[0:0];
    } TNK_INTR_STAT @ 0x9000;
    reg {
        name = "TNK_INTR_EN";
        desc = "TNK_INTR_EN is the interrupt enable register. TNK_INTR_EN (offset 0x09004, total reset 0x0000_0000; PROVEN: Hi3535 data sheet, PDF page 862, section 5.6).";
        field {
            name = "reserved";
            desc = "Reserved.";
            sw = r; hw = w;
            reset = 0x0;
        } reserved_31_8[31:8];
        field {
            name = "toe_ien";
            desc = "Interrupt enable of toe_int.";
            sw = rw; hw = r;
            reset = 0x0;
        } toe_ien[7:7];
        field {
            name = "gmac1_ien";
            desc = "Enable of all interrupts from GMAC1.";
            sw = rw; hw = r;
            reset = 0x0;
        } gmac1_ien[6:6];
        field {
            name = "gmac0_ien";
            desc = "Enable of all interrupts from GMAC0.";
            sw = rw; hw = r;
            reset = 0x0;
        } gmac0_ien[5:5];
        field {
            name = "dma_ch2_ien";
            desc = "Enable of all interrupts from DMA2.";
            sw = rw; hw = r;
            reset = 0x0;
        } dma_ch2_ien[4:4];
        field {
            name = "dma_ch1_ien";
            desc = "Enable of all interrupts from DMA1.";
            sw = rw; hw = r;
            reset = 0x0;
        } dma_ch1_ien[3:3];
        field {
            name = "dma_ch0_ien";
            desc = "Enable of all interrupts from DMA0.";
            sw = rw; hw = r;
            reset = 0x0;
        } dma_ch0_ien[2:2];
        field {
            name = "dma_ttx_err_ien";
            desc = "Interrupt enable of dma_ttx_err_int.";
            sw = rw; hw = r;
            reset = 0x0;
        } dma_ttx_err_ien[1:1];
        field {
            name = "dma_ttx_ack_ien";
            desc = "Interrupt enable of dma_ttx_ack_int.";
            sw = rw; hw = r;
            reset = 0x0;
        } dma_ttx_ack_ien[0:0];
    } TNK_INTR_EN @ 0x9004;
    reg {
        name = "TNK_RESET_STAT";
        desc = "TNK_RESET_STAT is the MAC reset status register. TNK_RESET_STAT (offset 0x09008, total reset 0x0000_0000; PROVEN: Hi3535 data sheet, PDF page 863, section 5.6).";
        field {
            name = "reserved";
            desc = "Reserved.";
            sw = r; hw = w;
            reset = 0x0;
        } reserved_31_2[31:2];
        field {
            name = "mac1_in_reset";
            desc = "If this value is 1, the reset of MAC1 is asserted, and the MAC does not leave the reset state before the MAC receive clock and transmit clock toggle.
- 0: The MAC is not in the reset state.
- 1: The MAC is in the reset state.";
            sw = r; hw = w;
            reset = 0x0;
        } mac1_in_reset[1:1];
        field {
            name = "mac0_in_reset";
            desc = "If this value is 1, the reset of MAC0 is asserted, and the MAC does not leave the reset state until the MAC receive clock and transmit clock have toggled.
- 0: MAC is not in the reset state;
- 1: MAC is in the reset state.";
            sw = r; hw = w;
            reset = 0x0;
        } mac0_in_reset[0:0];
    } TNK_RESET_STAT @ 0x9008;
    reg {
        name = "TNK_ID";
        desc = "TNK_ID is the register for the supported number of connections and the hardware version number. TNK_ID (offset 0x0900C, total reset 0x0001_00FF; PROVEN: Hi3535 data sheet, PDF page 863, section 5.6).";
        field {
            name = "tnk_id";
            desc = "Hardware version number.";
            sw = r; hw = w;
            reset = 0x1;
        } tnk_id[31:16];
        field {
            name = "num_conn";
            desc = "Number of supported connections. Contents";
            sw = r; hw = w;
            reset = 0xff;
        } num_conn[15:0];
    } TNK_ID @ 0x900c;
};

`endif
