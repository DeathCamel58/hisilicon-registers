`ifndef EHI3535_USB3_RDL
`define EHI3535_USB3_RDL
regfile eHI3535_USB3 {
    name = "USB 3.0 host";
    desc = "USB 3.0 host. 21 registers extracted programmatically from the Hi3535 H.264 codec processor (Hi3535 user guide) data sheet (Issue 00B08, 2014-02-25); chapter 13.6.5, table 13-11. Field names, bit ranges, access types and reset values are taken from the register tables; reset values are the data sheet total reset values split onto the fields (per-field values where the table has them). Label: PROVEN. Hardware not verified here (no board).";
    reg {
        name = "PERI_USB3_GSBUSCFG0";
        desc = "PERI_USB3_GSBUSCFG0 is global SOC bus configuration register 0. PERI_USB3_GSBUSCFG0 (offset 0xC100, total reset 0x0000_0000; PROVEN: Hi3535 data sheet, PDF page 1294, section 13.6.5).";
        field {
            name = "datrdreqinfo";
            desc = "Read data request.";
            sw = rw; hw = r;
            reset = 0x0;
        } datrdreqinfo[31:28];
        field {
            name = "desrdreqinfo";
            desc = "Read list request.";
            sw = rw; hw = r;
            reset = 0x0;
        } desrdreqinfo[27:24];
        field {
            name = "datwrreqinfo";
            desc = "Write data request.";
            sw = rw; hw = r;
            reset = 0x0;
        } datwrreqinfo[23:20];
        field {
            name = "deswrreqinfo";
            desc = "Write linked list request.";
            sw = rw; hw = r;
            reset = 0x0;
        } deswrreqinfo[19:16];
        field {
            name = "reserved";
            desc = "Reserved.";
            sw = r; hw = w;
            reset = 0x0;
        } reserved_15_12[15:12];
        field {
            name = "datbigend";
            desc = "Data access endianness select.
- 0: Little endian;
- 1: Big endian.";
            sw = rw; hw = r;
            reset = 0x0;
        } datbigend[11:11];
        field {
            name = "descbigend";
            desc = "Linked list access endianness select
- 0: Little endian.
- 1: Big endian.";
            sw = rw; hw = r;
            reset = 0x0;
        } descbigend[10:10];
        field {
            name = "reserved";
            desc = "Reserved.";
            sw = r; hw = w;
            reset = 0x0;
        } reserved_9_8[9:8];
        field {
            name = "incr256brstena";
            desc = "Enable signal for 256-beat burst transfers by the AHB master INCR.
- 0: Disable;
- 1: Enable.";
            sw = rw; hw = r;
            reset = 0x0;
        } incr256brstena[7:7];
        field {
            name = "incr128brstena";
            desc = "Enable signal for 128-beat burst transfers by AHB master INCR.
- 0: Disable;
- 1: Enable.";
            sw = rw; hw = r;
            reset = 0x0;
        } incr128brstena[6:6];
        field {
            name = "incr64brstena";
            desc = "Enable signal for 64-beat burst transfers by AHB master INCR.
- 0: Disable;
- 1: Enable.";
            sw = rw; hw = r;
            reset = 0x0;
        } incr64brstena[5:5];
        field {
            name = "incr32brstena";
            desc = "Enable signal for the AHB master to perform INCR 32-beat burst transfers.
- 0: Disable.
- 1: Enable.";
            sw = rw; hw = r;
            reset = 0x0;
        } incr32brstena[4:4];
        field {
            name = "incr16brstena";
            desc = "Enable signal for the AHB master INCR to perform 16-beat burst transfers.
- 0: Disable.
- 1: Enable.";
            sw = rw; hw = r;
            reset = 0x0;
        } incr16brstena[3:3];
        field {
            name = "incr8brstena";
            desc = "Enable signal for 8-beat burst transfers of AHB master INCR.
- 0: Disable;
- 1: Enable.";
            sw = rw; hw = r;
            reset = 0x0;
        } incr8brstena[2:2];
        field {
            name = "incr4brstena";
            desc = "Enable signal for AHB master INCR 4-beat burst transfers.
- 0: Disable;
- 1: Enable.";
            sw = rw; hw = r;
            reset = 0x0;
        } incr4brstena[1:1];
        field {
            name = "incrbrstena";
            desc = "Enable signal for AHB master INCR 1-beat burst transfers.
- 0: Disable;
- 1: Enable.";
            sw = rw; hw = r;
            reset = 0x0;
        } incrbrstena[0:0];
    } PERI_USB3_GSBUSCFG0 @ 0xc100;
    reg {
        name = "PERI_USB3_GSBUSCFG1";
        desc = "PERI_USB3_GSBUSCFG1 is global SOC bus configuration register 1. PERI_USB3_GSBUSCFG1 (offset 0xC104, total reset 0x0000_0000; PROVEN: Hi3535 data sheet, PDF page 1295, section 13.6.5).";
        field {
            name = "reserved";
            desc = "Reserved.";
            sw = r; hw = w;
            reset = 0x0;
        } reserved_31_13[31:13];
        field {
            name = "en1kpage";
            desc = "1K boundary select.
- 0: 4K boundary.
- 1: 1K boundary.";
            sw = rw; hw = r;
            reset = 0x0;
        } en1kpage[12:12];
        field {
            name = "pipetranslimit";
            desc = "Number of AXI master outstanding requests.
- 0x0: 1 request;
- 0x1: 2 requests;
- 0x2: 3 requests;
- 0x3: 4 requests;
- ...
- 0xF: 16 requests.";
            sw = rw; hw = r;
            reset = 0x0;
        } pipetranslimit[11:8];
        field {
            name = "reserved";
            desc = "Reserved.";
            sw = r; hw = w;
            reset = 0x0;
        } reserved_7_0[7:0];
    } PERI_USB3_GSBUSCFG1 @ 0xc104;
    reg {
        name = "PERI_USB3_GTXTHRCFG";
        desc = "PERI_USB3_GTXTHRCFG is the global transmit threshold control register. PERI_USB3_GTXTHRCFG (offset 0xC108, total reset 0x0000_0000; PROVEN: Hi3535 data sheet, PDF page 1296, section 13.6.5).";
        field {
            name = "reserved";
            desc = "Reserved.";
            sw = r; hw = w;
            reset = 0x0;
        } reserved_31_30[31:30];
        field {
            name = "usbtxpktcntsel";
            desc = "USB TXFIFO threshold select, valid only in SuperSpeed.
- 0: USB starts transmission only after all of the packet has been read into the given TXFIFO.
- 1: USB starts transmission only after the configured amount of the packet has been read into the given TXFIFO.";
            sw = rw; hw = r;
            reset = 0x0;
        } usbtxpktcntsel[29:29];
        field {
            name = "reserved";
            desc = "Reserved.";
            sw = r; hw = w;
            reset = 0x0;
        } reserved_28_28[28:28];
        field {
            name = "usbtxpktcnt";
            desc = "TXFIFO threshold setting; valid values are within 1-15.";
            sw = rw; hw = r;
            reset = 0x0;
        } usbtxpktcnt[27:24];
        field {
            name = "usbmaxtxburstsize";
            desc = "Maximum transmit burst, valid only for the OUT endpoints of SuperSpeed bulk and interrupt transfers in host mode; valid values are 1 to 16.";
            sw = rw; hw = r;
            reset = 0x0;
        } usbmaxtxburstsize[23:16];
        field {
            name = "reserved";
            desc = "Reserved.";
            sw = r; hw = w;
            reset = 0x0;
        } reserved_15_0[15:0];
    } PERI_USB3_GTXTHRCFG @ 0xc108;
    reg {
        name = "PERI_USB3_GRXTHRCFG";
        desc = "PERI_USB3_GRXTHRCFG is the global receive threshold control register. PERI_USB3_GRXTHRCFG (offset 0xC10C, total reset 0x0000_0000; PROVEN: Hi3535 data sheet, PDF page 1297, section 13.6.5).";
        field {
            name = "reserved";
            desc = "Reserved.";
            sw = r; hw = w;
            reset = 0x0;
        } reserved_31_30[31:30];
        field {
            name = "usbtxpktcntsel";
            desc = "USB RXFIFO threshold select, valid only in SuperSpeed.
- 0: USB starts a transfer only after all packets have been read into the given RXFIFO;
- 1: USB starts a transfer only after the configured number of packets have been read into the given RXFIFO.";
            sw = rw; hw = r;
            reset = 0x0;
        } usbtxpktcntsel[29:29];
        field {
            name = "reserved";
            desc = "Reserved.";
            sw = r; hw = w;
            reset = 0x0;
        } reserved_28_28[28:28];
        field {
            name = "usbtxpktcnt";
            desc = "RXFIFO threshold setting; valid values are within 1 to 15.";
            sw = rw; hw = r;
            reset = 0x0;
        } usbtxpktcnt[27:24];
        field {
            name = "usbmaxtxburstsize";
            desc = "Reserved.";
            sw = r; hw = w;
            reset = 0x0;
        } usbmaxtxburstsize[23:19];
        field {
            name = "reserved";
            desc = "Maximum receive burst, valid only for the IN endpoints of SuperSpeed bulk and interrupt transfers in host mode; valid values are 1 to 16.";
            sw = r; hw = w;
            reset = 0x0;
        } reserved_18_0[18:0];
    } PERI_USB3_GRXTHRCFG @ 0xc10c;
    reg {
        name = "PERI_USB3_GCTL";
        desc = "PERI_USB3_GCTL is the global core control register. PERI_USB3_GCTL (offset 0xC110, total reset 0x0000_0000; PROVEN: Hi3535 data sheet, PDF page 1298, section 13.6.5).";
        field {
            name = "pwrdnscale";
            desc = "Suspend_clk setting, GCTL[31:19] x 16K = Suspend_clk. Note: 32kHz<Suspend_clk<125MHz.";
            sw = rw; hw = r;
            reset = 0x0;
        } pwrdnscale[31:19];
        field {
            name = "masterfiltbypass";
            desc = "Filter function select.
- 0: When the value of DWC_USB3_EN_BUS_FILTERS is 1, the filter function is selected.
- 1: The filter function is turned off regardless of the value of DWC_USB3_EN_BUS_FILTERS.";
            sw = rw; hw = r;
            reset = 0x0;
        } masterfiltbypass[18:18];
        field {
            name = "reserved";
            desc = "Reserved.";
            sw = r; hw = w;
            reset = 0x0;
        } reserved_17_17[17:17];
        field {
            name = "reserved";
            desc = "Reserved.";
            sw = r; hw = w;
            reset = 0x0;
        } reserved_16_16[16:16];
        field {
            name = "frmscldwn";
            desc = "SOF/USOF/ITP time interval selection. For SS/HS mode:
- 0x3: 15.625us;
- 0x2: 31.25u;
- 0x1: 62.5us;
- 0x1: 125us; For FS mode, multiply the above values by 8. When xHCI Debug mode is selected, the MaxPacketSize of bulk in and bulk out transfers during simulation can be configured,
- 0x0: 1024 bytes;
- 0x1: 512 bytes;
- 0x2: 256 bytes;
- 0x3: 128 bytes;";
            sw = rw; hw = r;
            reset = 0x0;
        } frmscldwn[15:14];
        field {
            name = "reserved";
            desc = "Reserved.";
            sw = rw; hw = r;
            reset = 0x0;
        } reserved_13_12[13:12];
        field {
            name = "coresoftreset";
            desc = "Core soft reset select.
- 0: No soft reset;
- 1: Soft reset the core; Note: When the core is soft reset, interrupts and all interrupts other than the following registers are cleared: -GCTL; -GUCTL; -GSTS; -GSNPSID; -GGPIO; -GUID; -GUSB2PHYCFGn; -GUSB3PIPECTLn; -DCFG; -DCTL; -DEVTEN; -DSTS;";
            sw = rw; hw = r;
            reset = 0x0;
        } coresoftreset[11:11];
        field {
            name = "sofitpsync";
            desc = "- 0: The first port of the UTMI/ULPI PHY is in the non-suspended state, regardless of whether any other SS port is not in the Rx.Detect, SS.Disable, or U3 state.
- 1: The first port of the UTMI/ULPI PHY is in the non-suspended state, regardless of whether any other non-SS port is not in the non-suspended state. Note: This bit is valid only when the controller operates in host mode.";
            sw = rw; hw = r;
            reset = 0x0;
        } sofitpsync[10:10];
        field {
            name = "u1u2timerscale";
            desc = "U1/U2 timer scaledown select.
- 0: Not turned off;
- 1: If GCTL[5:4] (ScaleDown)=X1, turn off the scaledown of the U1/U2 response time.";
            sw = rw; hw = r;
            reset = 0x0;
        } u1u2timerscale[9:9];
        field {
            name = "debugattach";
            desc = "Debug. When this bit is set to 1 and the Run/Stop bit in the DCTL register is set, the SS controller goes directly to the Polling link state without detecting a remote device connection; the Link LFPS polling timeout is infinite. The TS1 polling timeout is infinite.";
            sw = rw; hw = r;
            reset = 0x0;
        } debugattach[8:8];
        field {
            name = "ramclksel";
            desc = "RAM Clock select.
- 00: bus clock;
- 01: pipe clock;
- 10: pipe/2 clock;
- 11: reserved.
Note: In host mode, hardware sets these 2 bits to 00, that is, connects ram_clk to bus_clk, because pipe_clk is turned off when the SS port is in the P3 state and the USB2.0 port would not work.";
            sw = rw; hw = r;
            reset = 0x0;
        } ramclksel[7:6];
        field {
            name = "scaledown";
            desc = "scale-down timing select: In HS/FS/LS mode:
- 00: Turn off all scale-down timing and simulate with the actual timing.
- 01: Enable all scale-down timing except the following functions: -speed enumeration; -HNP/SRP; -suspend and resume in host mode.
- 10: Enable the scale-down timing only for the suspend and resume functions in device mode.
- 11: Enable all scale-down timing.

In SS mode: In HS/FS/LS mode:
- 00: Turn off all scale-down timing and simulate with the actual timing.
- 01: Enable the SS scale-down timing, including: -reduce the number of TxEq training sequences to 8; -reduce the LFPS polling burst time to 100 ns; -reduce the LFPS warm reset receive time to 30 us.
- 10: Do not send TxEq training sequences.
- 11: Enable all scale-down timing.";
            sw = rw; hw = r;
            reset = 0x0;
        } scaledown[5:4];
        field {
            name = "disscramble";
            desc = "Disable the scrambling function.
- 1: Disable;
- 0: Do not disable.";
            sw = rw; hw = r;
            reset = 0x0;
        } disscramble[3:3];
        field {
            name = "u2exit_lfps";
            desc = "U2 state exit signal.
- 0: The link treats a 248ns LFPS signal as a valid U2 exit signal.
- 1: The link layer waits 8us before detecting a valid U2 exit signal.";
            sw = rw; hw = r;
            reset = 0x0;
        } u2exit_lfps[2:2];
        field {
            name = "gblhibernationen";
            desc = "Hibernation enable.
- 0: Disable the global hibernation function. The PMU accepts D0->D3 or D3->D0 state switches, and the internal state of the core is not saved or restored.
- 1: Enable the global hibernation function.";
            sw = rw; hw = r;
            reset = 0x0;
        } gblhibernationen[1:1];
        field {
            name = "dsblclkgtng";
            desc = "Internal clock gating select.
- 0: Select the internal clock gating;
- 1: Turn off the internal clock gating when the core is in lpm mode;
Note: this bit can be set to 1 after power-on reset.";
            sw = rw; hw = r;
            reset = 0x0;
        } dsblclkgtng[0:0];
    } PERI_USB3_GCTL @ 0xc110;
    reg {
        name = "PERI_USB3_GSTS";
        desc = "PERI_USB3_GSTS is the global status register. PERI_USB3_GSTS (offset 0xC118, total reset 0x0000_0000; PROVEN: Hi3535 data sheet, PDF page 1301, section 13.6.5).";
        field {
            name = "cbelt";
            desc = "In host mode, indicates the minimum of all received device BELT values and the BELT value set by the Set Latency Tolerance Value command.";
            sw = r; hw = w;
            reset = 0x0;
        } cbelt[31:20];
        field {
            name = "reserved";
            desc = "Reserved.";
            sw = r; hw = w;
            reset = 0x0;
        } reserved_19_11[19:11];
        field {
            name = "otg_ip";
            desc = "Indicates that an OTG-related interrupt is pending in the OEVT register.";
            sw = r; hw = w;
            reset = 0x0;
        } otg_ip[10:10];
        field {
            name = "bc_ip";
            desc = "Indicates that an interrupt related to BC is pending in the BCEVT register.";
            sw = r; hw = w;
            reset = 0x0;
        } bc_ip[9:9];
        field {
            name = "adp_ip";
            desc = "Indicates that an ADP-related interrupt is pending in the ADPEVT register.";
            sw = r; hw = w;
            reset = 0x0;
        } adp_ip[8:8];
        field {
            name = "host_ip";
            desc = "Indicates that an xHCI-related interrupt is pending in the Host event queue.";
            sw = r; hw = w;
            reset = 0x0;
        } host_ip[7:7];
        field {
            name = "reserved";
            desc = "Reserved.";
            sw = r; hw = w;
            reset = 0x0;
        } reserved_6_6[6:6];
        field {
            name = "csrtimeout";
            desc = "Indicates that a software register access exceeded the time defined by DWC_USB3_CSR_ACCESS_TIMEOUT.";
            sw = r; hw = w;
            reset = 0x0;
        } csrtimeout[5:5];
        field {
            name = "buserraddrvld";
            desc = "Indicates whether the GBUSERRADDR register is valid and gives the first address at which the error occurred.";
            sw = r; hw = w;
            reset = 0x0;
        } buserraddrvld[4:4];
        field {
            name = "reserved";
            desc = "Reserved.";
            sw = r; hw = w;
            reset = 0x0;
        } reserved_3_2[3:2];
        field {
            name = "curmod";
            desc = "Current operating mode.
- 01: host mode;
Others: Reserved.";
            sw = r; hw = w;
            reset = 0x0;
        } curmod[1:0];
    } PERI_USB3_GSTS @ 0xc118;
    reg {
        name = "PERI_USB3_GUCTL1";
        desc = "PERI_USB3_GUCTL1 is global user control register 1. PERI_USB3_GUCTL1 (offset 0xC11C, total reset 0x0000_0000; PROVEN: Hi3535 data sheet, PDF page 1302, section 13.6.5).";
        field {
            name = "reserved";
            desc = "Reserved.";
            sw = r; hw = w;
            reset = 0x0;
        } reserved_31_2[31:2];
        field {
            name = "ovrld_l1_susp_com";
            desc = "When using the vendor PHY, any value can be configured.";
            sw = rw; hw = r;
            reset = 0x0;
        } ovrld_l1_susp_com[1:1];
        field {
            name = "loa_filter_en";
            desc = "Port shutdown detection status. When this bit is set to 1, the controller checks the port status over three consecutive cycles before the port is shut down.";
            sw = rw; hw = r;
            reset = 0x0;
        } loa_filter_en[0:0];
    } PERI_USB3_GUCTL1 @ 0xc11c;
    reg {
        name = "PERI_USB3_GSNPSID";
        desc = "PERI_USB3_GSNPSID is the global Synopsys ID register. PERI_USB3_GSNPSID (offset 0xC120, total reset 0x5533_250A; PROVEN: Hi3535 data sheet, PDF page 1302, section 13.6.5).";
        field {
            name = "synopsysid";
            desc = "The upper 16 bits represent USB3 and the lower 16 bits represent 2.50a.";
            sw = r; hw = w;
            reset = 0x5533250a;
        } synopsysid[31:0];
    } PERI_USB3_GSNPSID @ 0xc120;
    reg {
        name = "PERI_USB3_GUID";
        desc = "PERI_USB3_GUID is the global user ID register. PERI_USB3_GUID (offset 0xC128, total reset 0x0000_0000; PROVEN: Hi3535 data sheet, PDF page 1303, section 13.6.5).";
        field {
            name = "userid";
            desc = "User information, including: system version; hardware configuration.";
            sw = r; hw = w;
            reset = 0x0;
        } userid[31:0];
    } PERI_USB3_GUID @ 0xc128;
    reg {
        name = "PERI_USB3_GUCTL";
        desc = "PERI_USB3_GUCTL is the global user control register. PERI_USB3_GUCTL (offset 0xC12C, total reset 0x0000_0000; PROVEN: Hi3535 data sheet, PDF page 1303, section 13.6.5).";
        field {
            name = "refclkper";
            desc = "Reference clock ref_clk period expressed in ns. For example, if ref_clk is 125 MHz, this value is 1/125MHz = 8 ns.";
            sw = rw; hw = r;
            reset = 0x0;
        } refclkper[31:22];
        field {
            name = "noextrdl_";
            desc = "Extra delay select between the SOF packet and the first packet.
- 0: After the SOF packet, the host waits 2ms before sending the first packet.
- 1: After the SOF, the host sends the first packet immediately without delay.";
            sw = rw; hw = r;
            reset = 0x0;
        } noextrdl[21:21];
        field {
            name = "reserved";
            desc = "Reserved.";
            sw = rw; hw = r;
            reset = 0x0;
        } reserved_20_18[20:18];
        field {
            name = "sprsctrltransen";
            desc = "Split control transfer enable. Some devices respond very slowly to control transfers, and performing multiple transfers within one frame/microframe can cause the device to misbehave. When this bit is set to 1, the host controller spreads a control transfer across different frames or microframes.";
            sw = rw; hw = r;
            reset = 0x0;
        } sprsctrltransen[17:17];
        field {
            name = "resbwhseps";
            desc = "Reserve 85% of the bandwidth for high-speed periodic endpoints.";
            sw = rw; hw = r;
            reset = 0x0;
        } resbwhseps[16:16];
        field {
            name = "cmdevaddr";
            desc = "Device address mode.
- 0: The device address equals the Slot ID;
- 1: The address increments for each assign-device-address command.";
            sw = rw; hw = r;
            reset = 0x0;
        } cmdevaddr[15:15];
        field {
            name = "usbhstlnautoretryen";
            desc = "Host IN transfer auto-retry enable.
- 0: Auto-retry disabled; if an error occurs in a host IN transfer, the host automatically replies to the device with a terminating ACK (Retry = 1 and NumP = 0).
- 1: Auto-retry enabled. When auto-retry is enabled and an error occurs in a host IN transfer, the host automatically replies to the device with a non-terminating ACK (Retry = 1 and

NumP != 0).";
            sw = rw; hw = r;
            reset = 0x0;
        } usbhstlnautoretryen[14:14];
        field {
            name = "enoverlapchk";
            desc = "LFPS superimposed signal detection enable.
- 0: Do not detect the LFPS superimposed signal;
- 1: Detect the LFPS superimposed signal to avoid the effect of glitches.";
            sw = rw; hw = r;
            reset = 0x0;
        } enoverlapchk[13:13];
        field {
            name = "extcapsupten";
            desc = "External additional function enable.";
            sw = rw; hw = r;
            reset = 0x0;
        } extcapsupten[12:12];
        field {
            name = "csr";
            desc = "Insert extra delay between full-speed BULKOUT transfers.";
            sw = rw; hw = r;
            reset = 0x0;
        } csr[11:11];
        field {
            name = "dtct";
            desc = "Coarse timeout time for the device to respond to the host. If this field is 0, the timeout time is defined by DTFT; if it is non-zero:
- 01: 500us.
- 10: 1.5ms.
- 11: 6.5ms.";
            sw = rw; hw = r;
            reset = 0x0;
        } dtct[10:9];
        field {
            name = "dtft";
            desc = "Precise timeout for the device to respond to the host, valid when DTCT is 0, T = DTFT x 256 x 8 us.";
            sw = rw; hw = r;
            reset = 0x0;
        } dtft[8:0];
    } PERI_USB3_GUCTL @ 0xc12c;
    reg {
        name = "PERI_USB3_GBUSERRADD_HI";
        desc = "PERI_USB3_GBUSERRADD_HI is the global bus error address register. PERI_USB3_GBUSERRADD_HI (offset 0xC130, total reset 0x0000_0000; PROVEN: Hi3535 data sheet, PDF page 1305, section 13.6.5).";
        field {
            name = "busaddrhi";
            desc = "High 32 bits of the address where the error occurred. Notes: Valid only when GSTS.BusErrAddrVld is 1. Cleared only on reset. Supports only AHB and AXI bus configurations.";
            sw = r; hw = w;
            reset = 0x0;
        } busaddrhi[31:0];
    } PERI_USB3_GBUSERRADD_HI @ 0xc130;
    reg {
        name = "PERI_USB3_GBUSERRADDR_LO";
        desc = "PERI_USB3_GBUSERRADDR_LO is the global bus error address register. PERI_USB3_GBUSERRADDR_LO (offset 0xC134, total reset 0x0000_0000; PROVEN: Hi3535 data sheet, PDF page 1305, section 13.6.5).";
        field {
            name = "busaddrlo";
            desc = "Lower 32 bits of the address where the error occurred. Note: Valid only when GSTS.BusErrAddrVld is 1. Cleared only on reset. Only AHB and AXI bus configurations are supported.";
            sw = r; hw = w;
            reset = 0x0;
        } busaddrlo[31:0];
    } PERI_USB3_GBUSERRADDR_LO @ 0xc134;
    reg {
        name = "PERI_USB3_GUSB2PHYCFGN";
        desc = "PERI_USB3_GUSB2PHYCFGN is the global USB2.0 PHY configuration register. PERI_USB3_GUSB2PHYCFGN (offset 0xC200, total reset 0x0000_0000; PROVEN: Hi3535 data sheet, PDF page 1306, section 13.6.5).";
        field {
            name = "phy_soft_rst";
            desc = "Triggers the usb2phy_reset signal to soft-reset the UTMI PHY. The ULPI PHY is not reset here, because the ULPI PHY is reset through the FunctionControl.Reset register; when the core is reset, the core automatically configures the following registers to reset it: vcc_reset_n, USBCMD.HCRST, DCTL.SoftReset, or GCTL.SoftReset.";
            sw = rw; hw = r;
            reset = 0x0;
        } phy_soft_rst[31:31];
        field {
            name = "u2_freeclk_exists";
            desc = "Whether the USB2 PHY provides free_clk.
- 0: Does not provide the free clock.
- 1: Provides the free clock.";
            sw = rw; hw = r;
            reset = 0x0;
        } u2_freeclk_exists[30:30];
        field {
            name = "ulpi_lpm_with_opmode_chk";
            desc = "- 0: In LPM mode, the controller sends a NOPID before sending EXTPID;
- 1: In LPM mode, the controller does not send a NOPID before sending EXTPID.";
            sw = rw; hw = r;
            reset = 0x0;
        } ulpi_lpm_with_opmode_chk[29:29];
        field {
            name = "reserved";
            desc = "Reserved.";
            sw = r; hw = w;
            reset = 0x0;
        } reserved_28_19[28:19];
        field {
            name = "ulpi_ext_vbus_indicator";
            desc = "ULPI external Vbus indication.
- 0: The PHY uses the internal VBUS valid comparator;
- 1: The PHY uses the external VBUS valid comparator.";
            sw = rw; hw = r;
            reset = 0x0;
        } ulpi_ext_vbus_indicator[18:18];
        field {
            name = "ulpi_ext_vbus_drv";
            desc = "ULPI external Vbus indication.
- 0: The PHY uses the internal VBUS valid comparator;
- 1: The PHY uses the external VBUS valid comparator.";
            sw = rw; hw = r;
            reset = 0x0;
        } ulpi_ext_vbus_drv[17:17];
        field {
            name = "reserved";
            desc = "Reserved.";
            sw = r; hw = w;
            reset = 0x0;
        } reserved_16_16[16:16];
        field {
            name = "ulpi_auto_res";
            desc = "ULPI auto resume.
- 0: The PHY does not enable the auto resume function;
- 1: The PHY enables the auto resume function.";
            sw = rw; hw = r;
            reset = 0x0;
        } ulpi_auto_res[15:15];
        field {
            name = "reserved";
            desc = "Reserved.";
            sw = r; hw = w;
            reset = 0x0;
        } reserved_14_14[14:14];
        field {
            name = "usbtrdtim";
            desc = "USB2 Turnaround Time, the response time for the MAC to request the Packet FIFO Controller (PFC) to fetch data from the DFIFO (SPRAM). For 16-bit UTMI+: 0x5; For 8-bit UTMI+/ULPI interface: 0x9.";
            sw = rw; hw = r;
            reset = 0x0;
        } usbtrdtim[13:10];
        field {
            name = "xcvrdly";
            desc = "Transceiver delay select. When this bit is 1, a 2.5us delay is inserted between Transceiver Select being set to 00 (high speed) and TxValid being pulled to 0, used for sending the chirp-K handshake signal.";
            sw = rw; hw = r;
            reset = 0x0;
        } xcvrdly[9:9];
        field {
            name = "enblslpm";
            desc = "utmi_sleep_n and utmi_l1_suspend_n signal enable.
- 0: The utmi_sleep_n and utmi_l1_suspend_n signals are not connected to the PHY;
- 1: The utmi_sleep_n and utmi_l1_suspend_n signals are connected to the PHY.";
            sw = rw; hw = r;
            reset = 0x0;
        } enblslpm[8:8];
        field {
            name = "physel";
            desc = "PHY interface type select.
- 0: USB2.0 high-speed UTMI+ or ULPI PHY;
- 1: USB1.1 full-speed serial interface. When write-only, this bit is 1.";
            sw = rw; hw = r;
            reset = 0x0;
        } physel[7:7];
        field {
            name = "susphy";
            desc = "USB2.0 HS/FS/LS PHY suspend select.
- 0: Not suspended;
- 1: Suspended.";
            sw = rw; hw = r;
            reset = 0x0;
        } susphy[6:6];
        field {
            name = "fsintf";
            desc = "Full-speed PHY serial interface type selection.
- 0: 6-pin unidirectional full-speed serial transfer interface;
- 1: 3-pin bidirectional full-speed serial transfer interface. When read-only, the returned value is 0.";
            sw = rw; hw = r;
            reset = 0x0;
        } fsintf[5:5];
        field {
            name = "ulpi_utmi_sel";
            desc = "High-speed PHY interface type selection.
- 0: UTMI+;
- 1: ULPI.";
            sw = rw; hw = r;
            reset = 0x0;
        } ulpi_utmi_sel[4:4];
        field {
            name = "phyif";
            desc = "UTMI interface data width select.
- 0: 8bits;
- 1: 16bits.";
            sw = rw; hw = r;
            reset = 0x0;
        } phyif[3:3];
        field {
            name = "toutcal";
            desc = "HS/FS timeout calibration. The corresponding bit time is added for each PHY clock. High-speed mode: One 30-MHz PHY clock = 16 bit times; One 60-MHz PHY clock = 8 bit times. Full-speed mode: One 30-MHz PHY clock = 0.4 bit times; One 60-MHz PHY clock = 0.2 bit times; One 48-MHz PHY clock = 0.25 bit times.";
            sw = rw; hw = r;
            reset = 0x0;
        } toutcal[2:0];
    } PERI_USB3_GUSB2PHYCFGN @ 0xc200;
    reg {
        name = "PERI_USB3_GUSB3PIPECTLN";
        desc = "PERI_USB3_GUSB3PIPECTLN is the global USB3.0 PIPE control register. PERI_USB3_GUSB3PIPECTLN (offset 0xC2C0, total reset 0x0000_0000; PROVEN: Hi3535 data sheet, PDF page 1308, section 13.6.5).";
        field {
            name = "phy_soft_rst";
            desc = "USB3 soft reset.";
            sw = rw; hw = r;
            reset = 0x0;
        } phy_soft_rst[31:31];
        field {
            name = "hstprtcmpl";
            desc = "Test the PIPE PHY template without a USB3.0 cable.";
            sw = rw; hw = r;
            reset = 0x0;
        } hstprtcmpl[30:30];
        field {
            name = "u2ssinactp3ok";
            desc = "PHY state selection in the U2/SSInactive state.
- 0: PHY enters the P2 state;
- 1: PHY enters the P3 state.";
            sw = rw; hw = r;
            reset = 0x0;
        } u2ssinactp3ok[29:29];
        field {
            name = "disrxdetp3";
            desc = "Receiver detection enable in the p3 state.
- 0: If the PHY is in the P3 state and the core needs receiver detection, the core performs receiver detection in the P3 state.
- 1: If the PHY is in the P3 state and the core needs receiver detection, the core changes the PHY state to P2, performs receiver detection, and then changes the PHY state back to P3 after detection completes.";
            sw = rw; hw = r;
            reset = 0x0;
        } disrxdetp3[28:28];
        field {
            name = "ux_exit_in_px";
            desc = "PHY state selection when the core changes state.
- 0: When the core exits the U1/U2/U3 state, the PHY is in the P0 state;
- 1: When the core exits the U1/u2/u3 state, the PHY is in the corresponding P1/P2/P3 state.
Note: Set this bit to 0 when using the Synopsys PHY.";
            sw = rw; hw = r;
            reset = 0x0;
        } ux_exit_in_px[27:27];
        field {
            name = "ping_enhancement_en";
            desc = "The timeout of the ping command of downstream port U1 changes from 500 ms to 300 ms. Note: Set this bit to 0 when using the Synopsys PHY.";
            sw = rw; hw = r;
            reset = 0x0;
        } ping_enhancement_en[26:26];
        field {
            name = "u1u2exitfail_to_recov";
            desc = "Signal selection for exiting P3 from the P2 state: when this bit is set to 1, the core puts the PHY into the P2 state before issuing the handshake signal to exit U3.";
            sw = rw; hw = r;
            reset = 0x0;
        } u1u2exitfail_to_recov[25:25];
        field {
            name = "request_p1p2p3";
            desc = "When the core switches from state U0 to U1/U2/U3, the core always requests the PHY to switch from state P0 to P1/P2/P3. Note: Set this bit to 1 when a Synopsys PHY is used.";
            sw = rw; hw = r;
            reset = 0x0;
        } request_p1p2p3[24:24];
        field {
            name = "startrxdetu3rxdet";
            desc = "Not used; tie to 0.";
            sw = rw; hw = r;
            reset = 0x0;
        } startrxdetu3rxdet[23:23];
        field {
            name = "disrxdetu3rxdet";
            desc = "Not used; tie to 0.";
            sw = rw; hw = r;
            reset = 0x0;
        } disrxdetu3rxdet[22:22];
        field {
            name = "delayp1p2p3";
            desc = "Delay of the P0 to P1/P2/P3 state transition. When the core enters the U1/U2/U3 state, the time for P0 to enter P1/P2/P3 is extended until Pipe3_RxValid is pulled to 0 or an 8B10B error occurs. Note: valid only when bit 18 is set to 1.";
            sw = rw; hw = r;
            reset = 0x0;
        } delayp1p2p3[21:19];
        field {
            name = "delay_phy_powerchange";
            desc = "PHY state transition delay
- 0: When the core enters the U1/U2/U3 state from U0, the PHY enters the P1/P2/P3 state directly, without checking Pipe3_RxElecIlde and pipe3_RxValid;
- 1: When the core enters the U1/U2/U3 state from U0, the PHY transition to P1/P2/P3 is delayed until Pipe3_RxElecIlde is 1 and pipe3_RxValid is 0.
Note: set this bit to 1 when using a Synopsys PHY.";
            sw = rw; hw = r;
            reset = 0x0;
        } delay_phy_powerchange[18:18];
        field {
            name = "suspend_en";
            desc = "USB3.0 PHY suspend enable.
- 0: Do not suspend;
- 1: Suspend. Note: In DRD mode, set this bit to 1 after core initialization completes.";
            sw = rw; hw = r;
            reset = 0x0;
        } suspend_en[17:17];
        field {
            name = "datwidth";
            desc = "Data width of the PIPE interface.
- 00: 32 bits.
- 01: 16 bits.
- 10: 8 bits.";
            sw = rw; hw = r;
            reset = 0x0;
        } datwidth[16:15];
        field {
            name = "abortrxdetinu2";
            desc = "Cancel Rx Detect in the U2 state. When this bit is set to 1 and the link state is U2, the core does not perform receiver detection when it receives the U2 exit signal sent by the remote connected device. Note: Set this bit to 0 when using the Synopsys PHY.";
            sw = rw; hw = r;
            reset = 0x0;
        } abortrxdetinu2[14:14];
        field {
            name = "skiprxdet";
            desc = "Skip Rx Detect: if this bit is set to 1, Rx Detection is skipped when pipe3_RxElecIdle goes low.";
            sw = rw; hw = r;
            reset = 0x0;
        } skiprxdet[13:13];
        field {
            name = "lfps_p0_align";
            desc = "When the controller exits the U1/U2/U3 state, it terminates LFPS transmission at the clock edge of the request to PHY P0; otherwise the LFPS signal is sent one cycle earlier. When the PHY switches from the P1 or P2 state to the P0 state, the controller requests transmission 2 clock cycles after the PHY sets PhyStatus.";
            sw = rw; hw = r;
            reset = 0x0;
        } lfps_p0_align[12:12];
        field {
            name = "p3p2_tran_ok";
            desc = "P3P2 direct state switching.
- 0: Every switch between P2 and P3 in the PHY must go through the intermediate state P0;
- 1: The PHY state switches directly from P2 to P3, or directly from P3 to P2, without going through the intermediate state P0. Note: When a synopsys PHY is used, set this bit to 0.";
            sw = rw; hw = r;
            reset = 0x0;
        } p3p2_tran_ok[11:11];
        field {
            name = "p3exsigp2";
            desc = "P3 exit state select.
- 1: When the core exits from U3, the PHY state must exit from P3 to P2. Note: When using a Synopsys PHY, set this bit to 0.";
            sw = rw; hw = r;
            reset = 0x0;
        } p3exsigp2[10:10];
        field {
            name = "lfps_filter";
            desc = "LFPS filtering. When this bit is 1, the controller filters the LFPS signal from the PHY unless pipe3_Rxelecidle and pipe3_RxValid are deasserted.";
            sw = rw; hw = r;
            reset = 0x0;
        } lfps_filter[9:9];
        field {
            name = "polling_lfps_control";
            desc = "RX_DETECT to Polling.LFPS control.
- 0: (Default) Polling LFPS starts 400 us after RX_DETECT.
- 1: Polling LFPS starts directly after RX_DETECT without delay.";
            sw = rw; hw = r;
            reset = 0x0;
        } polling_lfps_control[8:8];
        field {
            name = "reserved";
            desc = "Reserved.";
            sw = r; hw = w;
            reset = 0x0;
        } reserved_7_7[7:7];
        field {
            name = "txswing";
            desc = "PIPE interface transmit swing.";
            sw = rw; hw = r;
            reset = 0x0;
        } txswing[6:6];
        field {
            name = "txmargin";
            desc = "PIPE interface transmitter margin.";
            sw = rw; hw = r;
            reset = 0x0;
        } txmargin[5:3];
        field {
            name = "txdeemphasis";
            desc = "PIPE interface transmitter pre-emphasis.";
            sw = rw; hw = r;
            reset = 0x0;
        } txdeemphasis[2:1];
        field {
            name = "elastic_buffer_mode";
            desc = "Elastic buffer mode select.";
            sw = rw; hw = r;
            reset = 0x0;
        } elastic_buffer_mode[0:0];
    } PERI_USB3_GUSB3PIPECTLN @ 0xc2c0;
    reg {
        name = "PERI_USB3_GTXFIFOSIZN";
        desc = "PERI_USB3_GTXFIFOSIZN is the global transmit FIFO size register. PERI_USB3_GTXFIFOSIZN (offset 0xC300+0x04xf (f = 0~31), total reset 0x0000_0000; PROVEN: Hi3535 data sheet, PDF page 1310, section 13.6.5).";
        field {
            name = "txfstaddr_n";
            desc = "Start address of Transmit FIFOn RAM in memory.";
            sw = rw; hw = r;
            reset = 0x0;
        } txfstaddr_n[31:16];
        field {
            name = "txfdep_n";
            desc = "Transmit FIFO depth. Minimum: 32 MDWIDTH-bit words; maximum: 32768 MDWIDTH-bit words.";
            sw = rw; hw = r;
            reset = 0x0;
        } txfdep_n[15:0];
    } PERI_USB3_GTXFIFOSIZN[32] @ 0xc300 += 0x4;
    reg {
        name = "PERI_USB3_GRXFIFOSIZN";
        desc = "PERI_USB3_GRXFIFOSIZN is the global receive FIFO size register. PERI_USB3_GRXFIFOSIZN (offset 0xC380+0x04xf (f = 0~31), total reset 0x0000_0000; PROVEN: Hi3535 data sheet, PDF page 1311, section 13.6.5).";
        field {
            name = "rxfstaddr_n";
            desc = "Start address of Receive FIFOn RAM in memory.";
            sw = rw; hw = r;
            reset = 0x0;
        } rxfstaddr_n[31:16];
        field {
            name = "rxfdep_n";
            desc = "Receive FIFO depth. Minimum: 32 MDWIDTH-bit words; Maximum: 32768 MDWIDTH-bit words.";
            sw = rw; hw = r;
            reset = 0x0;
        } rxfdep_n[15:0];
    } PERI_USB3_GRXFIFOSIZN[32] @ 0xc380 += 0x4;
    reg {
        name = "PERI_USB3_GTXFIFOPRIHST";
        desc = "PERI_USB3_GTXFIFOPRIHST is the global TX FIFO DMA priority register for the host. PERI_USB3_GTXFIFOPRIHST (offset 0xC618, total reset 0x0000_0000; PROVEN: Hi3535 data sheet, PDF page 1311, section 13.6.5).";
        field {
            name = "reserved";
            desc = "Reserved.";
            sw = r; hw = w;
            reset = 0x0;
        } reserved_31_4[31:4];
        field {
            name = "host_txfifo_priority";
            desc = "Host TXFIFO priority.
- 0: low;
- 1: high.";
            sw = rw; hw = r;
            reset = 0x0;
        } host_txfifo_priority[3:0];
    } PERI_USB3_GTXFIFOPRIHST @ 0xc618;
    reg {
        name = "PERI_USB3_GRXFIFOPRIHST";
        desc = "PERI_USB3_GRXFIFOPRIHST is the global RX FIFO DMA priority register for the host. PERI_USB3_GRXFIFOPRIHST (offset 0xC61C, total reset 0x0000_0000; PROVEN: Hi3535 data sheet, PDF page 1312, section 13.6.5).";
        field {
            name = "reserved";
            desc = "Reserved.";
            sw = r; hw = w;
            reset = 0x0;
        } reserved_31_4[31:4];
        field {
            name = "host_rxfifo_priority";
            desc = "Host RXFIFO priority.
- 0: low;
- 1: high.";
            sw = rw; hw = r;
            reset = 0x0;
        } host_rxfifo_priority[3:0];
    } PERI_USB3_GRXFIFOPRIHST @ 0xc61c;
    reg {
        name = "PERI_USB3_GFIFOPRIDBC";
        desc = "PERI_USB3_GFIFOPRIDBC is the DMA priority register for the host global debug performance. PERI_USB3_GFIFOPRIDBC (offset 0xC620, total reset 0x0000_0000; PROVEN: Hi3535 data sheet, PDF page 1312, section 13.6.5).";
        field {
            name = "reserved";
            desc = "Reserved.";
            sw = r; hw = w;
            reset = 0x0;
        } reserved_31_2[31:2];
        field {
            name = "host_dbc_dma_priority";
            desc = "Host DbC DMA priority.
- 00: Low.
- 01: Normal.
- 10: High. Others: Reserved.";
            sw = rw; hw = r;
            reset = 0x0;
        } host_dbc_dma_priority[1:0];
    } PERI_USB3_GFIFOPRIDBC @ 0xc620;
    reg {
        name = "PERI_USB3_GDMAHLRATIO";
        desc = "PERI_USB3_GDMAHLRATIO is the host global FIFO DMA high/low priority ratio register. PERI_USB3_GDMAHLRATIO (offset 0xC624, total reset 0x0000_0000; PROVEN: Hi3535 data sheet, PDF page 1313, section 13.6.5).";
        field {
            name = "reserved";
            desc = "Reserved.";
            sw = r; hw = w;
            reset = 0x0;
        } reserved_31_13[31:13];
        field {
            name = "hst_rxfifo_dma_hilo_priority_ratio";
            desc = "Host RXFIFO DMA high-to-low priority ratio.";
            sw = rw; hw = r;
            reset = 0x0;
        } hst_rxfifo_dma_hilo_priority_ratio[12:8];
        field {
            name = "reserved";
            desc = "Reserved.";
            sw = r; hw = w;
            reset = 0x0;
        } reserved_7_5[7:5];
        field {
            name = "hst_txfifo_dma_hilo_priority_ratio";
            desc = "Host TXFIFO DMA high-to-low priority ratio.";
            sw = rw; hw = r;
            reset = 0x0;
        } hst_txfifo_dma_hilo_priority_ratio[4:0];
    } PERI_USB3_GDMAHLRATIO @ 0xc624;
    reg {
        name = "PERI_USB3_GFLADJ";
        desc = "PERI_USB3_GFLADJ is the global frame length adjustment register. PERI_USB3_GFLADJ (offset 0xC630, total reset 0x0000_0000; PROVEN: Hi3535 data sheet, PDF page 1314, section 13.6.5).";
        field {
            name = "gfladj_refclk_240mhzdecr_pls1";
            desc = "Precision adjustment of GFLADJ_REFCLK_240MHZ_DECR/ref_frequency. Set this bit to 1 when the gfladj_refclk_lpm_sel bit is 1 and the fractional part is greater than or equal to 0.5.";
            sw = rw; hw = r;
            reset = 0x0;
        } gfladj_refclk_240mhzdecr_pls1[31:31];
        field {
            name = "gfladj_refclk_240mhz_decr";
            desc = "GFLADJ_REFCLK_240MHZ_DECR = 240/ref_clk_frequency.";
            sw = rw; hw = r;
            reset = 0x0;
        } gfladj_refclk_240mhz_decr[30:24];
        field {
            name = "gfladj_refclk_lpm_sel";
            desc = "SOF/ITP counting clock select. If this bit is set to 1, the SOF/ITP is counted with ref_clk.";
            sw = rw; hw = r;
            reset = 0x0;
        } gfladj_refclk_lpm_sel[23:23];
        field {
            name = "reserved";
            desc = "Reserved.";
            sw = r; hw = w;
            reset = 0x0;
        } reserved_22_22[22:22];
        field {
            name = "gfladj_refclk_fladj";
            desc = "SOF/ITP calibration value when bit 23 is 1. FLADJ_REF_CLK_FLADJ=((125000/ref_clk_period_integer)- (125000/ref_clk_period)) * ref_clk_period.";
            sw = rw; hw = r;
            reset = 0x0;
        } gfladj_refclk_fladj[21:8];
        field {
            name = "gfladj_30mhz_reg_sel";
            desc = "SOF/ITP frame length calibration select signal.
- 0: The controller calibrates SOF/ITP using the value of the input signal fladj_30mhz_reg.
- 1: The controller calibrates SOF/ITP using the value of GFLADJ.GFLADJ_30MHZ.";
            sw = rw; hw = r;
            reset = 0x0;
        } gfladj_30mhz_reg_sel[7:7];
        field {
            name = "reserved";
            desc = "Reserved.";
            sw = r; hw = w;
            reset = 0x0;
        } reserved_6_6[6:6];
        field {
            name = "gfladj_30mhz";
            desc = "When bit 7 is 1 and SOF/ITP is counted with the UTMI/ULPI clock, the controller uses the value here to calibrate SOF/ITP.";
            sw = rw; hw = r;
            reset = 0x0;
        } gfladj_30mhz[5:0];
    } PERI_USB3_GFLADJ @ 0xc630;
};

`endif
