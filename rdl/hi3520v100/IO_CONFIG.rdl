`ifndef HI3520V100_IO_CONFIG_RDL
`define HI3520V100_IO_CONFIG_RDL

regfile eIO_CONFIG {
    name = "IO configuration (pin multiplexing control), Hi3520 V100";
    desc = "
    Pin multiplexing control registers of the Hi3520 V100 at 0x200F0000 ('IO config registers', 64 KB window, DS Table 1-1 line 11535): 83 registers `reg0`..`reg82` at offsets 0x0..0x148,
    one register per software-multiplexed pin, each holding one RW field (1 or 2 bits) that selects the pin function; all reset to 0 (the first listed
    function, usually the pin's primary function, GPIO where the pin is GPIO by default). The register name is the data sheet's; the register title names the pin.

    Source: Hi3520 User Guide (user guide / data sheet), original Chinese edition document version 02 (2010-01-19), section 2.4 (summary Table 2-35, dump line 5094) and section 2.5 (register descriptions, dump lines 5305..7785). Chinese original, so the
    values are high confidence; the function names are copied verbatim, the sentences translated. No Hi3520 V100 vendor code (U-Boot/kernel board files) exists in this
    workspace to cross-check against (only Hi3520D and Hi3516A trees), so the register set is data-sheet only.

    | Register | Offset | Pin | Values |
    |----------|--------|-----|--------|
    | reg0 | 0x0 | VI0HS | 00=VI0HS, 01=URXD2, 10=GPIO1_3 |
    | reg1 | 0x4 | VI0VS | 00=VI0VS, 01=UTXD2, 10=GPIO1_4 |
    | reg2 | 0x8 | VI0DAT0 | 0=VI0DAT0, 1=VOUDAT8 |
    | reg3 | 0xC | VI0DAT1 | 0=VI0DAT1, 1=VOUDAT9 |
    | reg4 | 0x10 | VI0DAT2 | 0=VI0DAT2, 1=VOUDAT10 |
    | reg5 | 0x14 | VI0DAT3 | 0=VI0DAT3, 1=VOUDAT11 |
    | reg6 | 0x18 | VI0DAT4 | 0=VI0DAT4, 1=VOUDAT12 |
    | reg7 | 0x1C | VI0DAT5 | 0=VI0DAT5, 1=VOUDAT13 |
    | reg8 | 0x20 | VI0DAT6 | 0=VI0DAT6, 1=VOUDAT14 |
    | reg9 | 0x24 | VI0DAT7 | 0=VI0DAT7, 1=VOUDAT15 |
    | reg10 | 0x28 | VI1DAT0 | 00=VI1DAT0, 01=GPIO4_0, 10=VOUDAT0 |
    | reg11 | 0x2C | VI1DAT1 | 00=VI1DAT1, 01=GPIO4_1, 10=VOUDAT1 |
    | reg12 | 0x30 | VI1DAT2 | 00=VI1DAT2, 01=GPIO4_2, 10=VOUDAT2 |
    | reg13 | 0x34 | VI1DAT3 | 00=VI1DAT3, 01=GPIO4_3, 10=VOUDAT3 |
    | reg14 | 0x38 | VI1DAT4 | 00=VI1DAT4, 01=GPIO4_4, 10=VOUDAT4 |
    | reg15 | 0x3C | VI1DAT5 | 00=VI1DAT5, 01=GPIO4_5, 10=VOUDAT5 |
    | reg16 | 0x40 | VI1DAT6 | 00=VI1DAT6, 01=GPIO4_6, 10=VOUDAT6 |
    | reg17 | 0x44 | VI1DAT7 | 00=VI1DAT7, 01=GPIO4_7, 10=VOUDAT7 |
    | reg18 | 0x48 | VI2HS | 00=VI2HS, 01=URXD3, 10=GPIO3_4 |
    | reg19 | 0x4C | VI2VS | 00=VI2VS, 01=UTXD3, 10=GPIO3_5 |
    | reg20 | 0x50 | VI2DAT0 | 0=VI2DAT0, 1=GPIO5_0 |
    | reg21 | 0x54 | VI2DAT1 | 0=VI2DAT1, 1=GPIO5_1 |
    | reg22 | 0x58 | VI2DAT2 | 0=VI2DAT2, 1=GPIO5_2 |
    | reg23 | 0x5C | VI2DAT3 | 0=VI2DAT3, 1=GPIO5_3 |
    | reg24 | 0x60 | VI2DAT4 | 0=VI2DAT4, 1=GPIO5_4 |
    | reg25 | 0x64 | VI2DAT5 | 0=VI2DAT5, 1=GPIO5_5 |
    | reg26 | 0x68 | VI2DAT6 | 0=VI2DAT6, 1=GPIO5_6 |
    | reg27 | 0x6C | VI2DAT7 | 0=VI2DAT7, 1=GPIO5_7 |
    | reg28 | 0x70 | VI3DAT0 | 0=VI3DAT0, 1=GPIO6_0 |
    | reg29 | 0x74 | VI3DAT1 | 0=VI3DAT1, 1=GPIO6_1 |
    | reg30 | 0x78 | VI3DAT2 | 0=VI3DAT2, 1=GPIO6_2 |
    | reg31 | 0x7C | VI3DAT3 | 0=VI3DAT3, 1=GPIO6_3 |
    | reg32 | 0x80 | VI3DAT4 | 0=VI3DAT4, 1=GPIO6_4 |
    | reg33 | 0x84 | VI3DAT5 | 0=VI3DAT5, 1=GPIO6_5 |
    | reg34 | 0x88 | VI3DAT6 | 0=VI3DAT6, 1=GPIO6_6 |
    | reg35 | 0x8C | VI3DAT7 | 0=VI3DAT7, 1=GPIO6_7 |
    | reg36 | 0x90 | VO0CK | 00=GPIO1_5, 01=VO0CK, 10=VORDAT0 |
    | reg37 | 0x94 | VO0DAT0 | 00=GPIO2_0, 01=VO0DAT0, 10=VORDAT1 |
    | reg38 | 0x98 | VO0DAT1 | 00=GPIO2_1, 01=VO0DAT1, 10=VORDAT2 |
    | reg39 | 0x9C | VO0DAT2 | 00=GPIO2_2, 01=VO0DAT2, 10=VORDAT3 |
    | reg40 | 0xA0 | VO0DAT3 | 00=GPIO2_3, 01=VO0DAT3, 10=VORDAT4 |
    | reg41 | 0xA4 | VO0DAT4 | 00=GPIO2_4, 01=VO0DAT4, 10=VORDAT5 |
    | reg42 | 0xA8 | VO0DAT5 | 00=GPIO2_5, 01=VO0DAT5, 10=VORDAT6 |
    | reg43 | 0xAC | VO0DAT6 | 00=GPIO2_6, 01=VO0DAT6, 10=VORDAT7 |
    | reg44 | 0xB0 | VO0DAT7 | 00=GPIO2_7, 01=VO0DAT7, 10=VOGDAT0 |
    | reg45 | 0xB4 | VO1CK | 00=GPIO7_2, 01=VO1CK, 10=SDIOCK |
    | reg46 | 0xB8 | VO1DAT0 | 0=VGA1HS, 1=VO1DAT0 |
    | reg47 | 0xBC | VO1DAT1 | 0=VGA1VS, 1=VO1DAT1 |
    | reg48 | 0xC0 | VO1DAT2 | 00=SDIOCMD, 01=VO1DAT2, 10=VOGDAT1 |
    | reg49 | 0xC4 | VO1DAT3 | 00=SDIODAT0, 01=VO1DAT3, 10=VOGDAT2 |
    | reg50 | 0xC8 | VO1DAT4 | 00=SDIODAT1, 01=VO1DAT4, 10=VOGDAT3 |
    | reg51 | 0xCC | VO1DAT5 | 00=SDIODAT2, 01=VO1DAT5, 10=VOGDAT4 |
    | reg52 | 0xD0 | VO1DAT6 | 00=SDIODAT3, 01=VO1DAT6, 10=VOGDAT5 |
    | reg53 | 0xD4 | VO1DAT7 | 00=GPIO1_6, 01=VO1DAT7, 10=VOGDAT6 |
    | reg54 | 0xD8 | VO1DAT8 | 00=SPICK, 01=VO1DAT8, 10=VOGDAT7 |
    | reg55 | 0xDC | VO1DAT9 | 00=SPIDI, 01=VO1DAT9, 10=VOBDAT0 |
    | reg56 | 0xE0 | VO1DAT10 | 00=SPIDO, 01=VO1DAT10, 10=VOBDAT1 |
    | reg57 | 0xE4 | VO1DAT11 | 00=SPICSN0, 01=VO1DAT11, 10=VOBDAT2 |
    | reg58 | 0xE8 | VO1DAT12 | 00=SPICSN1, 01=VO1DAT12, 10=VOBDAT3 |
    | reg59 | 0xEC | VO1DAT13 | 00=GPIO7_4, 01=VO1DAT13, 10=VOBDAT4, 11=VGA0HS |
    | reg60 | 0xF0 | VO1DAT14 | 00=GPIO7_5, 01=VO1DAT14, 10=VOBDAT5, 11=VGA0VS |
    | reg61 | 0xF4 | VO1DAT15 | 00=GPIO1_7, 01=VO1DAT15, 10=VOBDAT6 |
    | reg62 | 0xF8 | GPIO3_0 | 0=GPIO3_0, 1=VOBDAT7 |
    | reg63 | 0xFC | SDA | 0=SDA, 1=GPIO0_0 |
    | reg64 | 0x100 | SCL | 0=SCL, 1=GPIO0_1 |
    | reg65 | 0x104 | SIO0XFS | 0=SIO0XFS, 1=GPIO0_2 |
    | reg66 | 0x108 | SIO0XCK | 0=SIO0XCK, 1=GPIO0_3 |
    | reg67 | 0x10C | ACKOUT | 0=GPIO0_4, 1=ACKOUT |
    | reg68 | 0x110 | SIO2DI | 00=GPIO0_5, 01=SIO2DI, 10=SIO1DO |
    | reg69 | 0x114 | SIO2RFS | 00=GPIO0_6, 01=SIO2RFS, 10=SIO1XFS |
    | reg70 | 0x118 | SIO2RCK | 00=GPIO0_7, 01=SIO2RCK, 10=SIO1XCK |
    | reg71 | 0x11C | SMICS1N | 0=GPIO3_2, 1=SMICS1N |
    | reg72 | 0x120 | NFCS1N | 0=GPIO3_3, 1=NFCS1N |
    | reg73 | 0x124 | NFRB | 0=NFRB, 1=GPIO3_1 |
    | reg74 | 0x128 | EBIRDYN | 0=EBIRDYN, 1=IRRCV |
    | reg75 | 0x12C | GTCLKOUT | 0=GPIO1_0, 1=GTCLKOUT |
    | reg76 | 0x130 | GCOL | 0=GCOL, 1=GPIO1_1 |
    | reg77 | 0x134 | GCRS | 0=GCRS, 1=GPIO1_2 |
    | reg78 | 0x138 | PCIREQ3N | 0=GPIO3_6, 1=PCIREQ3N |
    | reg79 | 0x13C | PCIREQ4N | 0=GPIO3_7, 1=PCIREQ4N |
    | reg80 | 0x140 | PCIGRANT3N | 0=GPIO7_0, 1=PCIGRANT3N |
    | reg81 | 0x144 | PCIGRANT4N | 0=GPIO7_1, 1=PCIGRANT4N |
    | reg82 | 0x148 | VORGBDV | 0=GPIO7_3, 1=VORGBDV |
    ";

    reg {
        name = "Multiplexing control register for the VI0HS pin";
        desc = "reg0 is the multiplexing control register for the VI0HS pin (DS: VI0HS pin multiplexing control register). Reset value 0 selects VI0HS. Other values: reserved (Other: reserved).

Data sheet 2.5 reg0 (offset 0x0, printed page 2-66, `hi3520v100--Hi3520-Datasheet.txt` line 5305).";

        enum reg0_reg0_enum {
            VI0HS = 0 { name = "Vi0Hs"; desc = "VI0HS"; };
            URXD2 = 1 { name = "Urxd2"; desc = "URXD2"; };
            GPIO1_3 = 2 { name = "Gpio1 3"; desc = "GPIO1_3"; };
        };

        field {
            name = "reg0";
            desc = "Function of the VI0HS pin (DS: VI0HS pin function selection details).";
            sw = rw;
            hw = r;
            encode = reg0_reg0_enum;
            reset = 0x0;
        } reg0[1:0];
    } reg0 @ 0x0;

    reg {
        name = "Multiplexing control register for the VI0VS pin";
        desc = "reg1 is the multiplexing control register for the VI0VS pin (DS: VI0VS pin multiplexing control register). Reset value 0 selects VI0VS. Other values: reserved (Other: reserved).

Data sheet 2.5 reg1 (offset 0x4, printed page 2-67, `hi3520v100--Hi3520-Datasheet.txt` line 5341).";

        enum reg1_reg1_enum {
            VI0VS = 0 { name = "Vi0Vs"; desc = "VI0VS"; };
            UTXD2 = 1 { name = "Utxd2"; desc = "UTXD2"; };
            GPIO1_4 = 2 { name = "Gpio1 4"; desc = "GPIO1_4"; };
        };

        field {
            name = "reg1";
            desc = "Function of the VI0VS pin (DS: VI0VS pin function selection details).";
            sw = rw;
            hw = r;
            encode = reg1_reg1_enum;
            reset = 0x0;
        } reg1[1:0];
    } reg1 @ 0x4;

    reg {
        name = "Multiplexing control register for the VI0DAT0 pin";
        desc = "reg2 is the multiplexing control register for the VI0DAT0 pin (DS: VI0DAT0 pin multiplexing control register). Reset value 0 selects VI0DAT0.

Data sheet 2.5 reg2 (offset 0x8, printed page 2-67, `hi3520v100--Hi3520-Datasheet.txt` line 5368).";

        enum reg2_reg2_enum {
            VI0DAT0 = 0 { name = "Vi0Dat0"; desc = "VI0DAT0"; };
            VOUDAT8 = 1 { name = "Voudat8"; desc = "VOUDAT8"; };
        };

        field {
            name = "reg2";
            desc = "Function of the VI0DAT0 pin (DS: VI0DAT0 pin function selection details).";
            sw = rw;
            hw = r;
            encode = reg2_reg2_enum;
            reset = 0x0;
        } reg2[0:0];
    } reg2 @ 0x8;

    reg {
        name = "Multiplexing control register for the VI0DAT1 pin";
        desc = "reg3 is the multiplexing control register for the VI0DAT1 pin (DS: VI0DAT1 pin multiplexing control register). Reset value 0 selects VI0DAT1.

Data sheet 2.5 reg3 (offset 0xC, printed page 2-68, `hi3520v100--Hi3520-Datasheet.txt` line 5403).";

        enum reg3_reg3_enum {
            VI0DAT1 = 0 { name = "Vi0Dat1"; desc = "VI0DAT1"; };
            VOUDAT9 = 1 { name = "Voudat9"; desc = "VOUDAT9"; };
        };

        field {
            name = "reg3";
            desc = "Function of the VI0DAT1 pin (DS: VI0DAT1 pin function selection details).";
            sw = rw;
            hw = r;
            encode = reg3_reg3_enum;
            reset = 0x0;
        } reg3[0:0];
    } reg3 @ 0xC;

    reg {
        name = "Multiplexing control register for the VI0DAT2 pin";
        desc = "reg4 is the multiplexing control register for the VI0DAT2 pin (DS: VI0DAT2 pin multiplexing control register). Reset value 0 selects VI0DAT2.

Data sheet 2.5 reg4 (offset 0x10, printed page 2-68, `hi3520v100--Hi3520-Datasheet.txt` line 5428).";

        enum reg4_reg4_enum {
            VI0DAT2 = 0 { name = "Vi0Dat2"; desc = "VI0DAT2"; };
            VOUDAT10 = 1 { name = "Voudat10"; desc = "VOUDAT10"; };
        };

        field {
            name = "reg4";
            desc = "Function of the VI0DAT2 pin (DS: VI0DAT2 pin function selection details).";
            sw = rw;
            hw = r;
            encode = reg4_reg4_enum;
            reset = 0x0;
        } reg4[0:0];
    } reg4 @ 0x10;

    reg {
        name = "Multiplexing control register for the VI0DAT3 pin";
        desc = "reg5 is the multiplexing control register for the VI0DAT3 pin (DS: VI0DAT3 pin multiplexing control register). Reset value 0 selects VI0DAT3.

Data sheet 2.5 reg5 (offset 0x14, printed page 2-69, `hi3520v100--Hi3520-Datasheet.txt` line 5459).";

        enum reg5_reg5_enum {
            VI0DAT3 = 0 { name = "Vi0Dat3"; desc = "VI0DAT3"; };
            VOUDAT11 = 1 { name = "Voudat11"; desc = "VOUDAT11"; };
        };

        field {
            name = "reg5";
            desc = "Function of the VI0DAT3 pin (DS: VI0DAT3 pin function selection details).";
            sw = rw;
            hw = r;
            encode = reg5_reg5_enum;
            reset = 0x0;
        } reg5[0:0];
    } reg5 @ 0x14;

    reg {
        name = "Multiplexing control register for the VI0DAT4 pin";
        desc = "reg6 is the multiplexing control register for the VI0DAT4 pin (DS: VI0DAT4 pin multiplexing control register). Reset value 0 selects VI0DAT4.

Data sheet 2.5 reg6 (offset 0x18, printed page 2-69, `hi3520v100--Hi3520-Datasheet.txt` line 5484).";

        enum reg6_reg6_enum {
            VI0DAT4 = 0 { name = "Vi0Dat4"; desc = "VI0DAT4"; };
            VOUDAT12 = 1 { name = "Voudat12"; desc = "VOUDAT12"; };
        };

        field {
            name = "reg6";
            desc = "Function of the VI0DAT4 pin (DS: VI0DAT4 pin function selection details).";
            sw = rw;
            hw = r;
            encode = reg6_reg6_enum;
            reset = 0x0;
        } reg6[0:0];
    } reg6 @ 0x18;

    reg {
        name = "Multiplexing control register for the VI0DAT5 pin";
        desc = "reg7 is the multiplexing control register for the VI0DAT5 pin (DS: VI0DAT5 pin multiplexing control register). Reset value 0 selects VI0DAT5.

Data sheet 2.5 reg7 (offset 0x1C, printed page 2-70, `hi3520v100--Hi3520-Datasheet.txt` line 5518).";

        enum reg7_reg7_enum {
            VI0DAT5 = 0 { name = "Vi0Dat5"; desc = "VI0DAT5"; };
            VOUDAT13 = 1 { name = "Voudat13"; desc = "VOUDAT13"; };
        };

        field {
            name = "reg7";
            desc = "Function of the VI0DAT5 pin (DS: VI0DAT5 pin function selection details).";
            sw = rw;
            hw = r;
            encode = reg7_reg7_enum;
            reset = 0x0;
        } reg7[0:0];
    } reg7 @ 0x1C;

    reg {
        name = "Multiplexing control register for the VI0DAT6 pin";
        desc = "reg8 is the multiplexing control register for the VI0DAT6 pin (DS: VI0DAT6 pin multiplexing control register). Reset value 0 selects VI0DAT6.

Data sheet 2.5 reg8 (offset 0x20, printed page 2-70, `hi3520v100--Hi3520-Datasheet.txt` line 5543).";

        enum reg8_reg8_enum {
            VI0DAT6 = 0 { name = "Vi0Dat6"; desc = "VI0DAT6"; };
            VOUDAT14 = 1 { name = "Voudat14"; desc = "VOUDAT14"; };
        };

        field {
            name = "reg8";
            desc = "Function of the VI0DAT6 pin (DS: VI0DAT6 pin function selection details).";
            sw = rw;
            hw = r;
            encode = reg8_reg8_enum;
            reset = 0x0;
        } reg8[0:0];
    } reg8 @ 0x20;

    reg {
        name = "Multiplexing control register for the VI0DAT7 pin";
        desc = "reg9 is the multiplexing control register for the VI0DAT7 pin (DS: VI0DAT7 pin multiplexing control register). Reset value 0 selects VI0DAT7.

Data sheet 2.5 reg9 (offset 0x24, printed page 2-71, `hi3520v100--Hi3520-Datasheet.txt` line 5577).";

        enum reg9_reg9_enum {
            VI0DAT7 = 0 { name = "Vi0Dat7"; desc = "VI0DAT7"; };
            VOUDAT15 = 1 { name = "Voudat15"; desc = "VOUDAT15"; };
        };

        field {
            name = "reg9";
            desc = "Function of the VI0DAT7 pin (DS: VI0DAT7 pin function selection details).";
            sw = rw;
            hw = r;
            encode = reg9_reg9_enum;
            reset = 0x0;
        } reg9[0:0];
    } reg9 @ 0x24;

    reg {
        name = "Multiplexing control register for the VI1DAT0 pin";
        desc = "reg10 is the multiplexing control register for the VI1DAT0 pin (DS: VI1DAT0 pin multiplexing control register). Reset value 0 selects VI1DAT0. Other values: reserved (Other: reserved).

Data sheet 2.5 reg10 (offset 0x28, printed page 2-71, `hi3520v100--Hi3520-Datasheet.txt` line 5602).";

        enum reg10_reg10_enum {
            VI1DAT0 = 0 { name = "Vi1Dat0"; desc = "VI1DAT0"; };
            GPIO4_0 = 1 { name = "Gpio4 0"; desc = "GPIO4_0"; };
            VOUDAT0 = 2 { name = "Voudat0"; desc = "VOUDAT0"; };
        };

        field {
            name = "reg10";
            desc = "Function of the VI1DAT0 pin (DS: VI1DAT0 pin function selection details).";
            sw = rw;
            hw = r;
            encode = reg10_reg10_enum;
            reset = 0x0;
        } reg10[1:0];
    } reg10 @ 0x28;

    reg {
        name = "Multiplexing control register for the VI1DAT1 pin";
        desc = "reg11 is the multiplexing control register for the VI1DAT1 pin (DS: VI1DAT1 pin multiplexing control register). Reset value 0 selects VI1DAT1. Other values: reserved (Other: reserved).

Data sheet 2.5 reg11 (offset 0x2C, printed page 2-72, `hi3520v100--Hi3520-Datasheet.txt` line 5638).";

        enum reg11_reg11_enum {
            VI1DAT1 = 0 { name = "Vi1Dat1"; desc = "VI1DAT1"; };
            GPIO4_1 = 1 { name = "Gpio4 1"; desc = "GPIO4_1"; };
            VOUDAT1 = 2 { name = "Voudat1"; desc = "VOUDAT1"; };
        };

        field {
            name = "reg11";
            desc = "Function of the VI1DAT1 pin (DS: VI1DAT1 pin function selection details).";
            sw = rw;
            hw = r;
            encode = reg11_reg11_enum;
            reset = 0x0;
        } reg11[1:0];
    } reg11 @ 0x2C;

    reg {
        name = "Multiplexing control register for the VI1DAT2 pin";
        desc = "reg12 is the multiplexing control register for the VI1DAT2 pin (DS: VI1DAT2 pin multiplexing control register). Reset value 0 selects VI1DAT2. Other values: reserved (Other: reserved).

Data sheet 2.5 reg12 (offset 0x30, printed page 2-72, `hi3520v100--Hi3520-Datasheet.txt` line 5665).";

        enum reg12_reg12_enum {
            VI1DAT2 = 0 { name = "Vi1Dat2"; desc = "VI1DAT2"; };
            GPIO4_2 = 1 { name = "Gpio4 2"; desc = "GPIO4_2"; };
            VOUDAT2 = 2 { name = "Voudat2"; desc = "VOUDAT2"; };
        };

        field {
            name = "reg12";
            desc = "Function of the VI1DAT2 pin (DS: VI1DAT2 pin function selection details).";
            sw = rw;
            hw = r;
            encode = reg12_reg12_enum;
            reset = 0x0;
        } reg12[1:0];
    } reg12 @ 0x30;

    reg {
        name = "Multiplexing control register for the VI1DAT3 pin";
        desc = "reg13 is the multiplexing control register for the VI1DAT3 pin (DS: VI1DAT3 pin multiplexing control register). Reset value 0 selects VI1DAT3. Other values: reserved (Other: reserved).

Data sheet 2.5 reg13 (offset 0x34, printed page 2-73, `hi3520v100--Hi3520-Datasheet.txt` line 5700).";

        enum reg13_reg13_enum {
            VI1DAT3 = 0 { name = "Vi1Dat3"; desc = "VI1DAT3"; };
            GPIO4_3 = 1 { name = "Gpio4 3"; desc = "GPIO4_3"; };
            VOUDAT3 = 2 { name = "Voudat3"; desc = "VOUDAT3"; };
        };

        field {
            name = "reg13";
            desc = "Function of the VI1DAT3 pin (DS: VI1DAT3 pin function selection details).";
            sw = rw;
            hw = r;
            encode = reg13_reg13_enum;
            reset = 0x0;
        } reg13[1:0];
    } reg13 @ 0x34;

    reg {
        name = "Multiplexing control register for the VI1DAT4 pin";
        desc = "reg14 is the multiplexing control register for the VI1DAT4 pin (DS: VI1DAT4 pin multiplexing control register). Reset value 0 selects VI1DAT4. Other values: reserved (Other: reserved).

Data sheet 2.5 reg14 (offset 0x38, printed page 2-73, `hi3520v100--Hi3520-Datasheet.txt` line 5727).";

        enum reg14_reg14_enum {
            VI1DAT4 = 0 { name = "Vi1Dat4"; desc = "VI1DAT4"; };
            GPIO4_4 = 1 { name = "Gpio4 4"; desc = "GPIO4_4"; };
            VOUDAT4 = 2 { name = "Voudat4"; desc = "VOUDAT4"; };
        };

        field {
            name = "reg14";
            desc = "Function of the VI1DAT4 pin (DS: VI1DAT4 pin function selection details).";
            sw = rw;
            hw = r;
            encode = reg14_reg14_enum;
            reset = 0x0;
        } reg14[1:0];
    } reg14 @ 0x38;

    reg {
        name = "Multiplexing control register for the VI1DAT5 pin";
        desc = "reg15 is the multiplexing control register for the VI1DAT5 pin (DS: VI1DAT5 pin multiplexing control register). Reset value 0 selects VI1DAT5. Other values: reserved (Other: reserved).

Data sheet 2.5 reg15 (offset 0x3C, printed page 2-74, `hi3520v100--Hi3520-Datasheet.txt` line 5762).";

        enum reg15_reg15_enum {
            VI1DAT5 = 0 { name = "Vi1Dat5"; desc = "VI1DAT5"; };
            GPIO4_5 = 1 { name = "Gpio4 5"; desc = "GPIO4_5"; };
            VOUDAT5 = 2 { name = "Voudat5"; desc = "VOUDAT5"; };
        };

        field {
            name = "reg15";
            desc = "Function of the VI1DAT5 pin (DS: VI1DAT5 pin function selection details).";
            sw = rw;
            hw = r;
            encode = reg15_reg15_enum;
            reset = 0x0;
        } reg15[1:0];
    } reg15 @ 0x3C;

    reg {
        name = "Multiplexing control register for the VI1DAT6 pin";
        desc = "reg16 is the multiplexing control register for the VI1DAT6 pin (DS: VI1DAT6 pin multiplexing control register). Reset value 0 selects VI1DAT6. Other values: reserved (Other: reserved).

Data sheet 2.5 reg16 (offset 0x40, printed page 2-74, `hi3520v100--Hi3520-Datasheet.txt` line 5789).";

        enum reg16_reg16_enum {
            VI1DAT6 = 0 { name = "Vi1Dat6"; desc = "VI1DAT6"; };
            GPIO4_6 = 1 { name = "Gpio4 6"; desc = "GPIO4_6"; };
            VOUDAT6 = 2 { name = "Voudat6"; desc = "VOUDAT6"; };
        };

        field {
            name = "reg16";
            desc = "Function of the VI1DAT6 pin (DS: VI1DAT6 pin function selection details).";
            sw = rw;
            hw = r;
            encode = reg16_reg16_enum;
            reset = 0x0;
        } reg16[1:0];
    } reg16 @ 0x40;

    reg {
        name = "Multiplexing control register for the VI1DAT7 pin";
        desc = "reg17 is the multiplexing control register for the VI1DAT7 pin (DS: VI1DAT7 pin multiplexing control register). Reset value 0 selects VI1DAT7. Other values: reserved (Other: reserved).

Data sheet 2.5 reg17 (offset 0x44, printed page 2-75, `hi3520v100--Hi3520-Datasheet.txt` line 5824).";

        enum reg17_reg17_enum {
            VI1DAT7 = 0 { name = "Vi1Dat7"; desc = "VI1DAT7"; };
            GPIO4_7 = 1 { name = "Gpio4 7"; desc = "GPIO4_7"; };
            VOUDAT7 = 2 { name = "Voudat7"; desc = "VOUDAT7"; };
        };

        field {
            name = "reg17";
            desc = "Function of the VI1DAT7 pin (DS: VI1DAT7 pin function selection details).";
            sw = rw;
            hw = r;
            encode = reg17_reg17_enum;
            reset = 0x0;
        } reg17[1:0];
    } reg17 @ 0x44;

    reg {
        name = "Multiplexing control register for the VI2HS pin";
        desc = "reg18 is the multiplexing control register for the VI2HS pin (DS: VI2HS pin multiplexing control register). Reset value 0 selects VI2HS. Other values: reserved (Other: reserved).

Data sheet 2.5 reg18 (offset 0x48, printed page 2-75, `hi3520v100--Hi3520-Datasheet.txt` line 5851).";

        enum reg18_reg18_enum {
            VI2HS = 0 { name = "Vi2Hs"; desc = "VI2HS"; };
            URXD3 = 1 { name = "Urxd3"; desc = "URXD3"; };
            GPIO3_4 = 2 { name = "Gpio3 4"; desc = "GPIO3_4"; };
        };

        field {
            name = "reg18";
            desc = "Function of the VI2HS pin (DS: VI2HS pin function selection details).";
            sw = rw;
            hw = r;
            encode = reg18_reg18_enum;
            reset = 0x0;
        } reg18[1:0];
    } reg18 @ 0x48;

    reg {
        name = "Multiplexing control register for the VI2VS pin";
        desc = "reg19 is the multiplexing control register for the VI2VS pin (DS: VI2VS pin multiplexing control register). Reset value 0 selects VI2VS. Other values: reserved (Other: reserved).

Data sheet 2.5 reg19 (offset 0x4C, printed page 2-76, `hi3520v100--Hi3520-Datasheet.txt` line 5886).";

        enum reg19_reg19_enum {
            VI2VS = 0 { name = "Vi2Vs"; desc = "VI2VS"; };
            UTXD3 = 1 { name = "Utxd3"; desc = "UTXD3"; };
            GPIO3_5 = 2 { name = "Gpio3 5"; desc = "GPIO3_5"; };
        };

        field {
            name = "reg19";
            desc = "Function of the VI2VS pin (DS: VI2VS pin function selection details).";
            sw = rw;
            hw = r;
            encode = reg19_reg19_enum;
            reset = 0x0;
        } reg19[1:0];
    } reg19 @ 0x4C;

    reg {
        name = "Multiplexing control register for the VI2DAT0 pin";
        desc = "reg20 is the multiplexing control register for the VI2DAT0 pin (DS: VI2DAT0 pin multiplexing control register). Reset value 0 selects VI2DAT0.

Data sheet 2.5 reg20 (offset 0x50, printed page 2-76, `hi3520v100--Hi3520-Datasheet.txt` line 5913).";

        enum reg20_reg20_enum {
            VI2DAT0 = 0 { name = "Vi2Dat0"; desc = "VI2DAT0"; };
            GPIO5_0 = 1 { name = "Gpio5 0"; desc = "GPIO5_0"; };
        };

        field {
            name = "reg20";
            desc = "Function of the VI2DAT0 pin (DS: VI2DAT0 pin function selection details).";
            sw = rw;
            hw = r;
            encode = reg20_reg20_enum;
            reset = 0x0;
        } reg20[0:0];
    } reg20 @ 0x50;

    reg {
        name = "Multiplexing control register for the VI2DAT1 pin";
        desc = "reg21 is the multiplexing control register for the VI2DAT1 pin (DS: VI2DAT1 pin multiplexing control register). Reset value 0 selects VI2DAT1.

Data sheet 2.5 reg21 (offset 0x54, printed page 2-77, `hi3520v100--Hi3520-Datasheet.txt` line 5947).";

        enum reg21_reg21_enum {
            VI2DAT1 = 0 { name = "Vi2Dat1"; desc = "VI2DAT1"; };
            GPIO5_1 = 1 { name = "Gpio5 1"; desc = "GPIO5_1"; };
        };

        field {
            name = "reg21";
            desc = "Function of the VI2DAT1 pin (DS: VI2DAT1 pin function selection details).";
            sw = rw;
            hw = r;
            encode = reg21_reg21_enum;
            reset = 0x0;
        } reg21[0:0];
    } reg21 @ 0x54;

    reg {
        name = "Multiplexing control register for the VI2DAT2 pin";
        desc = "reg22 is the multiplexing control register for the VI2DAT2 pin (DS: VI2DAT2 pin multiplexing control register). Reset value 0 selects VI2DAT2.

Data sheet 2.5 reg22 (offset 0x58, printed page 2-77, `hi3520v100--Hi3520-Datasheet.txt` line 5972).";

        enum reg22_reg22_enum {
            VI2DAT2 = 0 { name = "Vi2Dat2"; desc = "VI2DAT2"; };
            GPIO5_2 = 1 { name = "Gpio5 2"; desc = "GPIO5_2"; };
        };

        field {
            name = "reg22";
            desc = "Function of the VI2DAT2 pin (DS: VI2DAT2 pin function selection details).";
            sw = rw;
            hw = r;
            encode = reg22_reg22_enum;
            reset = 0x0;
        } reg22[0:0];
    } reg22 @ 0x58;

    reg {
        name = "Multiplexing control register for the VI2DAT3 pin";
        desc = "reg23 is the multiplexing control register for the VI2DAT3 pin (DS: VI2DAT3 pin multiplexing control register). Reset value 0 selects VI2DAT3.

Data sheet 2.5 reg23 (offset 0x5C, printed page 2-78, `hi3520v100--Hi3520-Datasheet.txt` line 6006).";

        enum reg23_reg23_enum {
            VI2DAT3 = 0 { name = "Vi2Dat3"; desc = "VI2DAT3"; };
            GPIO5_3 = 1 { name = "Gpio5 3"; desc = "GPIO5_3"; };
        };

        field {
            name = "reg23";
            desc = "Function of the VI2DAT3 pin (DS: VI2DAT3 pin function selection details).";
            sw = rw;
            hw = r;
            encode = reg23_reg23_enum;
            reset = 0x0;
        } reg23[0:0];
    } reg23 @ 0x5C;

    reg {
        name = "Multiplexing control register for the VI2DAT4 pin";
        desc = "reg24 is the multiplexing control register for the VI2DAT4 pin (DS: VI2DAT4 pin multiplexing control register). Reset value 0 selects VI2DAT4.

Data sheet 2.5 reg24 (offset 0x60, printed page 2-78, `hi3520v100--Hi3520-Datasheet.txt` line 6031).";

        enum reg24_reg24_enum {
            VI2DAT4 = 0 { name = "Vi2Dat4"; desc = "VI2DAT4"; };
            GPIO5_4 = 1 { name = "Gpio5 4"; desc = "GPIO5_4"; };
        };

        field {
            name = "reg24";
            desc = "Function of the VI2DAT4 pin (DS: VI2DAT4 pin function selection details).";
            sw = rw;
            hw = r;
            encode = reg24_reg24_enum;
            reset = 0x0;
        } reg24[0:0];
    } reg24 @ 0x60;

    reg {
        name = "Multiplexing control register for the VI2DAT5 pin";
        desc = "reg25 is the multiplexing control register for the VI2DAT5 pin (DS: VI2DAT5 pin multiplexing control register). Reset value 0 selects VI2DAT5.

Data sheet 2.5 reg25 (offset 0x64, printed page 2-79, `hi3520v100--Hi3520-Datasheet.txt` line 6065).";

        enum reg25_reg25_enum {
            VI2DAT5 = 0 { name = "Vi2Dat5"; desc = "VI2DAT5"; };
            GPIO5_5 = 1 { name = "Gpio5 5"; desc = "GPIO5_5"; };
        };

        field {
            name = "reg25";
            desc = "Function of the VI2DAT5 pin (DS: VI2DAT5 pin function selection details).";
            sw = rw;
            hw = r;
            encode = reg25_reg25_enum;
            reset = 0x0;
        } reg25[0:0];
    } reg25 @ 0x64;

    reg {
        name = "Multiplexing control register for the VI2DAT6 pin";
        desc = "reg26 is the multiplexing control register for the VI2DAT6 pin (DS: VI2DAT6 pin multiplexing control register). Reset value 0 selects VI2DAT6.

Data sheet 2.5 reg26 (offset 0x68, printed page 2-79, `hi3520v100--Hi3520-Datasheet.txt` line 6090).";

        enum reg26_reg26_enum {
            VI2DAT6 = 0 { name = "Vi2Dat6"; desc = "VI2DAT6"; };
            GPIO5_6 = 1 { name = "Gpio5 6"; desc = "GPIO5_6"; };
        };

        field {
            name = "reg26";
            desc = "Function of the VI2DAT6 pin (DS: VI2DAT6 pin function selection details).";
            sw = rw;
            hw = r;
            encode = reg26_reg26_enum;
            reset = 0x0;
        } reg26[0:0];
    } reg26 @ 0x68;

    reg {
        name = "Multiplexing control register for the VI2DAT7 pin";
        desc = "reg27 is the multiplexing control register for the VI2DAT7 pin (DS: VI2DAT7 pin multiplexing control register). Reset value 0 selects VI2DAT7.

Data sheet 2.5 reg27 (offset 0x6C, printed page 2-80, `hi3520v100--Hi3520-Datasheet.txt` line 6124).";

        enum reg27_reg27_enum {
            VI2DAT7 = 0 { name = "Vi2Dat7"; desc = "VI2DAT7"; };
            GPIO5_7 = 1 { name = "Gpio5 7"; desc = "GPIO5_7"; };
        };

        field {
            name = "reg27";
            desc = "Function of the VI2DAT7 pin (DS: VI2DAT7 pin function selection details).";
            sw = rw;
            hw = r;
            encode = reg27_reg27_enum;
            reset = 0x0;
        } reg27[0:0];
    } reg27 @ 0x6C;

    reg {
        name = "Multiplexing control register for the VI3DAT0 pin";
        desc = "reg28 is the multiplexing control register for the VI3DAT0 pin (DS: VI3DAT0 pin multiplexing control register). Reset value 0 selects VI3DAT0.

Data sheet 2.5 reg28 (offset 0x70, printed page 2-80, `hi3520v100--Hi3520-Datasheet.txt` line 6149).";

        enum reg28_reg28_enum {
            VI3DAT0 = 0 { name = "Vi3Dat0"; desc = "VI3DAT0"; };
            GPIO6_0 = 1 { name = "Gpio6 0"; desc = "GPIO6_0"; };
        };

        field {
            name = "reg28";
            desc = "Function of the VI3DAT0 pin (DS: VI3DAT0 pin function selection details).";
            sw = rw;
            hw = r;
            encode = reg28_reg28_enum;
            reset = 0x0;
        } reg28[0:0];
    } reg28 @ 0x70;

    reg {
        name = "Multiplexing control register for the VI3DAT1 pin";
        desc = "reg29 is the multiplexing control register for the VI3DAT1 pin (DS: VI3DAT1 pin multiplexing control register). Reset value 0 selects VI3DAT1.

Data sheet 2.5 reg29 (offset 0x74, printed page 2-81, `hi3520v100--Hi3520-Datasheet.txt` line 6183).";

        enum reg29_reg29_enum {
            VI3DAT1 = 0 { name = "Vi3Dat1"; desc = "VI3DAT1"; };
            GPIO6_1 = 1 { name = "Gpio6 1"; desc = "GPIO6_1"; };
        };

        field {
            name = "reg29";
            desc = "Function of the VI3DAT1 pin (DS: VI3DAT1 pin function selection details).";
            sw = rw;
            hw = r;
            encode = reg29_reg29_enum;
            reset = 0x0;
        } reg29[0:0];
    } reg29 @ 0x74;

    reg {
        name = "Multiplexing control register for the VI3DAT2 pin";
        desc = "reg30 is the multiplexing control register for the VI3DAT2 pin (DS: VI3DAT2 pin multiplexing control register). Reset value 0 selects VI3DAT2.

Data sheet 2.5 reg30 (offset 0x78, printed page 2-81, `hi3520v100--Hi3520-Datasheet.txt` line 6208).";

        enum reg30_reg30_enum {
            VI3DAT2 = 0 { name = "Vi3Dat2"; desc = "VI3DAT2"; };
            GPIO6_2 = 1 { name = "Gpio6 2"; desc = "GPIO6_2"; };
        };

        field {
            name = "reg30";
            desc = "Function of the VI3DAT2 pin (DS: VI3DAT2 pin function selection details).";
            sw = rw;
            hw = r;
            encode = reg30_reg30_enum;
            reset = 0x0;
        } reg30[0:0];
    } reg30 @ 0x78;

    reg {
        name = "Multiplexing control register for the VI3DAT3 pin";
        desc = "reg31 is the multiplexing control register for the VI3DAT3 pin (DS: VI3DAT3 pin multiplexing control register). Reset value 0 selects VI3DAT3.

Data sheet 2.5 reg31 (offset 0x7C, printed page 2-82, `hi3520v100--Hi3520-Datasheet.txt` line 6242).";

        enum reg31_reg31_enum {
            VI3DAT3 = 0 { name = "Vi3Dat3"; desc = "VI3DAT3"; };
            GPIO6_3 = 1 { name = "Gpio6 3"; desc = "GPIO6_3"; };
        };

        field {
            name = "reg31";
            desc = "Function of the VI3DAT3 pin (DS: VI3DAT3 pin function selection details).";
            sw = rw;
            hw = r;
            encode = reg31_reg31_enum;
            reset = 0x0;
        } reg31[0:0];
    } reg31 @ 0x7C;

    reg {
        name = "Multiplexing control register for the VI3DAT4 pin";
        desc = "reg32 is the multiplexing control register for the VI3DAT4 pin (DS: VI3DAT4 pin multiplexing control register). Reset value 0 selects VI3DAT4.

Data sheet 2.5 reg32 (offset 0x80, printed page 2-82, `hi3520v100--Hi3520-Datasheet.txt` line 6267).";

        enum reg32_reg32_enum {
            VI3DAT4 = 0 { name = "Vi3Dat4"; desc = "VI3DAT4"; };
            GPIO6_4 = 1 { name = "Gpio6 4"; desc = "GPIO6_4"; };
        };

        field {
            name = "reg32";
            desc = "Function of the VI3DAT4 pin (DS: VI3DAT4 pin function selection details).";
            sw = rw;
            hw = r;
            encode = reg32_reg32_enum;
            reset = 0x0;
        } reg32[0:0];
    } reg32 @ 0x80;

    reg {
        name = "Multiplexing control register for the VI3DAT5 pin";
        desc = "reg33 is the multiplexing control register for the VI3DAT5 pin (DS: VI3DAT5 pin multiplexing control register). Reset value 0 selects VI3DAT5.

Data sheet 2.5 reg33 (offset 0x84, printed page 2-83, `hi3520v100--Hi3520-Datasheet.txt` line 6301).";

        enum reg33_reg33_enum {
            VI3DAT5 = 0 { name = "Vi3Dat5"; desc = "VI3DAT5"; };
            GPIO6_5 = 1 { name = "Gpio6 5"; desc = "GPIO6_5"; };
        };

        field {
            name = "reg33";
            desc = "Function of the VI3DAT5 pin (DS: VI3DAT5 pin function selection details).";
            sw = rw;
            hw = r;
            encode = reg33_reg33_enum;
            reset = 0x0;
        } reg33[0:0];
    } reg33 @ 0x84;

    reg {
        name = "Multiplexing control register for the VI3DAT6 pin";
        desc = "reg34 is the multiplexing control register for the VI3DAT6 pin (DS: VI3DAT6 pin multiplexing control register). Reset value 0 selects VI3DAT6.

Data sheet 2.5 reg34 (offset 0x88, printed page 2-83, `hi3520v100--Hi3520-Datasheet.txt` line 6326).";

        enum reg34_reg34_enum {
            VI3DAT6 = 0 { name = "Vi3Dat6"; desc = "VI3DAT6"; };
            GPIO6_6 = 1 { name = "Gpio6 6"; desc = "GPIO6_6"; };
        };

        field {
            name = "reg34";
            desc = "Function of the VI3DAT6 pin (DS: VI3DAT6 pin function selection details).";
            sw = rw;
            hw = r;
            encode = reg34_reg34_enum;
            reset = 0x0;
        } reg34[0:0];
    } reg34 @ 0x88;

    reg {
        name = "Multiplexing control register for the VI3DAT7 pin";
        desc = "reg35 is the multiplexing control register for the VI3DAT7 pin (DS: VI3DAT7 pin multiplexing control register). Reset value 0 selects VI3DAT7.

Data sheet 2.5 reg35 (offset 0x8C, printed page 2-84, `hi3520v100--Hi3520-Datasheet.txt` line 6360).";

        enum reg35_reg35_enum {
            VI3DAT7 = 0 { name = "Vi3Dat7"; desc = "VI3DAT7"; };
            GPIO6_7 = 1 { name = "Gpio6 7"; desc = "GPIO6_7"; };
        };

        field {
            name = "reg35";
            desc = "Function of the VI3DAT7 pin (DS: VI3DAT7 pin function selection details).";
            sw = rw;
            hw = r;
            encode = reg35_reg35_enum;
            reset = 0x0;
        } reg35[0:0];
    } reg35 @ 0x8C;

    reg {
        name = "Multiplexing control register for the VO0CK pin";
        desc = "reg36 is the multiplexing control register for the VO0CK pin (DS: VO0CK pin multiplexing control register). Reset value 0 selects GPIO1_5. Other values: reserved (Other: reserved).

Data sheet 2.5 reg36 (offset 0x90, printed page 2-84, `hi3520v100--Hi3520-Datasheet.txt` line 6385).";

        enum reg36_reg36_enum {
            GPIO1_5 = 0 { name = "Gpio1 5"; desc = "GPIO1_5"; };
            VO0CK = 1 { name = "Vo0Ck"; desc = "VO0CK"; };
            VORDAT0 = 2 { name = "Vordat0"; desc = "VORDAT0"; };
        };

        field {
            name = "reg36";
            desc = "Function of the VO0CK pin (DS: VO0CK pin function selection details).";
            sw = rw;
            hw = r;
            encode = reg36_reg36_enum;
            reset = 0x0;
        } reg36[1:0];
    } reg36 @ 0x90;

    reg {
        name = "Multiplexing control register for the VO0DAT0 pin";
        desc = "reg37 is the multiplexing control register for the VO0DAT0 pin (DS: VO0DAT0 pin multiplexing control register). Reset value 0 selects GPIO2_0. Other values: reserved (Other: reserved).

Data sheet 2.5 reg37 (offset 0x94, printed page 2-85, `hi3520v100--Hi3520-Datasheet.txt` line 6421).";

        enum reg37_reg37_enum {
            GPIO2_0 = 0 { name = "Gpio2 0"; desc = "GPIO2_0"; };
            VO0DAT0 = 1 { name = "Vo0Dat0"; desc = "VO0DAT0"; };
            VORDAT1 = 2 { name = "Vordat1"; desc = "VORDAT1"; };
        };

        field {
            name = "reg37";
            desc = "Function of the VO0DAT0 pin (DS: VO0DAT0 pin function selection details).";
            sw = rw;
            hw = r;
            encode = reg37_reg37_enum;
            reset = 0x0;
        } reg37[1:0];
    } reg37 @ 0x94;

    reg {
        name = "Multiplexing control register for the VO0DAT1 pin";
        desc = "reg38 is the multiplexing control register for the VO0DAT1 pin (DS: VO0DAT1 pin multiplexing control register). Reset value 0 selects GPIO2_1. Other values: reserved (Other: reserved).

Data sheet 2.5 reg38 (offset 0x98, printed page 2-85, `hi3520v100--Hi3520-Datasheet.txt` line 6448).";

        enum reg38_reg38_enum {
            GPIO2_1 = 0 { name = "Gpio2 1"; desc = "GPIO2_1"; };
            VO0DAT1 = 1 { name = "Vo0Dat1"; desc = "VO0DAT1"; };
            VORDAT2 = 2 { name = "Vordat2"; desc = "VORDAT2"; };
        };

        field {
            name = "reg38";
            desc = "Function of the VO0DAT1 pin (DS: VO0DAT1 pin function selection details).";
            sw = rw;
            hw = r;
            encode = reg38_reg38_enum;
            reset = 0x0;
        } reg38[1:0];
    } reg38 @ 0x98;

    reg {
        name = "Multiplexing control register for the VO0DAT2 pin";
        desc = "reg39 is the multiplexing control register for the VO0DAT2 pin (DS: VO0DAT2 pin multiplexing control register). Reset value 0 selects GPIO2_2. Other values: reserved (Other: reserved).

Data sheet 2.5 reg39 (offset 0x9C, printed page 2-86, `hi3520v100--Hi3520-Datasheet.txt` line 6483).";

        enum reg39_reg39_enum {
            GPIO2_2 = 0 { name = "Gpio2 2"; desc = "GPIO2_2"; };
            VO0DAT2 = 1 { name = "Vo0Dat2"; desc = "VO0DAT2"; };
            VORDAT3 = 2 { name = "Vordat3"; desc = "VORDAT3"; };
        };

        field {
            name = "reg39";
            desc = "Function of the VO0DAT2 pin (DS: VO0DAT2 pin function selection details).";
            sw = rw;
            hw = r;
            encode = reg39_reg39_enum;
            reset = 0x0;
        } reg39[1:0];
    } reg39 @ 0x9C;

    reg {
        name = "Multiplexing control register for the VO0DAT3 pin";
        desc = "reg40 is the multiplexing control register for the VO0DAT3 pin (DS: VO0DAT3 pin multiplexing control register). Reset value 0 selects GPIO2_3. Other values: reserved (Other: reserved).

Data sheet 2.5 reg40 (offset 0xA0, printed page 2-86, `hi3520v100--Hi3520-Datasheet.txt` line 6510).";

        enum reg40_reg40_enum {
            GPIO2_3 = 0 { name = "Gpio2 3"; desc = "GPIO2_3"; };
            VO0DAT3 = 1 { name = "Vo0Dat3"; desc = "VO0DAT3"; };
            VORDAT4 = 2 { name = "Vordat4"; desc = "VORDAT4"; };
        };

        field {
            name = "reg40";
            desc = "Function of the VO0DAT3 pin (DS: VO0DAT3 pin function selection details).";
            sw = rw;
            hw = r;
            encode = reg40_reg40_enum;
            reset = 0x0;
        } reg40[1:0];
    } reg40 @ 0xA0;

    reg {
        name = "Multiplexing control register for the VO0DAT4 pin";
        desc = "reg41 is the multiplexing control register for the VO0DAT4 pin (DS: VO0DAT4 pin multiplexing control register). Reset value 0 selects GPIO2_4. Other values: reserved (Other: reserved).

Data sheet 2.5 reg41 (offset 0xA4, printed page 2-87, `hi3520v100--Hi3520-Datasheet.txt` line 6545).";

        enum reg41_reg41_enum {
            GPIO2_4 = 0 { name = "Gpio2 4"; desc = "GPIO2_4"; };
            VO0DAT4 = 1 { name = "Vo0Dat4"; desc = "VO0DAT4"; };
            VORDAT5 = 2 { name = "Vordat5"; desc = "VORDAT5"; };
        };

        field {
            name = "reg41";
            desc = "Function of the VO0DAT4 pin (DS: VO0DAT4 pin function selection details).";
            sw = rw;
            hw = r;
            encode = reg41_reg41_enum;
            reset = 0x0;
        } reg41[1:0];
    } reg41 @ 0xA4;

    reg {
        name = "Multiplexing control register for the VO0DAT5 pin";
        desc = "reg42 is the multiplexing control register for the VO0DAT5 pin (DS: VO0DAT5 pin multiplexing control register). Reset value 0 selects GPIO2_5. Other values: reserved (Other: reserved).

Data sheet 2.5 reg42 (offset 0xA8, printed page 2-87, `hi3520v100--Hi3520-Datasheet.txt` line 6572).";

        enum reg42_reg42_enum {
            GPIO2_5 = 0 { name = "Gpio2 5"; desc = "GPIO2_5"; };
            VO0DAT5 = 1 { name = "Vo0Dat5"; desc = "VO0DAT5"; };
            VORDAT6 = 2 { name = "Vordat6"; desc = "VORDAT6"; };
        };

        field {
            name = "reg42";
            desc = "Function of the VO0DAT5 pin (DS: VO0DAT5 pin function selection details).";
            sw = rw;
            hw = r;
            encode = reg42_reg42_enum;
            reset = 0x0;
        } reg42[1:0];
    } reg42 @ 0xA8;

    reg {
        name = "Multiplexing control register for the VO0DAT6 pin";
        desc = "reg43 is the multiplexing control register for the VO0DAT6 pin (DS: VO0DAT6 pin multiplexing control register). Reset value 0 selects GPIO2_6. Other values: reserved (Other: reserved).

Data sheet 2.5 reg43 (offset 0xAC, printed page 2-88, `hi3520v100--Hi3520-Datasheet.txt` line 6607).";

        enum reg43_reg43_enum {
            GPIO2_6 = 0 { name = "Gpio2 6"; desc = "GPIO2_6"; };
            VO0DAT6 = 1 { name = "Vo0Dat6"; desc = "VO0DAT6"; };
            VORDAT7 = 2 { name = "Vordat7"; desc = "VORDAT7"; };
        };

        field {
            name = "reg43";
            desc = "Function of the VO0DAT6 pin (DS: VO0DAT6 pin function selection details).";
            sw = rw;
            hw = r;
            encode = reg43_reg43_enum;
            reset = 0x0;
        } reg43[1:0];
    } reg43 @ 0xAC;

    reg {
        name = "Multiplexing control register for the VO0DAT7 pin";
        desc = "reg44 is the multiplexing control register for the VO0DAT7 pin (DS: VO0DAT7 pin multiplexing control register). Reset value 0 selects GPIO2_7. Other values: reserved (Other: reserved).

Data sheet 2.5 reg44 (offset 0xB0, printed page 2-88, `hi3520v100--Hi3520-Datasheet.txt` line 6634).";

        enum reg44_reg44_enum {
            GPIO2_7 = 0 { name = "Gpio2 7"; desc = "GPIO2_7"; };
            VO0DAT7 = 1 { name = "Vo0Dat7"; desc = "VO0DAT7"; };
            VOGDAT0 = 2 { name = "Vogdat0"; desc = "VOGDAT0"; };
        };

        field {
            name = "reg44";
            desc = "Function of the VO0DAT7 pin (DS: VO0DAT7 pin function selection details).";
            sw = rw;
            hw = r;
            encode = reg44_reg44_enum;
            reset = 0x0;
        } reg44[1:0];
    } reg44 @ 0xB0;

    reg {
        name = "Multiplexing control register for the VO1CK pin";
        desc = "reg45 is the multiplexing control register for the VO1CK pin (DS: VO1CK pin multiplexing control register). Reset value 0 selects GPIO7_2. Other values: reserved (Other: reserved).

Data sheet 2.5 reg45 (offset 0xB4, printed page 2-89, `hi3520v100--Hi3520-Datasheet.txt` line 6669).";

        enum reg45_reg45_enum {
            GPIO7_2 = 0 { name = "Gpio7 2"; desc = "GPIO7_2"; };
            VO1CK = 1 { name = "Vo1Ck"; desc = "VO1CK"; };
            SDIOCK = 2 { name = "Sdiock"; desc = "SDIOCK"; };
        };

        field {
            name = "reg45";
            desc = "Function of the VO1CK pin (DS: VO1CK pin function selection details).";
            sw = rw;
            hw = r;
            encode = reg45_reg45_enum;
            reset = 0x0;
        } reg45[1:0];
    } reg45 @ 0xB4;

    reg {
        name = "Multiplexing control register for the VO1DAT0 pin";
        desc = "reg46 is the multiplexing control register for the VO1DAT0 pin (DS: VO1DAT0 pin multiplexing control register). Reset value 0 selects VGA1HS.

Data sheet 2.5 reg46 (offset 0xB8, printed page 2-89, `hi3520v100--Hi3520-Datasheet.txt` line 6696).";

        enum reg46_reg46_enum {
            VGA1HS = 0 { name = "Vga1Hs"; desc = "VGA1HS"; };
            VO1DAT0 = 1 { name = "Vo1Dat0"; desc = "VO1DAT0"; };
        };

        field {
            name = "reg46";
            desc = "Function of the VO1DAT0 pin (DS: VO1DAT0 pin function selection details).";
            sw = rw;
            hw = r;
            encode = reg46_reg46_enum;
            reset = 0x0;
        } reg46[0:0];
    } reg46 @ 0xB8;

    reg {
        name = "Multiplexing control register for the VO1DAT1 pin";
        desc = "reg47 is the multiplexing control register for the VO1DAT1 pin (DS: VO1DAT1 pin multiplexing control register). Reset value 0 selects VGA1VS.

Data sheet 2.5 reg47 (offset 0xBC, printed page 2-90, `hi3520v100--Hi3520-Datasheet.txt` line 6730).";

        enum reg47_reg47_enum {
            VGA1VS = 0 { name = "Vga1Vs"; desc = "VGA1VS"; };
            VO1DAT1 = 1 { name = "Vo1Dat1"; desc = "VO1DAT1"; };
        };

        field {
            name = "reg47";
            desc = "Function of the VO1DAT1 pin (DS: VO1DAT1 pin function selection details).";
            sw = rw;
            hw = r;
            encode = reg47_reg47_enum;
            reset = 0x0;
        } reg47[0:0];
    } reg47 @ 0xBC;

    reg {
        name = "Multiplexing control register for the VO1DAT2 pin";
        desc = "reg48 is the multiplexing control register for the VO1DAT2 pin (DS: VO1DAT2 pin multiplexing control register). Reset value 0 selects SDIOCMD. Other values: reserved (Other: reserved).

Data sheet 2.5 reg48 (offset 0xC0, printed page 2-90, `hi3520v100--Hi3520-Datasheet.txt` line 6755).";

        enum reg48_reg48_enum {
            SDIOCMD = 0 { name = "Sdiocmd"; desc = "SDIOCMD"; };
            VO1DAT2 = 1 { name = "Vo1Dat2"; desc = "VO1DAT2"; };
            VOGDAT1 = 2 { name = "Vogdat1"; desc = "VOGDAT1"; };
        };

        field {
            name = "reg48";
            desc = "Function of the VO1DAT2 pin (DS: VO1DAT2 pin function selection details).";
            sw = rw;
            hw = r;
            encode = reg48_reg48_enum;
            reset = 0x0;
        } reg48[1:0];
    } reg48 @ 0xC0;

    reg {
        name = "Multiplexing control register for the VO1DAT3 pin";
        desc = "reg49 is the multiplexing control register for the VO1DAT3 pin (DS: VO1DAT3 pin multiplexing control register). Reset value 0 selects SDIODAT0. Other values: reserved (Other: reserved).

Data sheet 2.5 reg49 (offset 0xC4, printed page 2-91, `hi3520v100--Hi3520-Datasheet.txt` line 6791).";

        enum reg49_reg49_enum {
            SDIODAT0 = 0 { name = "Sdiodat0"; desc = "SDIODAT0"; };
            VO1DAT3 = 1 { name = "Vo1Dat3"; desc = "VO1DAT3"; };
            VOGDAT2 = 2 { name = "Vogdat2"; desc = "VOGDAT2"; };
        };

        field {
            name = "reg49";
            desc = "Function of the VO1DAT3 pin (DS: VO1DAT3 pin function selection details).";
            sw = rw;
            hw = r;
            encode = reg49_reg49_enum;
            reset = 0x0;
        } reg49[1:0];
    } reg49 @ 0xC4;

    reg {
        name = "Multiplexing control register for the VO1DAT4 pin";
        desc = "reg50 is the multiplexing control register for the VO1DAT4 pin (DS: VO1DAT4 pin multiplexing control register). Reset value 0 selects SDIODAT1. Other values: reserved (Other: reserved).

Data sheet 2.5 reg50 (offset 0xC8, printed page 2-91, `hi3520v100--Hi3520-Datasheet.txt` line 6818).";

        enum reg50_reg50_enum {
            SDIODAT1 = 0 { name = "Sdiodat1"; desc = "SDIODAT1"; };
            VO1DAT4 = 1 { name = "Vo1Dat4"; desc = "VO1DAT4"; };
            VOGDAT3 = 2 { name = "Vogdat3"; desc = "VOGDAT3"; };
        };

        field {
            name = "reg50";
            desc = "Function of the VO1DAT4 pin (DS: VO1DAT4 pin function selection details).";
            sw = rw;
            hw = r;
            encode = reg50_reg50_enum;
            reset = 0x0;
        } reg50[1:0];
    } reg50 @ 0xC8;

    reg {
        name = "Multiplexing control register for the VO1DAT5 pin";
        desc = "reg51 is the multiplexing control register for the VO1DAT5 pin (DS: VO1DAT5 pin multiplexing control register). Reset value 0 selects SDIODAT2. Other values: reserved (Other: reserved).

Data sheet 2.5 reg51 (offset 0xCC, printed page 2-92, `hi3520v100--Hi3520-Datasheet.txt` line 6853).";

        enum reg51_reg51_enum {
            SDIODAT2 = 0 { name = "Sdiodat2"; desc = "SDIODAT2"; };
            VO1DAT5 = 1 { name = "Vo1Dat5"; desc = "VO1DAT5"; };
            VOGDAT4 = 2 { name = "Vogdat4"; desc = "VOGDAT4"; };
        };

        field {
            name = "reg51";
            desc = "Function of the VO1DAT5 pin (DS: VO1DAT5 pin function selection details).";
            sw = rw;
            hw = r;
            encode = reg51_reg51_enum;
            reset = 0x0;
        } reg51[1:0];
    } reg51 @ 0xCC;

    reg {
        name = "Multiplexing control register for the VO1DAT6 pin";
        desc = "reg52 is the multiplexing control register for the VO1DAT6 pin (DS: VO1DAT6 pin multiplexing control register). Reset value 0 selects SDIODAT3. Other values: reserved (Other: reserved).

Data sheet 2.5 reg52 (offset 0xD0, printed page 2-92, `hi3520v100--Hi3520-Datasheet.txt` line 6880).";

        enum reg52_reg52_enum {
            SDIODAT3 = 0 { name = "Sdiodat3"; desc = "SDIODAT3"; };
            VO1DAT6 = 1 { name = "Vo1Dat6"; desc = "VO1DAT6"; };
            VOGDAT5 = 2 { name = "Vogdat5"; desc = "VOGDAT5"; };
        };

        field {
            name = "reg52";
            desc = "Function of the VO1DAT6 pin (DS: VO1DAT6 pin function selection details).";
            sw = rw;
            hw = r;
            encode = reg52_reg52_enum;
            reset = 0x0;
        } reg52[1:0];
    } reg52 @ 0xD0;

    reg {
        name = "Multiplexing control register for the VO1DAT7 pin";
        desc = "reg53 is the multiplexing control register for the VO1DAT7 pin (DS: VO1DAT7 pin multiplexing control register). Reset value 0 selects GPIO1_6. Other values: reserved (Other: reserved).

Data sheet 2.5 reg53 (offset 0xD4, printed page 2-93, `hi3520v100--Hi3520-Datasheet.txt` line 6915).";

        enum reg53_reg53_enum {
            GPIO1_6 = 0 { name = "Gpio1 6"; desc = "GPIO1_6"; };
            VO1DAT7 = 1 { name = "Vo1Dat7"; desc = "VO1DAT7"; };
            VOGDAT6 = 2 { name = "Vogdat6"; desc = "VOGDAT6"; };
        };

        field {
            name = "reg53";
            desc = "Function of the VO1DAT7 pin (DS: VO1DAT7 pin function selection details).";
            sw = rw;
            hw = r;
            encode = reg53_reg53_enum;
            reset = 0x0;
        } reg53[1:0];
    } reg53 @ 0xD4;

    reg {
        name = "Multiplexing control register for the VO1DAT8 pin";
        desc = "reg54 is the multiplexing control register for the VO1DAT8 pin (DS: VO1DAT8 pin multiplexing control register). Reset value 0 selects SPICK. Other values: reserved (Other: reserved).

Data sheet 2.5 reg54 (offset 0xD8, printed page 2-93, `hi3520v100--Hi3520-Datasheet.txt` line 6942).";

        enum reg54_reg54_enum {
            SPICK = 0 { name = "Spick"; desc = "SPICK"; };
            VO1DAT8 = 1 { name = "Vo1Dat8"; desc = "VO1DAT8"; };
            VOGDAT7 = 2 { name = "Vogdat7"; desc = "VOGDAT7"; };
        };

        field {
            name = "reg54";
            desc = "Function of the VO1DAT8 pin (DS: VO1DAT8 pin function selection details).";
            sw = rw;
            hw = r;
            encode = reg54_reg54_enum;
            reset = 0x0;
        } reg54[1:0];
    } reg54 @ 0xD8;

    reg {
        name = "Multiplexing control register for the VO1DAT9 pin";
        desc = "reg55 is the multiplexing control register for the VO1DAT9 pin (DS: VO1DAT9 pin multiplexing control register). Reset value 0 selects SPIDI. Other values: reserved (Other: reserved).

Data sheet 2.5 reg55 (offset 0xDC, printed page 2-94, `hi3520v100--Hi3520-Datasheet.txt` line 6977).";

        enum reg55_reg55_enum {
            SPIDI = 0 { name = "Spidi"; desc = "SPIDI"; };
            VO1DAT9 = 1 { name = "Vo1Dat9"; desc = "VO1DAT9"; };
            VOBDAT0 = 2 { name = "Vobdat0"; desc = "VOBDAT0"; };
        };

        field {
            name = "reg55";
            desc = "Function of the VO1DAT9 pin (DS: VO1DAT9 pin function selection details).";
            sw = rw;
            hw = r;
            encode = reg55_reg55_enum;
            reset = 0x0;
        } reg55[1:0];
    } reg55 @ 0xDC;

    reg {
        name = "Multiplexing control register for the VO1DAT10 pin";
        desc = "reg56 is the multiplexing control register for the VO1DAT10 pin (DS: VO1DAT10 pin multiplexing control register). Reset value 0 selects SPIDO. Other values: reserved (Other: reserved).

Data sheet 2.5 reg56 (offset 0xE0, printed page 2-94, `hi3520v100--Hi3520-Datasheet.txt` line 7004).";

        enum reg56_reg56_enum {
            SPIDO = 0 { name = "Spido"; desc = "SPIDO"; };
            VO1DAT10 = 1 { name = "Vo1Dat10"; desc = "VO1DAT10"; };
            VOBDAT1 = 2 { name = "Vobdat1"; desc = "VOBDAT1"; };
        };

        field {
            name = "reg56";
            desc = "Function of the VO1DAT10 pin (DS: VO1DAT10 pin function selection details).";
            sw = rw;
            hw = r;
            encode = reg56_reg56_enum;
            reset = 0x0;
        } reg56[1:0];
    } reg56 @ 0xE0;

    reg {
        name = "Multiplexing control register for the VO1DAT11 pin";
        desc = "reg57 is the multiplexing control register for the VO1DAT11 pin (DS: VO1DAT11 pin multiplexing control register). Reset value 0 selects SPICSN0. Other values: reserved (Other: reserved).

Data sheet 2.5 reg57 (offset 0xE4, printed page 2-95, `hi3520v100--Hi3520-Datasheet.txt` line 7039).";

        enum reg57_reg57_enum {
            SPICSN0 = 0 { name = "Spicsn0"; desc = "SPICSN0"; };
            VO1DAT11 = 1 { name = "Vo1Dat11"; desc = "VO1DAT11"; };
            VOBDAT2 = 2 { name = "Vobdat2"; desc = "VOBDAT2"; };
        };

        field {
            name = "reg57";
            desc = "Function of the VO1DAT11 pin (DS: VO1DAT11 pin function selection details).";
            sw = rw;
            hw = r;
            encode = reg57_reg57_enum;
            reset = 0x0;
        } reg57[1:0];
    } reg57 @ 0xE4;

    reg {
        name = "Multiplexing control register for the VO1DAT12 pin";
        desc = "reg58 is the multiplexing control register for the VO1DAT12 pin (DS: VO1DAT12 pin multiplexing control register). Reset value 0 selects SPICSN1. Other values: reserved (Other: reserved).

Data sheet 2.5 reg58 (offset 0xE8, printed page 2-95, `hi3520v100--Hi3520-Datasheet.txt` line 7066).";

        enum reg58_reg58_enum {
            SPICSN1 = 0 { name = "Spicsn1"; desc = "SPICSN1"; };
            VO1DAT12 = 1 { name = "Vo1Dat12"; desc = "VO1DAT12"; };
            VOBDAT3 = 2 { name = "Vobdat3"; desc = "VOBDAT3"; };
        };

        field {
            name = "reg58";
            desc = "Function of the VO1DAT12 pin (DS: VO1DAT12 pin function selection details).";
            sw = rw;
            hw = r;
            encode = reg58_reg58_enum;
            reset = 0x0;
        } reg58[1:0];
    } reg58 @ 0xE8;

    reg {
        name = "Multiplexing control register for the VO1DAT13 pin";
        desc = "reg59 is the multiplexing control register for the VO1DAT13 pin (DS: VO1DAT13 pin multiplexing control register). Reset value 0 selects GPIO7_4.

Data sheet 2.5 reg59 (offset 0xEC, printed page 2-96, `hi3520v100--Hi3520-Datasheet.txt` line 7101).";

        enum reg59_reg59_enum {
            GPIO7_4 = 0 { name = "Gpio7 4"; desc = "GPIO7_4"; };
            VO1DAT13 = 1 { name = "Vo1Dat13"; desc = "VO1DAT13"; };
            VOBDAT4 = 2 { name = "Vobdat4"; desc = "VOBDAT4"; };
            VGA0HS = 3 { name = "Vga0Hs"; desc = "VGA0HS"; };
        };

        field {
            name = "reg59";
            desc = "Function of the VO1DAT13 pin (DS: VO1DAT13 pin function selection details).";
            sw = rw;
            hw = r;
            encode = reg59_reg59_enum;
            reset = 0x0;
        } reg59[1:0];
    } reg59 @ 0xEC;

    reg {
        name = "Multiplexing control register for the VO1DAT14 pin";
        desc = "reg60 is the multiplexing control register for the VO1DAT14 pin (DS: VO1DAT14 pin multiplexing control register). Reset value 0 selects GPIO7_5.

Data sheet 2.5 reg60 (offset 0xF0, printed page 2-96, `hi3520v100--Hi3520-Datasheet.txt` line 7128).";

        enum reg60_reg60_enum {
            GPIO7_5 = 0 { name = "Gpio7 5"; desc = "GPIO7_5"; };
            VO1DAT14 = 1 { name = "Vo1Dat14"; desc = "VO1DAT14"; };
            VOBDAT5 = 2 { name = "Vobdat5"; desc = "VOBDAT5"; };
            VGA0VS = 3 { name = "Vga0Vs"; desc = "VGA0VS"; };
        };

        field {
            name = "reg60";
            desc = "Function of the VO1DAT14 pin (DS: VO1DAT14 pin function selection details).";
            sw = rw;
            hw = r;
            encode = reg60_reg60_enum;
            reset = 0x0;
        } reg60[1:0];
    } reg60 @ 0xF0;

    reg {
        name = "Multiplexing control register for the VO1DAT15 pin";
        desc = "reg61 is the multiplexing control register for the VO1DAT15 pin (DS: VO1DAT15 pin multiplexing control register). Reset value 0 selects GPIO1_7. Other values: reserved (Other: reserved).

Data sheet 2.5 reg61 (offset 0xF4, printed page 2-97, `hi3520v100--Hi3520-Datasheet.txt` line 7163).";

        enum reg61_reg61_enum {
            GPIO1_7 = 0 { name = "Gpio1 7"; desc = "GPIO1_7"; };
            VO1DAT15 = 1 { name = "Vo1Dat15"; desc = "VO1DAT15"; };
            VOBDAT6 = 2 { name = "Vobdat6"; desc = "VOBDAT6"; };
        };

        field {
            name = "reg61";
            desc = "Function of the VO1DAT15 pin (DS: VO1DAT15 pin function selection details).";
            sw = rw;
            hw = r;
            encode = reg61_reg61_enum;
            reset = 0x0;
        } reg61[1:0];
    } reg61 @ 0xF4;

    reg {
        name = "Multiplexing control register for the GPIO3_0 pin";
        desc = "reg62 is the multiplexing control register for the GPIO3_0 pin (DS: GPIO3_0 pin multiplexing control register). Reset value 0 selects GPIO3_0.

Data sheet 2.5 reg62 (offset 0xF8, printed page 2-97, `hi3520v100--Hi3520-Datasheet.txt` line 7190).";

        enum reg62_reg62_enum {
            GPIO3_0 = 0 { name = "Gpio3 0"; desc = "GPIO3_0"; };
            VOBDAT7 = 1 { name = "Vobdat7"; desc = "VOBDAT7"; };
        };

        field {
            name = "reg62";
            desc = "Function of the GPIO3_0 pin (DS: GPIO3_0 pin function selection details).";
            sw = rw;
            hw = r;
            encode = reg62_reg62_enum;
            reset = 0x0;
        } reg62[0:0];
    } reg62 @ 0xF8;

    reg {
        name = "Multiplexing control register for the SDA pin";
        desc = "reg63 is the multiplexing control register for the SDA pin (DS: SDA pin multiplexing control register). Reset value 0 selects SDA.

Data sheet 2.5 reg63 (offset 0xFC, printed page 2-98, `hi3520v100--Hi3520-Datasheet.txt` line 7224).";

        enum reg63_reg63_enum {
            SDA = 0 { name = "Sda"; desc = "SDA"; };
            GPIO0_0 = 1 { name = "Gpio0 0"; desc = "GPIO0_0"; };
        };

        field {
            name = "reg63";
            desc = "Function of the SDA pin (DS: SDA pin function selection details).";
            sw = rw;
            hw = r;
            encode = reg63_reg63_enum;
            reset = 0x0;
        } reg63[0:0];
    } reg63 @ 0xFC;

    reg {
        name = "Multiplexing control register for the SCL pin";
        desc = "reg64 is the multiplexing control register for the SCL pin (DS: SCL pin multiplexing control register). Reset value 0 selects SCL.

Data sheet 2.5 reg64 (offset 0x100, printed page 2-98, `hi3520v100--Hi3520-Datasheet.txt` line 7249).";

        enum reg64_reg64_enum {
            SCL = 0 { name = "Scl"; desc = "SCL"; };
            GPIO0_1 = 1 { name = "Gpio0 1"; desc = "GPIO0_1"; };
        };

        field {
            name = "reg64";
            desc = "Function of the SCL pin (DS: SCL pin function selection details).";
            sw = rw;
            hw = r;
            encode = reg64_reg64_enum;
            reset = 0x0;
        } reg64[0:0];
    } reg64 @ 0x100;

    reg {
        name = "Multiplexing control register for the SIO0XFS pin";
        desc = "reg65 is the multiplexing control register for the SIO0XFS pin (DS: SIO0XFS pin multiplexing control register). Reset value 0 selects SIO0XFS.

Data sheet 2.5 reg65 (offset 0x104, printed page 2-99, `hi3520v100--Hi3520-Datasheet.txt` line 7283).";

        enum reg65_reg65_enum {
            SIO0XFS = 0 { name = "Sio0Xfs"; desc = "SIO0XFS"; };
            GPIO0_2 = 1 { name = "Gpio0 2"; desc = "GPIO0_2"; };
        };

        field {
            name = "reg65";
            desc = "Function of the SIO0XFS pin (DS: SIO0XFS pin function selection details).";
            sw = rw;
            hw = r;
            encode = reg65_reg65_enum;
            reset = 0x0;
        } reg65[0:0];
    } reg65 @ 0x104;

    reg {
        name = "Multiplexing control register for the SIO0XCK pin";
        desc = "reg66 is the multiplexing control register for the SIO0XCK pin (DS: SIO0XCK pin multiplexing control register). Reset value 0 selects SIO0XCK.

Data sheet 2.5 reg66 (offset 0x108, printed page 2-99, `hi3520v100--Hi3520-Datasheet.txt` line 7308).";

        enum reg66_reg66_enum {
            SIO0XCK = 0 { name = "Sio0Xck"; desc = "SIO0XCK"; };
            GPIO0_3 = 1 { name = "Gpio0 3"; desc = "GPIO0_3"; };
        };

        field {
            name = "reg66";
            desc = "Function of the SIO0XCK pin (DS: SIO0XCK pin function selection details).";
            sw = rw;
            hw = r;
            encode = reg66_reg66_enum;
            reset = 0x0;
        } reg66[0:0];
    } reg66 @ 0x108;

    reg {
        name = "Multiplexing control register for the ACKOUT pin";
        desc = "reg67 is the multiplexing control register for the ACKOUT pin (DS: ACKOUT pin multiplexing control register). Reset value 0 selects GPIO0_4.

Data sheet 2.5 reg67 (offset 0x10C, printed page 2-100, `hi3520v100--Hi3520-Datasheet.txt` line 7342).";

        enum reg67_reg67_enum {
            GPIO0_4 = 0 { name = "Gpio0 4"; desc = "GPIO0_4"; };
            ACKOUT = 1 { name = "Ackout"; desc = "ACKOUT"; };
        };

        field {
            name = "reg67";
            desc = "Function of the ACKOUT pin (DS: ACKOUT pin function selection details).";
            sw = rw;
            hw = r;
            encode = reg67_reg67_enum;
            reset = 0x0;
        } reg67[0:0];
    } reg67 @ 0x10C;

    reg {
        name = "Multiplexing control register for the SIO2DI pin";
        desc = "reg68 is the multiplexing control register for the SIO2DI pin (DS: SIO2DI pin multiplexing control register). Reset value 0 selects GPIO0_5. Other values: reserved (Other: reserved).

Data sheet 2.5 reg68 (offset 0x110, printed page 2-100, `hi3520v100--Hi3520-Datasheet.txt` line 7367).";

        enum reg68_reg68_enum {
            GPIO0_5 = 0 { name = "Gpio0 5"; desc = "GPIO0_5"; };
            SIO2DI = 1 { name = "Sio2Di"; desc = "SIO2DI"; };
            SIO1DO = 2 { name = "Sio1Do"; desc = "SIO1DO"; };
        };

        field {
            name = "reg68";
            desc = "Function of the SIO2DI pin (DS: SIO2DI pin function selection details).";
            sw = rw;
            hw = r;
            encode = reg68_reg68_enum;
            reset = 0x0;
        } reg68[1:0];
    } reg68 @ 0x110;

    reg {
        name = "Multiplexing control register for the SIO2RFS pin";
        desc = "reg69 is the multiplexing control register for the SIO2RFS pin (DS: SIO2RFS pin multiplexing control register). Reset value 0 selects GPIO0_6. Other values: reserved (Other: reserved).

Data sheet 2.5 reg69 (offset 0x114, printed page 2-101, `hi3520v100--Hi3520-Datasheet.txt` line 7403).";

        enum reg69_reg69_enum {
            GPIO0_6 = 0 { name = "Gpio0 6"; desc = "GPIO0_6"; };
            SIO2RFS = 1 { name = "Sio2Rfs"; desc = "SIO2RFS"; };
            SIO1XFS = 2 { name = "Sio1Xfs"; desc = "SIO1XFS"; };
        };

        field {
            name = "reg69";
            desc = "Function of the SIO2RFS pin (DS: SIO2RFS pin function selection details).";
            sw = rw;
            hw = r;
            encode = reg69_reg69_enum;
            reset = 0x0;
        } reg69[1:0];
    } reg69 @ 0x114;

    reg {
        name = "Multiplexing control register for the SIO2RCK pin";
        desc = "reg70 is the multiplexing control register for the SIO2RCK pin (DS: SIO2RCK pin multiplexing control register). Reset value 0 selects GPIO0_7. Other values: reserved (Other: reserved).

Data sheet 2.5 reg70 (offset 0x118, printed page 2-101, `hi3520v100--Hi3520-Datasheet.txt` line 7430).";

        enum reg70_reg70_enum {
            GPIO0_7 = 0 { name = "Gpio0 7"; desc = "GPIO0_7"; };
            SIO2RCK = 1 { name = "Sio2Rck"; desc = "SIO2RCK"; };
            SIO1XCK = 2 { name = "Sio1Xck"; desc = "SIO1XCK"; };
        };

        field {
            name = "reg70";
            desc = "Function of the SIO2RCK pin (DS: SIO2RCK pin function selection details).";
            sw = rw;
            hw = r;
            encode = reg70_reg70_enum;
            reset = 0x0;
        } reg70[1:0];
    } reg70 @ 0x118;

    reg {
        name = "Multiplexing control register for the SMICS1N pin";
        desc = "reg71 is the multiplexing control register for the SMICS1N pin (DS: SMICS1N pin multiplexing control register). Reset value 0 selects GPIO3_2.

Data sheet 2.5 reg71 (offset 0x11C, printed page 2-102, `hi3520v100--Hi3520-Datasheet.txt` line 7465).";

        enum reg71_reg71_enum {
            GPIO3_2 = 0 { name = "Gpio3 2"; desc = "GPIO3_2"; };
            SMICS1N = 1 { name = "Smics1N"; desc = "SMICS1N"; };
        };

        field {
            name = "reg71";
            desc = "Function of the SMICS1N pin (DS: SMICS1N pin function selection details).";
            sw = rw;
            hw = r;
            encode = reg71_reg71_enum;
            reset = 0x0;
        } reg71[0:0];
    } reg71 @ 0x11C;

    reg {
        name = "Multiplexing control register for the NFCS1N pin";
        desc = "reg72 is the multiplexing control register for the NFCS1N pin (DS: NFCS1N pin multiplexing control register). Reset value 0 selects GPIO3_3.

Data sheet 2.5 reg72 (offset 0x120, printed page 2-102, `hi3520v100--Hi3520-Datasheet.txt` line 7490).";

        enum reg72_reg72_enum {
            GPIO3_3 = 0 { name = "Gpio3 3"; desc = "GPIO3_3"; };
            NFCS1N = 1 { name = "Nfcs1N"; desc = "NFCS1N"; };
        };

        field {
            name = "reg72";
            desc = "Function of the NFCS1N pin (DS: NFCS1N pin function selection details).";
            sw = rw;
            hw = r;
            encode = reg72_reg72_enum;
            reset = 0x0;
        } reg72[0:0];
    } reg72 @ 0x120;

    reg {
        name = "Multiplexing control register for the NFRB pin";
        desc = "reg73 is the multiplexing control register for the NFRB pin (DS: NFRB pin multiplexing control register). Reset value 0 selects NFRB.

Data sheet 2.5 reg73 (offset 0x124, printed page 2-103, `hi3520v100--Hi3520-Datasheet.txt` line 7524).";

        enum reg73_reg73_enum {
            NFRB = 0 { name = "Nfrb"; desc = "NFRB"; };
            GPIO3_1 = 1 { name = "Gpio3 1"; desc = "GPIO3_1"; };
        };

        field {
            name = "reg73";
            desc = "Function of the NFRB pin (DS: NFRB pin function selection details).";
            sw = rw;
            hw = r;
            encode = reg73_reg73_enum;
            reset = 0x0;
        } reg73[0:0];
    } reg73 @ 0x124;

    reg {
        name = "Multiplexing control register for the EBIRDYN pin";
        desc = "reg74 is the multiplexing control register for the EBIRDYN pin (DS: EBIRDYN pin multiplexing control register). Reset value 0 selects EBIRDYN.

Data sheet 2.5 reg74 (offset 0x128, printed page 2-103, `hi3520v100--Hi3520-Datasheet.txt` line 7549).";

        enum reg74_reg74_enum {
            EBIRDYN = 0 { name = "Ebirdyn"; desc = "EBIRDYN"; };
            IRRCV = 1 { name = "Irrcv"; desc = "IRRCV"; };
        };

        field {
            name = "reg74";
            desc = "Function of the EBIRDYN pin (DS: EBIRDYN pin function selection details).";
            sw = rw;
            hw = r;
            encode = reg74_reg74_enum;
            reset = 0x0;
        } reg74[0:0];
    } reg74 @ 0x128;

    reg {
        name = "Multiplexing control register for the GTCLKOUT pin";
        desc = "reg75 is the multiplexing control register for the GTCLKOUT pin (DS: GTCLKOUT pin multiplexing control register). Reset value 0 selects GPIO1_0.

Data sheet 2.5 reg75 (offset 0x12C, printed page 2-104, `hi3520v100--Hi3520-Datasheet.txt` line 7583).";

        enum reg75_reg75_enum {
            GPIO1_0 = 0 { name = "Gpio1 0"; desc = "GPIO1_0"; };
            GTCLKOUT = 1 { name = "Gtclkout"; desc = "GTCLKOUT"; };
        };

        field {
            name = "reg75";
            desc = "Function of the GTCLKOUT pin (DS: GTCLKOUT pin function selection details).";
            sw = rw;
            hw = r;
            encode = reg75_reg75_enum;
            reset = 0x0;
        } reg75[0:0];
    } reg75 @ 0x12C;

    reg {
        name = "Multiplexing control register for the GCOL pin";
        desc = "reg76 is the multiplexing control register for the GCOL pin (DS: GCOL pin multiplexing control register). Reset value 0 selects GCOL.

Data sheet 2.5 reg76 (offset 0x130, printed page 2-104, `hi3520v100--Hi3520-Datasheet.txt` line 7608).";

        enum reg76_reg76_enum {
            GCOL = 0 { name = "Gcol"; desc = "GCOL"; };
            GPIO1_1 = 1 { name = "Gpio1 1"; desc = "GPIO1_1"; };
        };

        field {
            name = "reg76";
            desc = "Function of the GCOL pin (DS: GCOL pin function selection details).";
            sw = rw;
            hw = r;
            encode = reg76_reg76_enum;
            reset = 0x0;
        } reg76[0:0];
    } reg76 @ 0x130;

    reg {
        name = "Multiplexing control register for the GCRS pin";
        desc = "reg77 is the multiplexing control register for the GCRS pin (DS: GCRS pin multiplexing control register). Reset value 0 selects GCRS.

Data sheet 2.5 reg77 (offset 0x134, printed page 2-105, `hi3520v100--Hi3520-Datasheet.txt` line 7642).";

        enum reg77_reg77_enum {
            GCRS = 0 { name = "Gcrs"; desc = "GCRS"; };
            GPIO1_2 = 1 { name = "Gpio1 2"; desc = "GPIO1_2"; };
        };

        field {
            name = "reg77";
            desc = "Function of the GCRS pin (DS: GCRS pin function selection details).";
            sw = rw;
            hw = r;
            encode = reg77_reg77_enum;
            reset = 0x0;
        } reg77[0:0];
    } reg77 @ 0x134;

    reg {
        name = "Multiplexing control register for the PCIREQ3N pin";
        desc = "reg78 is the multiplexing control register for the PCIREQ3N pin (DS: PCIREQ3N pin multiplexing control register). Reset value 0 selects GPIO3_6.

Data sheet 2.5 reg78 (offset 0x138, printed page 2-105, `hi3520v100--Hi3520-Datasheet.txt` line 7667).";

        enum reg78_reg78_enum {
            GPIO3_6 = 0 { name = "Gpio3 6"; desc = "GPIO3_6"; };
            PCIREQ3N = 1 { name = "Pcireq3N"; desc = "PCIREQ3N"; };
        };

        field {
            name = "reg78";
            desc = "Function of the PCIREQ3N pin (DS: PCIREQ3N pin function selection details).";
            sw = rw;
            hw = r;
            encode = reg78_reg78_enum;
            reset = 0x0;
        } reg78[0:0];
    } reg78 @ 0x138;

    reg {
        name = "Multiplexing control register for the PCIREQ4N pin";
        desc = "reg79 is the multiplexing control register for the PCIREQ4N pin (DS: PCIREQ4N pin multiplexing control register). Reset value 0 selects GPIO3_7.

Data sheet 2.5 reg79 (offset 0x13C, printed page 2-106, `hi3520v100--Hi3520-Datasheet.txt` line 7701).";

        enum reg79_reg79_enum {
            GPIO3_7 = 0 { name = "Gpio3 7"; desc = "GPIO3_7"; };
            PCIREQ4N = 1 { name = "Pcireq4N"; desc = "PCIREQ4N"; };
        };

        field {
            name = "reg79";
            desc = "Function of the PCIREQ4N pin (DS: PCIREQ4N pin function selection details).";
            sw = rw;
            hw = r;
            encode = reg79_reg79_enum;
            reset = 0x0;
        } reg79[0:0];
    } reg79 @ 0x13C;

    reg {
        name = "Multiplexing control register for the PCIGRANT3N pin";
        desc = "reg80 is the multiplexing control register for the PCIGRANT3N pin (DS: PCIGRANT3N pin multiplexing control register). Reset value 0 selects GPIO7_0.

Data sheet 2.5 reg80 (offset 0x140, printed page 2-106, `hi3520v100--Hi3520-Datasheet.txt` line 7726).";

        enum reg80_reg80_enum {
            GPIO7_0 = 0 { name = "Gpio7 0"; desc = "GPIO7_0"; };
            PCIGRANT3N = 1 { name = "Pcigrant3N"; desc = "PCIGRANT3N"; };
        };

        field {
            name = "reg80";
            desc = "Function of the PCIGRANT3N pin (DS: PCIGRANT3N pin function selection details).";
            sw = rw;
            hw = r;
            encode = reg80_reg80_enum;
            reset = 0x0;
        } reg80[0:0];
    } reg80 @ 0x140;

    reg {
        name = "Multiplexing control register for the PCIGRANT4N pin";
        desc = "reg81 is the multiplexing control register for the PCIGRANT4N pin (DS: PCIGRANT4N pin multiplexing control register). Reset value 0 selects GPIO7_1.

Data sheet 2.5 reg81 (offset 0x144, printed page 2-107, `hi3520v100--Hi3520-Datasheet.txt` line 7760).";

        enum reg81_reg81_enum {
            GPIO7_1 = 0 { name = "Gpio7 1"; desc = "GPIO7_1"; };
            PCIGRANT4N = 1 { name = "Pcigrant4N"; desc = "PCIGRANT4N"; };
        };

        field {
            name = "reg81";
            desc = "Function of the PCIGRANT4N pin (DS: PCIGRANT4N pin function selection details).";
            sw = rw;
            hw = r;
            encode = reg81_reg81_enum;
            reset = 0x0;
        } reg81[0:0];
    } reg81 @ 0x144;

    reg {
        name = "Multiplexing control register for the VORGBDV pin";
        desc = "reg82 is the multiplexing control register for the VORGBDV pin (DS: VORGBDV pin multiplexing control register). Reset value 0 selects GPIO7_3.

Data sheet 2.5 reg82 (offset 0x148, printed page 2-107, `hi3520v100--Hi3520-Datasheet.txt` line 7785).";

        enum reg82_reg82_enum {
            GPIO7_3 = 0 { name = "Gpio7 3"; desc = "GPIO7_3"; };
            VORGBDV = 1 { name = "Vorgbdv"; desc = "VORGBDV"; };
        };

        field {
            name = "reg82";
            desc = "Function of the VORGBDV pin (DS: VORGBDV pin function selection details).";
            sw = rw;
            hw = r;
            encode = reg82_reg82_enum;
            reset = 0x0;
        } reg82[0:0];
    } reg82 @ 0x148;
};

`endif
