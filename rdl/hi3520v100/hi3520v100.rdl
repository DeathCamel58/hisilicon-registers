`include "defines.rdl"

`include "IO_CONFIG.rdl"
`include "../common/ARM_PL011.rdl"
`include "../common/ARM_PL061.rdl"
`include "../common/ARM_PL190.rdl"
`include "../common/DW_APB_I2C.rdl"
`include "../common/HISI_CIPHER.rdl"
`include "../common/HISI_DDRC.rdl"
`include "../common/HISI_DMAC.rdl"
`include "../common/HISI_DWMMC.rdl"
`include "../common/HISI_IR_V1.rdl"
`include "../common/HISI_MOTION_DETECT.rdl"
`include "../common/HISI_NANDC.rdl"
`include "../common/HISI_RTC.rdl"
`include "../common/HISI_SFC_350.rdl"
`include "../common/HISI_SIO.rdl"
`include "../common/HISI_SMI.rdl"
`include "../common/HISI_SPI.rdl"
`include "../common/HISI_SYS_CTRL.rdl"
`include "../common/HISI_TDE.rdl"
`include "../common/HISI_TIMER_SP804.rdl"
`include "../common/HISI_USB_HOST.rdl"
`include "../common/HISI_WDG_SP805.rdl"

addrmap hi3520v100 {
    name = "hi3520v100 registers";
    desc = "
        ## Datasheets

        * [Full Datasheet](assets/Hi3520-Datasheet.pdf)

        ## Diagrams

        ![Application Block Diagram](assets/Application-Block-Diagram.png)
        ![Logic Block Diagram](assets/Logic-Block-Diagram.png)

        <!-- overview:begin -->

        ### Diagrams

        ![Logic block diagram](assets/diagrams/hi3520v100-logic.svg)

        ![Register blocks by function](assets/diagrams/hi3520v100-blocks.svg)

        ![Clock tree](assets/diagrams/hi3520v100-clocks.svg)

        ![Boot flow](assets/diagrams/hi3520v100-boot.svg)

        ![Interrupt topology](assets/diagrams/hi3520v100-irq.svg)

        ![Reset tree](assets/diagrams/hi3520v100-resets.svg)

        ![Power domains](assets/diagrams/hi3520v100-power.svg)

        ![CRG register map](assets/diagrams/hi3520v100-crgmap.svg)

        ![IP edition per chip](assets/diagrams/hi3520v100-family.svg)

        ### Chip ID

        | Chip | System controller ID registers (0xEE0 .. 0xEEC) | Value read as SC_SYSID |
        |---|---|---|
        | hi3520v100 | SYSID0..3 reset values from the RDL | 0x35200100 |

        The four 8-bit registers form the 32-bit chip ID (SYSID3 is the most significant byte). The values are the reset values of the register descriptions: one data sheet documents one ID for all chips it covers, so the chips of a shared data sheet are not distinguished here (the real value of each variant is not stated).

        ### Key specifications (data sheet chapter 1 and 3.3; the data sheet is Chinese, translated; Issue 02, 2010-01-19)

        | | Hi3520 V100 |
        |---|---|
        | CPU | dual core: ARM1176JZF-S (ARM0, master, up to 600 MHz, 16 KB I + 16 KB D cache, 2 KB ITCM, VFP, MMU) and ARM926EJ-S (ARM1, audio/video service processor, 16 KB I + 16 KB D cache, 2 KB ITCM, MMU); two VICs, 32 interrupt sources each |
        | DDR | two DDR2 controllers up to 400 MHz: DDR0 16 bit (up to 256 MB) and DDR1 32 bit (up to 512 MB) |
        | Flash | 8-bit NOR (SMI, 2 chip selects, 32 MB each, NOR boot), 8-bit NAND (SLC/MLC, 1/4/8 bit ECC, up to 8 GB, NAND boot) |
        | Video codec | H.264 Main/Baseline L3 and JPEG/MJPEG baseline; up to 8 channels D1 real-time; 120 fps D1 enc + 120 fps CIF enc + 120 fps D1 dec at NTSC (100 fps at PAL); dual stream; 3 Mpixel JPEG at 10 fps; CBR/VBR/ABR 16 kbit/s to 20 Mbit/s |
        | Video input | 4 x BT.656 YCrCb 4:2:2 (8 bit, 27/54/108 MHz), 2 x SMPTE296M/BT.1120 HD, digital camera input up to 1280x1024@30, 1600x1200@20, 2048x1536@10 |
        | Video output | 2 digital outputs and 6 analog channels: VGA/YPbPr + 1 x CVBS, or 2 x VGA; BT.656/BT.1120/LCD digital output; up to 1920x1080p@30 / 1080i@60 |
        | Graphics | de-interlace, color/contrast enhancement and denoise, clip/alpha/ROP/colorkey/gamma, scaling up to 16x, OSD overlay, 4 cover regions, anti-flicker, 2D copy/fill |
        | Audio | 3 I2S interfaces (SIO), each with 16 cascaded 8/16-bit inputs, 8/16/32 bit samples, 8-48 kHz |
        | Network | one 10/100/1000 Mbit/s Ethernet MAC (RGMII/MII, MDIO, flow control, address filter), no integrated PHY |
        | Other | PCI 2.3 host or slave bridge (33/66 MHz, up to 5 devices), MMC/SD/SDIO, 2 USB 2.0 host (OHCI + EHCI), I2C, 4 UART (one with RTS/CTS), SPI/SSP, IR, up to 8 GPIO groups, 4 dual timers, watchdog, RTC, AES/DES/3DES with watermarking |
        | Package | 768-pin FPBGA, 27 x 27 mm, 0.8 mm pitch; 1.6 W typical (DVR use); 90 nm; core 1.0 V, 1.8 V, 3.3 V I/O; -20 to +85 C |

        ### Boot (data sheet 3.3.2.1, Table 3-17)

        The boot mode applies to the ARM1176 only and is selected by pull levels on the pins EBIADR23 and EBIADR24 at reset:

        | EBIADR23 | EBIADR24 | Boot mode |
        |---|---|---|
        | pull-down | pull-down | NOR flash (8-bit asynchronous NOR on the SMI interface) |
        | pull-down | pull-up | DDR |
        | pull-up | pull-down | NAND flash |
        | pull-up | pull-up | DDR |

        The ARM926 is the slave processor: it can start only after the ARM1176 has booted. The ARM1176 writes its start program to address 0xC8000000 and releases it by a system-controller register (the high 8 address bits of the boot address are programmable; data sheet 3.3.2.2). Diagram: boot flow.

        ### Memory map notes (data sheet 3.3.2, Figures 3-3 and 3-4; the figures are drawn, addresses read from the text layer)

        * Boot from NOR: SMI chip select 0 at 0x00000000 until the remap is cleared; afterwards 0x00000000 is the 2 KB ITCM (software must keep ITCM code and data within 2 KB and enable ITCM through CP15 first).
        * Fixed map: NAND flash address space 0x70000000-0x73FFFFFF, SMI chip select 0 at 0x80000000 and chip select 1 at 0x84000000 (32 MB each, also aliased in the boot window), PCI address space 0xB0000000, DDR0 0xC0000000-0xDFFFFFFF, DDR1 0xE0000000-0xFFFFFFFF.
        * Register windows: NANDC 0x10000000, SMI 0x10010000, MMC 0x10030000, SIO0-2 0x10040000-0x10060000, VIC0/VIC1 0x10070000/0x10080000, GMAC 0x10090000, USB OHCI/EHCI 0x100A0000/0x100B0000, CIPHER 0x100C0000, DMAC 0x100D0000, VDEU0/1 0x100E0000/0x100F0000, VIU 0x10100000; APB 0x20000000-0x201CFFFF (timers, WDG, system controller 0x20050000, RTC, IR, IPCM mailbox for ARM0/ARM1 0x20080000, UARTs, I2C, SPI, IO config 0x200F0000, DDRC0/1, VOU, TDE, GPIO0-7).

        ### DMA request lines (data sheet 3.5, Table 3-23; checked against the RDL DMAC description)

        One DMAC (PL080-style, block DMAC at 0x100D0000, interrupt 15 on the VIC): 8 channels, 16 request lines, second interrupt output for the slave ARM.

        | Line | Peripheral | Line | Peripheral |
        |---|---|---|---|
        | 0 | SIO0 RX | 8 | SDIO read |
        | 1 | SIO0 TX | 9 | SDIO write |
        | 2 | SIO1 RX | 10 | UART0 RX |
        | 3 | SIO1 TX | 11 | UART0 TX |
        | 4 | SIO2 RX | 12 | UART1 RX |
        | 5 | SIO2 TX | 13 | UART1 TX |
        | 6 | SPI RX | 14 | UART2 RX |
        | 7 | SPI TX | 15 | UART2 TX |

        ### Pin multiplexing summary (IO_CONFIG at 0x200F0000)

        Generated from the pin mux registers of this description (register offsets are relative to the block base; the function lists are the value-ordered choices of each register). Pads that repeat a pattern in consecutive registers are merged into one row.

        | Pads | Mux register (offset from 0x200F0000) | Function choices (value 0, 1, ...) |
        |---|---|---|
        | VI0HS | reg0 @0x000 | 0=VI0HS / 1=URXD2 / 2=GPIO1_3 |
        | VI0VS | reg1 @0x004 | 0=VI0VS / 1=UTXD2 / 2=GPIO1_4 |
        | VI0DAT0 ... VI0DAT7 (8) | reg2 ... reg9 @0x008 ... 0x024 | 0=VI0DAT0 / 1=VOUDAT8 (first pad; others the same pattern with the pad's own number) |
        | VI1DAT0 ... VI1DAT7 (8) | reg10 ... reg17 @0x028 ... 0x044 | 0=VI1DAT0 / 1=GPIO4_0 / 2=VOUDAT0 (first pad; others the same pattern with the pad's own number) |
        | VI2HS | reg18 @0x048 | 0=VI2HS / 1=URXD3 / 2=GPIO3_4 |
        | VI2VS | reg19 @0x04C | 0=VI2VS / 1=UTXD3 / 2=GPIO3_5 |
        | VI2DAT0 ... VI3DAT7 (16) | reg20 ... reg35 @0x050 ... 0x08C | 0=VI2DAT0 / 1=GPIO5_0 (first pad; others the same pattern with the pad's own number) |
        | VO0CK | reg36 @0x090 | 0=GPIO1_5 / 1=VO0CK / 2=VORDAT0 |
        | VO0DAT0 ... VO0DAT6 (7) | reg37 ... reg43 @0x094 ... 0x0AC | 0=GPIO2_0 / 1=VO0DAT0 / 2=VORDAT1 (first pad; others the same pattern with the pad's own number) |
        | VO0DAT7 | reg44 @0x0B0 | 0=GPIO2_7 / 1=VO0DAT7 / 2=VOGDAT0 |
        | VO1CK | reg45 @0x0B4 | 0=GPIO7_2 / 1=VO1CK / 2=SDIOCK |
        | VO1DAT0 | reg46 @0x0B8 | 0=VGA1HS / 1=VO1DAT0 |
        | VO1DAT1 | reg47 @0x0BC | 0=VGA1VS / 1=VO1DAT1 |
        | VO1DAT2 | reg48 @0x0C0 | 0=SDIOCMD / 1=VO1DAT2 / 2=VOGDAT1 |
        | VO1DAT3 ... VO1DAT6 (4) | reg49 ... reg52 @0x0C4 ... 0x0D0 | 0=SDIODAT0 / 1=VO1DAT3 / 2=VOGDAT2 (first pad; others the same pattern with the pad's own number) |
        | VO1DAT7 | reg53 @0x0D4 | 0=GPIO1_6 / 1=VO1DAT7 / 2=VOGDAT6 |
        | VO1DAT8 | reg54 @0x0D8 | 0=SPICK / 1=VO1DAT8 / 2=VOGDAT7 |
        | VO1DAT9 | reg55 @0x0DC | 0=SPIDI / 1=VO1DAT9 / 2=VOBDAT0 |
        | VO1DAT10 | reg56 @0x0E0 | 0=SPIDO / 1=VO1DAT10 / 2=VOBDAT1 |
        | VO1DAT11 ... VO1DAT12 (2) | reg57 ... reg58 @0x0E4 ... 0x0E8 | 0=SPICSN0 / 1=VO1DAT11 / 2=VOBDAT2 (first pad; others the same pattern with the pad's own number) |
        | VO1DAT13 | reg59 @0x0EC | 0=GPIO7_4 / 1=VO1DAT13 / 2=VOBDAT4 / 3=VGA0HS |
        | VO1DAT14 | reg60 @0x0F0 | 0=GPIO7_5 / 1=VO1DAT14 / 2=VOBDAT5 / 3=VGA0VS |
        | VO1DAT15 | reg61 @0x0F4 | 0=GPIO1_7 / 1=VO1DAT15 / 2=VOBDAT6 |
        | GPIO3_0 | reg62 @0x0F8 | 0=GPIO3_0 / 1=VOBDAT7 |
        | SDA | reg63 @0x0FC | 0=SDA / 1=GPIO0_0 |
        | SCL | reg64 @0x100 | 0=SCL / 1=GPIO0_1 |
        | SIO0XFS | reg65 @0x104 | 0=SIO0XFS / 1=GPIO0_2 |
        | SIO0XCK | reg66 @0x108 | 0=SIO0XCK / 1=GPIO0_3 |
        | ACKOUT | reg67 @0x10C | 0=GPIO0_4 / 1=ACKOUT |
        | SIO2DI | reg68 @0x110 | 0=GPIO0_5 / 1=SIO2DI / 2=SIO1DO |
        | SIO2RFS | reg69 @0x114 | 0=GPIO0_6 / 1=SIO2RFS / 2=SIO1XFS |
        | SIO2RCK | reg70 @0x118 | 0=GPIO0_7 / 1=SIO2RCK / 2=SIO1XCK |
        | SMICS1N | reg71 @0x11C | 0=GPIO3_2 / 1=SMICS1N |
        | NFCS1N | reg72 @0x120 | 0=GPIO3_3 / 1=NFCS1N |
        | NFRB | reg73 @0x124 | 0=NFRB / 1=GPIO3_1 |
        | EBIRDYN | reg74 @0x128 | 0=EBIRDYN / 1=IRRCV |
        | GTCLKOUT | reg75 @0x12C | 0=GPIO1_0 / 1=GTCLKOUT |
        | GCOL | reg76 @0x130 | 0=GCOL / 1=GPIO1_1 |
        | GCRS | reg77 @0x134 | 0=GCRS / 1=GPIO1_2 |
        | PCIREQ3N ... PCIREQ4N (2) | reg78 ... reg79 @0x138 ... 0x13C | 0=GPIO3_6 / 1=PCIREQ3N (first pad; others the same pattern with the pad's own number) |
        | PCIGRANT3N ... PCIGRANT4N (2) | reg80 ... reg81 @0x140 ... 0x144 | 0=GPIO7_0 / 1=PCIGRANT3N (first pad; others the same pattern with the pad's own number) |
        | VORGBDV | reg82 @0x148 | 0=GPIO7_3 / 1=VORGBDV |

        Pad drive-strength and pull controls are in the separate pad control registers of the same description (not repeated here).

        ### Power, reset and system modes (data sheet 3.1, 3.2, 3.3)

        * Resets: npor from the RSTN pin (low pulse above 12 XIN24 cycles, crystal stable); PCIRSTN from the PCI pin resets only the PCI block while the chip is a PCI slave; global soft reset from the system controller (at least 360 system clock cycles); per-module soft resets from the system controller. USB 2.0 host PHY and controller, MMC, ETH, VI, VO and RTC are held in reset after power-on and need their reset released before use. Diagram: reset tree.
        * System modes (SC_CTRL sysmode): NORMAL (ARMPLL on, ARM subsystem on the PLL), SLOW (PLL off, 24 MHz crystal), DOZE (PLL off, 45 kHz divided clock), SLEEP (everything stopped except the system controller and IR at 45 kHz). ARM clock mode after power-on is the crystal (sysmode 0xB).
        * PLL changes only in SLOW mode, PLL stable 0.1 ms after the change and never switch to PLL mode before it is stable.
        * The data sheet has no separate power-domain table.

        ### Clock-gate map (generated from the system controller registers)

        Each peripheral clock has an enable bit in PEREN (SC_PEREN, offset 0x24) and the matching disable bit in PERDIS (SC_PERDIS, offset 0x28); writing 1 to a bit in PEREN enables the clock, writing 1 to the same bit in PERDIS disables it; the state is read back in PERCLKEN (SC_PERCLKEN).

        | Bit | Clock enable field | Gated module |
        |---|---|---|
        | 2 | cipherclken | CIPHER |
        | 3 | smiclken | SMI |
        | 4 | uart0clken | UART0 |
        | 5 | uart1clken | UART1 |
        | 6 | uart2clken | UART2 |
        | 7 | uart3clken | UART3 |
        | 8 | sio0clken | SIO0 |
        | 9 | sio1clken | SIO1 |
        | 10 | sio2clken | SIO2 |
        | 11 | irclken | IR |
        | 12 | ipcmclken | IPCM |
        | 13 | pciclken | PCI |
        | 14 | mmcclken | MMC |
        | 15 | tdeclken | TDE |
        | 16 | vibusclken | VIBUS |
        | 17 | vi0clken | VI0 |
        | 18 | vi1clken | VI1 |
        | 19 | vi2clken | VI2 |
        | 20 | vi3clken | VI3 |
        | 21 | ethclken | ETH |
        | 22 | usbclken | USB |
        | 23 | vobusclken | VOBUS |
        | 24 | vosdclken | VOSD |
        | 25 | vohdclken | VOHD |
        | 26 | voadclken | VOAD |
        | 27 | nandcclken | NANDC |
        | 28 | arm9clken | ARM9 |
        | 29 | sspclken | SSP |
        | 30 | vdac0clken | VDAC0 |
        | 31 | vdac1clken | VDAC1 |

        Per-module soft resets and the ARM/IP clock frequency selects are in SC_PERCTRLn / PERIPHCTRLn (see the register pages and the clock tree diagram).

        ### Interrupts (VIC0 source numbers, data sheet Table 3-20; the data sheet is Chinese, names translated)

        The chip has two VICs. VIC1 (Table 3-21) has the same assignment except 4 = Dual-Timer4/5 and 5 = Dual-Timer6/7. COMMRX and COMMTX are for CPU debug use.

        | # | Source | # | Source | # | Source |
        |---|---|---|---|---|---|
        | 0 | Watchdog | 11 | SPI | 22 | USB 2.0 host OHCI |
        | 1 | Global software interrupt | 12 | UART0 or UART1 | 23 | USB 2.0 host EHCI |
        | 2 | COMMRX | 13 | UART2 or UART3 | 24 | SDIO |
        | 3 | COMMTX | 14 | GMAC | 25 | SIO0 |
        | 4 | Dual-Timer0/1 | 15 | DMAC | 26 | SIO1 |
        | 5 | Dual-Timer2/3 | 16 | I2C | 27 | SIO2 |
        | 6 | GPIO0 | 17 | VIU | 28 | CIPHER |
        | 7 | GPIO1 | 18 | TDE | 29 | PCI |
        | 8 | GPIO2-GPIO7 (combined) | 19 | VOU | 30 | NANDC |
        | 9 | IR | 20 | VEDU0 | 31 | IPCM |
        | 10 | RTC | 21 | VEDU1 |  |  |

        ### Register blocks (generated from this description)

        | Base | Instance | Block | Register space |
        |---|---|---|---|
        | 0x10000000 | NANDC | HiSilicon parallel NAND flash controller (hinfc300/301/504 family) | 96 B |
        | 0x10010000 | SMI | Static memory interface controller (SMI, PL172-style) | 520 B |
        | 0x10030000 | MMC | HiSilicon MMC/SD/SDIO controller (DesignWare-MMC based, himciv200) | 260 B |
        | 0x10040000 | SIO0 | HiSilicon SIO (I2S/PCM audio interface) | 196 B |
        | 0x10050000 | SIO1 | HiSilicon SIO (I2S/PCM audio interface) | 196 B |
        | 0x10060000 | SIO2 | HiSilicon SIO (I2S/PCM audio interface) | 196 B |
        | 0x10070000 | VIC0 | Vectored interrupt controller (ARM PrimeCell PL190) | 4 KB |
        | 0x10080000 | VIC1 | Vectored interrupt controller (ARM PrimeCell PL190) | 4 KB |
        | 0x100A0000 | OHCI | HiSilicon USB 2.0 host controller - OHCI | 92 B |
        | 0x100B0000 | EHCI | HiSilicon USB 2.0 host controller - EHCI | 176 B |
        | 0x100C0000 | CIPHER | CIPHER Registers | 132 B |
        | 0x100D0000 | DMAC | HiSilicon DMA controller (PL080-compatible, 4 or 8 channels) | 512 B |
        | 0x20000000 | TIMER0 | Timer Registers | 28 B |
        | 0x20000020 | TIMER1 | Timer Registers | 28 B |
        | 0x20010000 | TIMER2 | Timer Registers | 28 B |
        | 0x20010020 | TIMER3 | Timer Registers | 28 B |
        | 0x20020000 | TIMER4 | Timer Registers | 28 B |
        | 0x20020020 | TIMER5 | Timer Registers | 28 B |
        | 0x20030000 | TIMER6 | Timer Registers | 28 B |
        | 0x20030020 | TIMER7 | Timer Registers | 28 B |
        | 0x20040000 | WDG | Watchdog Registers | 3076 B |
        | 0x20050000 | SYS_CTRL | System Controller Registers | 3824 B |
        | 0x20060000 | RTC | RTC (ARM PL031-style 32-bit counter) | 32 B |
        | 0x20070000 | IR | HiSilicon IR receiver (V1, mode 0 only) | 56 B |
        | 0x20090000 | UART0 | UART (ARM PrimeCell PL011) | 4 KB |
        | 0x200A0000 | UART1 | UART (ARM PrimeCell PL011) | 4 KB |
        | 0x200B0000 | UART2 | UART (ARM PrimeCell PL011) | 4 KB |
        | 0x200C0000 | UART3 | UART (ARM PrimeCell PL011) | 4 KB |
        | 0x200D0000 | I2C | Synopsys DW_apb_i2c I2C Master/Slave Controller (16-bit, Hi3511/Hi3512/Hi3515/Hi3520 V100) | 148 B |
        | 0x200E0000 | SPI | SPI Registers | 40 B |
        | 0x200F0000 | IO_CONFIG | IO configuration (pin multiplexing control), Hi3520 V100 | 332 B |
        | 0x20110000 | DDRC0 | DDRC Registers | 620 B |
        | 0x20120000 | DDRC1 | DDRC Registers | 620 B |
        | 0x20140000 | TDE | HiSilicon TDE (registers not described) | 64 KB |
        | 0x20150000 | GPIO0 | ARM PL061 | 1053 B |
        | 0x20160000 | GPIO1 | ARM PL061 | 1053 B |
        | 0x20170000 | GPIO2 | ARM PL061 | 1053 B |
        | 0x20180000 | GPIO3 | ARM PL061 | 1053 B |
        | 0x20190000 | GPIO4 | ARM PL061 | 1053 B |
        | 0x201A0000 | GPIO5 | ARM PL061 | 1053 B |
        | 0x201B0000 | GPIO6 | ARM PL061 | 1053 B |
        | 0x201C0000 | GPIO7 | ARM PL061 | 1053 B |

        The table is generated from the elaborated root (instances at their absolute addresses; register space is the span of the block's registers, not the data sheet window).

        <!-- overview:end -->
    ";

    eHISI_NANDC         NANDC           @ 0x10000000;
    eHISI_SMI           SMI             @ 0x10010000;
    eHISI_DWMMC         MMC             @ 0x10030000;
    eHISI_SIO           SIO0            @ 0x10040000;
    eHISI_SIO           SIO1            @ 0x10050000;
    eHISI_SIO           SIO2            @ 0x10060000;
    eARM_PL190          VIC0            @ 0x10070000;
    eARM_PL190          VIC1            @ 0x10080000;
    eHISI_USB_OHCI      OHCI            @ 0x100A0000;
    eHISI_USB_EHCI      EHCI            @ 0x100B0000;
    eHISI_CIPHER        CIPHER          @ 0x100C0000;
    eHISI_DMAC          DMAC            @ 0x100D0000;
    eHISI_TIMER_SP804   TIMER4          @ 0x20020000;
    eHISI_TIMER_SP804   TIMER5          @ 0x20020020;
    eHISI_TIMER_SP804   TIMER6          @ 0x20030000;
    eHISI_TIMER_SP804   TIMER7          @ 0x20030020;
    eHISI_WDG_SP805     WDG             @ 0x20040000;
    eHISI_TIMER_SP804   TIMER0          @ 0x20000000;
    eHISI_TIMER_SP804   TIMER1          @ 0x20000020;
    eHISI_TIMER_SP804   TIMER2          @ 0x20010000;
    eHISI_TIMER_SP804   TIMER3          @ 0x20010020;
    eSYS_CTRL           SYS_CTRL        @ 0x20050000;
    eHISI_RTC           RTC             @ 0x20060000;
    eHISI_IR_V1         IR              @ 0x20070000;
    eARM_PL011          UART0           @ 0x20090000;
    eARM_PL011          UART1           @ 0x200A0000;
    eARM_PL011          UART2           @ 0x200B0000;
    eARM_PL011          UART3           @ 0x200C0000;
    eDW_APB_I2C         I2C             @ 0x200D0000;
    eHISI_SPI           SPI             @ 0x200E0000;
    eIO_CONFIG          IO_CONFIG       @ 0x200F0000;
    eDDRC               DDRC0           @ 0x20110000;
    eDDRC               DDRC1           @ 0x20120000;
    aHISI_TDE           TDE             @ 0x20140000;
    eARM_PL061          GPIO0           @ 0x20150000;
    eARM_PL061          GPIO1           @ 0x20160000;
    eARM_PL061          GPIO2           @ 0x20170000;
    eARM_PL061          GPIO3           @ 0x20180000;
    eARM_PL061          GPIO4           @ 0x20190000;
    eARM_PL061          GPIO5           @ 0x201A0000;
    eARM_PL061          GPIO6           @ 0x201B0000;
    eARM_PL061          GPIO7           @ 0x201C0000;
    // MOTION_DETECT removed: the Hi3520 V100 data sheet has no motion detection register block; 0x206C_0000 lies in
    // "Reserved 0x201D_0000-0x6FFF_FFFF" (DS-3520-ZH:11495, Table 1-1), only a feature bullet mentions motion detection
    // (DS-3520-ZH:57510). The block was copied from Hi3520D. See docs/rdl-sweep/hi3520/eMOTION_DETECT.yaml.
    // eMOTION_DETECT      MOTION_DETECT   @ 0x206C0000;
};
