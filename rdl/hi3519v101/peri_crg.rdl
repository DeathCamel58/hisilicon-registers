`ifndef CRG_RDL
`define CRG_RDL

regfile ePERI_CRG {
    name = "Clock and reset generator (CRG), Hi3519 V101";
    desc = "    PERI_CRGn clock/reset registers at 0x12010000 (CRG; `PERI_CRG` is the HiSilicon register prefix, offset = n x 4). Data sheet: Hi3519 V101 Professional HD IP Camera SoC, Issue 01 (2018-07-05), chapter 3.2 (Clock) and 3.1 (Reset), registers in 3.2.6/3.2.7; the Hi3516A V200 data sheet has the same CRG chapter, register for register (checked 2026-11-10: the same 43 registers, offsets, reset values and field tables; the only difference is PERI_CRG19 vedu_clksel, which lists 500 and 594 MHz codes only here). 43 registers, offsets 0x0-0x24 (PLLs), 0x28-0xF0 and 0x13C.

    Clock tree facts for bring-up. Input clocks: XIN = 24 MHz crystal, RTC_XIN = 32.768 kHz. Four PLLs, each with two configuration registers (DS Table 3-3): APLL = PERI_CRG_PLL0/1 (offsets 0x0/0x4), DPLL = PERI_CRG_PLL4/5 (0x10/0x14), VPLL = PERI_CRG_PLL6/7 (0x18/0x1C), EPLL = PERI_CRG_PLL8/9 (0x20/0x24). Formula (DS Table 3-4): FOUTVCO = 24 MHz x (fbdiv + frac/2^24) / refdiv, which must stay above 800 MHz and at most 2.3 GHz; FOUTPOSTDIV = FOUTVCO / (postdiv1 x postdiv2) with postdiv1 >= postdiv2; FOUTVCO2X = 2 x FOUTVCO; FOUT1PH0/2/3/4 = FOUTVCO / (postdiv1 x postdiv2 x 2/4/6/8). Reset configurations: APLL 1200 MHz (refdiv 1, fbdiv 50, postdiv 2 x 1 = 600 MHz), DPLL 932 MHz (refdiv 6, fbdiv 233, POSTDIV 466 MHz), VPLL 1188 MHz (POSTDIV 594 MHz), EPLL 1500 MHz (POSTDIV 500 MHz); only the APLL and DPLL are meant to be reprogrammed (the VPLL and EPLL are fixed). PLL change procedure (DS 3.2.5.3): first switch every consumer of the PLL to a non-PLL (or another PLL) clock, change the PLL configuration, wait 0.1 ms and poll the lock bits PERI_CRG58[4:0] (apll [0], dpll [2], vpll [3], epll [4]; gzip_rst_ok is bit 8), then switch back once the PLL is locked.

    Clock muxes (DS 3.2.5, Tables 3-5/3-6; everything that has a mux resets to its first entry, normally the 24 MHz crystal): a7_clksel PERI_CRG13[9:7], a17_clksel PERI_CRG13[6:4], ddr_clksel PERI_CRG13[2:0], sysaxi_clksel PERI_CRG13[13:12] (completion indicators in PERI_CRG79); VDP: vdp_core_clksel PERI_CRG17[17], vdp_out_clksel [16:14], hd_div_mode [13:12], lcd_mclk_div PERI_CRG18[26:0]; sensor0/1_clksel PERI_CRG16[3:0]/[11:8]; vi0_clksel PERI_CRG19[2:0], vi1_clksel PERI_CRG21[2:0], isp0_clksel PERI_CRG21[18:14], isp1_clksel PERI_CRG21[10:6]; vedu/vpss/vgs/ive/gdc_clksel PERI_CRG19[12:10]/[7:5]/[15:13]/[21:19]/[18:16]; FMC fmc_clksel PERI_CRG48[4:2] (0: 24 MHz, 1: 75, 2: 125, 3: 150, 4: 198(200), 5: 250, 6: 300, 7: 396(400) MHz, confirmed by the vendor U-Boot platform.h and the vendor Linux clk-hi3519.c fmc_mux at 0xC0 [4:2], gate at bit 1); MMC mmc0/1/2_clksel PERI_CRG49[12:10]/[4:2]/[20:18] and mmc*_clk_mode [13]/[5]/[21] (must be 1); cipher ca_clksel PERI_CRG31[6]; PWM pwm_clksel PERI_CRG55[3:2] (3 MHz / 50 MHz / 24 MHz); UART uart_clksel PERI_CRG57[25] (1: 24 MHz; the vendor U-Boot sets it in board_init) and I2C i2c_clksel PERI_CRG57[26] (1: 50 MHz); GMAC mac_speed/port_select PERI_CRG59[1:0], ext_fephy_clksel PERI_CRG51[6], rmii_clksel PERI_CRG51[4]; AIAO aiao_clksel PERI_CRG32[3:2] (1188 MHz VPLL VCO or 1500 MHz EPLL VCO); USB: combphy_refclk_sel PERI_CRG43[9], usb3_utmi_clksel PERI_CRG46[13] (USB 2.0 controller and PHY in PERI_CRG45).

    Reset polarity: every *_srst_req bit is 1 = reset asserted, 0 = reset released (`0: reset deasserted, 1: reset`); *_clken bits are 1 = clock on. Several modules come up held in reset (srst_req resets to 1 for the A17 cluster, VEDU, VPSS, VDP, VI0, MIPI0, ISP0, USB, COMB PHY), so software must release them and enable the clock.

    Cross-checks: the vendor U-Boot 2010.06 (`arch-hi3519v101/platform.h` PERI_CRG43 = 0xAC, PERI_CRG57 = 0xE4, REG_CRG48 = 0xC0 for the FMC, REG_ETH_CRG = 0xCC = PERI_CRG51; `board/hi3519v101/board.c`) and the vendor-derived Linux clock driver (`drivers/clk/hisilicon/clk-hi3519.c`: fmc mux at 0xC0 bits [4:2] with the straight table 0..7, fmc gate 0xC0 bit 1, UART0-4 gates 0xE4 bits 20..24, SPI0-2 gates bits 16..18) use the same offsets and bits as this data sheet. The vendor code does not touch the a7/a17/ddr/sysaxi muxes (the boot ROM and the DDR training code set them), so the PERI_CRG13 value tables rest on the data sheet bit rows alone.

    Known data sheet errors and decisions (dump `hi3519v101--Hi3519V101-Datasheet.txt`, checked 2026-11-10): (1) PERI_CRG22 (VPSS) prints `Offset Address 0x0048` in its description block; the summary table and the register sequence put it at 0x58 (PERI_CRG18, the LCD register, owns 0x48): 0x58 is used. (2) PERI_CRG17 header reset 0x4 vs rows 0x5 (vdp_srst_req resets to 1) and PERI_CRG49 header 0x00020200 vs rows 0x00020202 (mmc1_clken resets to 1): the row values are used, low confidence. (3) For PERI_CRG10, 11, 15, 45, 54 the header total reset value has bits set that the rows call reserved: they are modelled as RO reserved_nz_<hi>_<lo> fields so that the register reset equals the header value. (4) DS Table 3-2 lists the A7/A17 frequency choices in the opposite order of the PERI_CRG13 rows (see the PERI_CRG13 register); the rows are followed. (5) PERI_CRG58 is RO (lock status) and PERI_CRG79 is RO (clock switch completion). (6) The previous RDL carried a placeholder `PERI_CRG68 @ 0x0110` (marked UNDOCUMENTED): it is not in the data sheet, not used by the vendor U-Boot nor by the OpenIPC clock driver, and has been dropped. (7) Field tables of PERI_CRG57 (test_clk_en, i2c_clksel and the lower reset bits) and several descriptions are mangled by the PDF layout; the meaning is taken from the bit table.

    Sources: HiSilicon's own English data sheet `Hi3519V101-Datasheet.pdf` (not machine translated; no watermark); no Chinese original available for this chip. Registers, fields and reset values were extracted from the text dump `hi3519v101--Hi3519V101-Datasheet.txt` (CRG register summary and description from 3.2.6/3.2.7) and compared programmatically with this file.
    ";

    reg {
        name = "APLL configuration register 0";
        desc = "PERI_CRG_PLL0 is APLL configuration register 0.

APLL configuration register 0 (APLL = PERI_CRG_PLL0/PERI_CRG_PLL1). FOUTVCO = 24 MHz x (fbdiv + frac/2^24) / refdiv, must be above 800 MHz and at most 2.3 GHz (DS Table 3-4); FOUTPOSTDIV = FOUTVCO / (postdiv1 x postdiv2) with postdiv1 >= postdiv2. Reset: postdiv2 = 1, postdiv1 = 2; with PERI_CRG_PLL1 (refdiv 1, fbdiv 50) FOUTVCO = 1200 MHz and POSTDIV = 600 MHz, which is also the worked example of DS 3.2.4. Change procedure: DS 3.2.5.3 (switch the consumers away first, reprogram, wait 0.1 ms, poll PERI_CRG58[4:0]).

Data sheet 3.2.7 PERI_CRG_PLL0 (offset 0x0, printed page 3-13, `hi3519v101--Hi3519V101-Datasheet.txt` line 4533).";

        field {
            name = "apll_postdiv2";
            desc = "Level-2 output frequency divider of the APLL";
            sw = rw;
            hw = r;
            reset = 0x1;
        } apll_postdiv2[30:28];

        field {
            name = "apll_postdiv1";
            desc = "Level-1 output frequency divider of the APLL";
            sw = rw;
            hw = r;
            reset = 0x2;
        } apll_postdiv1[26:24];

        field {
            name = "apll_frac";
            desc = "Decimal part of the APLL frequency multiplication coefficient";
            sw = rw;
            hw = r;
            reset = 0x0;
        } apll_frac[23:0];
    } PERI_CRG_PLL0 @ 0x0;

    reg {
        name = "APLL configuration register 1";
        desc = "PERI_CRG_PLL1 is APLL configuration register 1.

APLL configuration register 1. Reset 0x09101032: foutvco2xpd 1, dsmpd 1 (integer mode, apll_frac ignored), fout4phasepd 1, refdiv 1, fbdiv 50. FOUTVCO2X = 2 x FOUTVCO; the phase outputs FOUT1PH0/2/3/4 = FOUTVCO / (postdiv1 x postdiv2 x 2/4/6/8).

Data sheet 3.2.7 PERI_CRG_PLL1 (offset 0x4, printed page 3-14, `hi3519v101--Hi3519V101-Datasheet.txt` line 4572).";

        enum PERI_CRG_PLL1_apll_foutvco2xpd_enum {
            NORMAL_OUTPUT = 0 { name = "Normal Output"; desc = "normal output clock"; };
            NO_OUTPUT = 1 { name = "No Output"; desc = "no output clock"; };
        };

        field {
            name = "apll_foutvco2xpd";
            desc = "APLL VCO2X output power-down control";
            sw = rw;
            hw = r;
            encode = PERI_CRG_PLL1_apll_foutvco2xpd_enum;
            reset = 0x1;
        } apll_foutvco2xpd[27:27];

        enum PERI_CRG_PLL1_apll_bypass_enum {
            NOT_BYPASSED = 0 { name = "Not Bypassed"; desc = "not bypassed"; };
            BYPASSED = 1 { name = "Bypassed"; desc = "bypassed"; };
        };

        field {
            name = "apll_bypass";
            desc = "APLL clock frequency division bypass";
            sw = rw;
            hw = r;
            encode = PERI_CRG_PLL1_apll_bypass_enum;
            reset = 0x0;
        } apll_bypass[26:26];

        enum PERI_CRG_PLL1_apll_dacpd_enum {
            NORMAL_OPERATING_MODE = 0 { name = "Normal Operating Mode"; desc = "normal operating mode"; };
            POWER_DOWN_MODE = 1 { name = "Power Down Mode"; desc = "power-down mode"; };
        };

        field {
            name = "apll_dacpd";
            desc = "APLL test signal control";
            sw = rw;
            hw = r;
            encode = PERI_CRG_PLL1_apll_dacpd_enum;
            reset = 0x0;
        } apll_dacpd[25:25];

        enum PERI_CRG_PLL1_apll_dsmpd_enum {
            DECIMAL_FREQUENCY_DIVISION = 0 { name = "Decimal Frequency Division"; desc = "decimal frequency-division mode"; };
            INTEGRAL_FREQUENCY_DIVISION = 1 { name = "Integral Frequency Division"; desc = "integral frequency-division mode"; };
        };

        field {
            name = "apll_dsmpd";
            desc = "APLL decimal division control";
            sw = rw;
            hw = r;
            encode = PERI_CRG_PLL1_apll_dsmpd_enum;
            reset = 0x1;
        } apll_dsmpd[24:24];

        enum PERI_CRG_PLL1_apll_pd_enum {
            NORMAL_OPERATING_MODE = 0 { name = "Normal Operating Mode"; desc = "normal operating mode"; };
            POWER_DOWN_MODE = 1 { name = "Power Down Mode"; desc = "power-down mode"; };
        };

        field {
            name = "apll_pd";
            desc = "APLL power-down control";
            sw = rw;
            hw = r;
            encode = PERI_CRG_PLL1_apll_pd_enum;
            reset = 0x0;
        } apll_pd[23:23];

        enum PERI_CRG_PLL1_apll_foutvcopd_enum {
            NORMAL_OUTPUT = 0 { name = "Normal Output"; desc = "normal output clock"; };
            NO_OUTPUT = 1 { name = "No Output"; desc = "no output clock"; };
        };

        field {
            name = "apll_foutvcopd";
            desc = "APLL VCO output power-down control";
            sw = rw;
            hw = r;
            encode = PERI_CRG_PLL1_apll_foutvcopd_enum;
            reset = 0x0;
        } apll_foutvcopd[22:22];

        enum PERI_CRG_PLL1_apll_postdivpd_enum {
            NORMAL_CLOCK_OUTPUT = 0 { name = "Normal Clock Output"; desc = "normal clock output"; };
            NO_OUTPUT = 1 { name = "No Output"; desc = "no output clock"; };
        };

        field {
            name = "apll_postdivpd";
            desc = "APLL POSTDIV output power-down control";
            sw = rw;
            hw = r;
            encode = PERI_CRG_PLL1_apll_postdivpd_enum;
            reset = 0x0;
        } apll_postdivpd[21:21];

        enum PERI_CRG_PLL1_apll_fout4phasepd_enum {
            NORMAL_OUTPUT = 0 { name = "Normal Output"; desc = "normal output clock"; };
            NO_OUTPUT = 1 { name = "No Output"; desc = "no output clock"; };
        };

        field {
            name = "apll_fout4phasepd";
            desc = "APLL FOUT output power-down control";
            sw = rw;
            hw = r;
            encode = PERI_CRG_PLL1_apll_fout4phasepd_enum;
            reset = 0x1;
        } apll_fout4phasepd[20:20];

        field {
            name = "apll_refdiv";
            desc = "Frequency divider of the APLL reference clock";
            sw = rw;
            hw = r;
            reset = 0x1;
        } apll_refdiv[17:12];

        field {
            name = "apll_fbdiv";
            desc = "Integral part of the APLL frequency multiplication coefficient";
            sw = rw;
            hw = r;
            reset = 0x32;
        } apll_fbdiv[11:0];
    } PERI_CRG_PLL1 @ 0x4;

    reg {
        name = "DPLL configuration register 0";
        desc = "PERI_CRG_PLL4 is DPLL configuration register 0.

DPLL configuration register 0 (DPLL = PERI_CRG_PLL4/PERI_CRG_PLL5), same layout as PERI_CRG_PLL0. Reset: postdiv2 = 1, postdiv1 = 2; with PERI_CRG_PLL5 (refdiv 6, fbdiv 233) FOUTVCO = 24 x 233 / 6 = 932 MHz and POSTDIV = 466 MHz (the `DPLL POSTDIV (maximum 466 MHz)` choice of ddr_clksel).

Data sheet 3.2.7 PERI_CRG_PLL4 (offset 0x10, printed page 3-15, `hi3519v101--Hi3519V101-Datasheet.txt` line 4636).";

        field {
            name = "dpll_postdiv2";
            desc = "Level-2 output divider of DPLL";
            sw = rw;
            hw = r;
            reset = 0x1;
        } dpll_postdiv2[30:28];

        field {
            name = "dpll_postdiv1";
            desc = "Level-1 output divider of DPLL";
            sw = rw;
            hw = r;
            reset = 0x2;
        } dpll_postdiv1[26:24];

        field {
            name = "dpll_frac";
            desc = "Decimal part of the DPLL frequency multiplication coefficient";
            sw = rw;
            hw = r;
            reset = 0x0;
        } dpll_frac[23:0];
    } PERI_CRG_PLL4 @ 0x10;

    reg {
        name = "DPLL configuration register 1";
        desc = "PERI_CRG_PLL5 is DPLL configuration register 1.

DPLL configuration register 1. Reset 0x091060E9: foutvco2xpd 1, dsmpd 1, fout4phasepd 1, refdiv 6, fbdiv 233 (FOUTVCO 932 MHz).

Data sheet 3.2.7 PERI_CRG_PLL5 (offset 0x14, printed page 3-16, `hi3519v101--Hi3519V101-Datasheet.txt` line 4675).";

        enum PERI_CRG_PLL5_dpll_foutvco2xpd_enum {
            NORMAL_OUTPUT = 0 { name = "Normal Output"; desc = "normal output clock"; };
            NO_OUTPUT = 1 { name = "No Output"; desc = "no output clock"; };
        };

        field {
            name = "dpll_foutvco2xpd";
            desc = "DPLL VCO2X output power-down control";
            sw = rw;
            hw = r;
            encode = PERI_CRG_PLL5_dpll_foutvco2xpd_enum;
            reset = 0x1;
        } dpll_foutvco2xpd[27:27];

        enum PERI_CRG_PLL5_dpll_bypass_enum {
            NOT_BYPASSED = 0 { name = "Not Bypassed"; desc = "not bypassed"; };
            BYPASSED = 1 { name = "Bypassed"; desc = "bypassed"; };
        };

        field {
            name = "dpll_bypass";
            desc = "DPLL clock frequency division bypass";
            sw = rw;
            hw = r;
            encode = PERI_CRG_PLL5_dpll_bypass_enum;
            reset = 0x0;
        } dpll_bypass[26:26];

        enum PERI_CRG_PLL5_dpll_dacpd_enum {
            NORMAL_OPERATING_MODE = 0 { name = "Normal Operating Mode"; desc = "normal operating mode"; };
            POWER_DOWN_MODE = 1 { name = "Power Down Mode"; desc = "power-down mode"; };
        };

        field {
            name = "dpll_dacpd";
            desc = "DPLL test signal control";
            sw = rw;
            hw = r;
            encode = PERI_CRG_PLL5_dpll_dacpd_enum;
            reset = 0x0;
        } dpll_dacpd[25:25];

        enum PERI_CRG_PLL5_dpll_dsmpd_enum {
            DECIMAL_FREQUENCY_DIVISION = 0 { name = "Decimal Frequency Division"; desc = "decimal frequency-division mode"; };
            INTEGRAL_FREQUENCY_DIVISION = 1 { name = "Integral Frequency Division"; desc = "integral frequency-division mode"; };
        };

        field {
            name = "dpll_dsmpd";
            desc = "DPLL decimal division control";
            sw = rw;
            hw = r;
            encode = PERI_CRG_PLL5_dpll_dsmpd_enum;
            reset = 0x1;
        } dpll_dsmpd[24:24];

        enum PERI_CRG_PLL5_dpll_pd_enum {
            NORMAL_OPERATING_MODE = 0 { name = "Normal Operating Mode"; desc = "normal operating mode"; };
            POWER_DOWN_MODE = 1 { name = "Power Down Mode"; desc = "power-down mode"; };
        };

        field {
            name = "dpll_pd";
            desc = "DPLL power-down control";
            sw = rw;
            hw = r;
            encode = PERI_CRG_PLL5_dpll_pd_enum;
            reset = 0x0;
        } dpll_pd[23:23];

        enum PERI_CRG_PLL5_dpll_foutvcopd_enum {
            NORMAL_OUTPUT = 0 { name = "Normal Output"; desc = "normal output clock"; };
            NO_OUTPUT = 1 { name = "No Output"; desc = "no output clock"; };
        };

        field {
            name = "dpll_foutvcopd";
            desc = "DPLL VCO output power-down control";
            sw = rw;
            hw = r;
            encode = PERI_CRG_PLL5_dpll_foutvcopd_enum;
            reset = 0x0;
        } dpll_foutvcopd[22:22];

        enum PERI_CRG_PLL5_dpll_postdivpd_enum {
            NORMAL_CLOCK_OUTPUT = 0 { name = "Normal Clock Output"; desc = "normal clock output"; };
            NO_OUTPUT = 1 { name = "No Output"; desc = "no output clock"; };
        };

        field {
            name = "dpll_postdivpd";
            desc = "DPLL POSTDIV output power-down control";
            sw = rw;
            hw = r;
            encode = PERI_CRG_PLL5_dpll_postdivpd_enum;
            reset = 0x0;
        } dpll_postdivpd[21:21];

        enum PERI_CRG_PLL5_dpll_fout4phasepd_enum {
            NORMAL_OUTPUT = 0 { name = "Normal Output"; desc = "normal output clock"; };
            NO_OUTPUT = 1 { name = "No Output"; desc = "no output clock"; };
        };

        field {
            name = "dpll_fout4phasepd";
            desc = "DPLL FOUT output power-down control";
            sw = rw;
            hw = r;
            encode = PERI_CRG_PLL5_dpll_fout4phasepd_enum;
            reset = 0x1;
        } dpll_fout4phasepd[20:20];

        field {
            name = "dpll_refdiv";
            desc = "Frequency divider of the DPLL reference clock";
            sw = rw;
            hw = r;
            reset = 0x6;
        } dpll_refdiv[17:12];

        field {
            name = "dpll_fbdiv";
            desc = "Integral part of the DPLL frequency multiplication coefficient";
            sw = rw;
            hw = r;
            reset = 0xE9;
        } dpll_fbdiv[11:0];
    } PERI_CRG_PLL5 @ 0x14;

    reg {
        name = "VPLL configuration register 0";
        desc = "PERI_CRG_PLL6 is VPLL configuration register 0

VPLL configuration register 0 (VPLL = PERI_CRG_PLL6/PERI_CRG_PLL7). Reset: postdiv2 = 1, postdiv1 = 2; with PERI_CRG_PLL7 (refdiv 2, fbdiv 99) FOUTVCO = 1188 MHz and POSTDIV = 594 MHz; the fixed module clocks of DS Table 3-2 (198/297/396/594 MHz) derive from it. The data sheet states that only the APLL and DPLL are meant to be programmed; the other PLLs keep their fixed configuration.

Data sheet 3.2.7 PERI_CRG_PLL6 (offset 0x18, printed page 3-17, `hi3519v101--Hi3519V101-Datasheet.txt` line 4739).";

        field {
            name = "vpll_postdiv2";
            desc = "Level-2 output divider of VPLL";
            sw = rw;
            hw = r;
            reset = 0x1;
        } vpll_postdiv2[30:28];

        field {
            name = "vpll_postdiv1";
            desc = "Level-1 output divider of VPLL";
            sw = rw;
            hw = r;
            reset = 0x2;
        } vpll_postdiv1[26:24];

        field {
            name = "vpll_frac";
            desc = "Decimal part of the VPLL frequency multiplication coefficient";
            sw = rw;
            hw = r;
            reset = 0x0;
        } vpll_frac[23:0];
    } PERI_CRG_PLL6 @ 0x18;

    reg {
        name = "VPLL configuration register 1";
        desc = "PERI_CRG_PLL7 is VPLL configuration register 1.

VPLL configuration register 1. Reset 0x01002063: dsmpd 1 (integer mode), refdiv 2, fbdiv 99, all power-down bits 0 (FOUTVCO 1188 MHz). Bits [27:20] are modelled here like PLL1/PLL5/PLL9 (the previous RDL carried them only as a comment); the header value 0x0100_2063 agrees with the rows.

Data sheet 3.2.7 PERI_CRG_PLL7 (offset 0x1C, printed page 3-18, `hi3519v101--Hi3519V101-Datasheet.txt` line 4779).";

        enum PERI_CRG_PLL7_vpll_foutvco2xpd_enum {
            NORMAL_OUTPUT = 0 { name = "Normal Output"; desc = "normal output clock"; };
            NO_OUTPUT = 1 { name = "No Output"; desc = "no output clock"; };
        };

        field {
            name = "vpll_foutvco2xpd";
            desc = "VPLL VCO2X output power-down control";
            sw = rw;
            hw = r;
            encode = PERI_CRG_PLL7_vpll_foutvco2xpd_enum;
            reset = 0x0;
        } vpll_foutvco2xpd[27:27];

        enum PERI_CRG_PLL7_vpll_bypass_enum {
            NOT_BYPASSED = 0 { name = "Not Bypassed"; desc = "not bypassed"; };
            BYPASSED = 1 { name = "Bypassed"; desc = "bypassed"; };
        };

        field {
            name = "vpll_bypass";
            desc = "VPLL clock frequency division bypass";
            sw = rw;
            hw = r;
            encode = PERI_CRG_PLL7_vpll_bypass_enum;
            reset = 0x0;
        } vpll_bypass[26:26];

        enum PERI_CRG_PLL7_vpll_dacpd_enum {
            NORMAL_OPERATING_MODE = 0 { name = "Normal Operating Mode"; desc = "normal operating mode"; };
            POWER_DOWN_MODE = 1 { name = "Power Down Mode"; desc = "power-down mode"; };
        };

        field {
            name = "vpll_dacpd";
            desc = "VPLL test signal control";
            sw = rw;
            hw = r;
            encode = PERI_CRG_PLL7_vpll_dacpd_enum;
            reset = 0x0;
        } vpll_dacpd[25:25];

        enum PERI_CRG_PLL7_vpll_dsmpd_enum {
            DECIMAL_FREQUENCY_DIVISION = 0 { name = "Decimal Frequency Division"; desc = "decimal frequency-division mode"; };
            INTEGRAL_FREQUENCY_DIVISION = 1 { name = "Integral Frequency Division"; desc = "integral frequency-division mode"; };
        };

        field {
            name = "vpll_dsmpd";
            desc = "VPLL decimal division control";
            sw = rw;
            hw = r;
            encode = PERI_CRG_PLL7_vpll_dsmpd_enum;
            reset = 0x1;
        } vpll_dsmpd[24:24];

        enum PERI_CRG_PLL7_vpll_pd_enum {
            NORMAL_OPERATING_MODE = 0 { name = "Normal Operating Mode"; desc = "normal operating mode"; };
            POWER_DOWN_MODE = 1 { name = "Power Down Mode"; desc = "power-down mode"; };
        };

        field {
            name = "vpll_pd";
            desc = "VPLL power-down control";
            sw = rw;
            hw = r;
            encode = PERI_CRG_PLL7_vpll_pd_enum;
            reset = 0x0;
        } vpll_pd[23:23];

        enum PERI_CRG_PLL7_vpll_foutvcopd_enum {
            NORMAL_OUTPUT = 0 { name = "Normal Output"; desc = "normal output clock"; };
            NO_OUTPUT = 1 { name = "No Output"; desc = "no output clock"; };
        };

        field {
            name = "vpll_foutvcopd";
            desc = "VPLL VCO output power-down control";
            sw = rw;
            hw = r;
            encode = PERI_CRG_PLL7_vpll_foutvcopd_enum;
            reset = 0x0;
        } vpll_foutvcopd[22:22];

        enum PERI_CRG_PLL7_vpll_postdivpd_enum {
            NORMAL_OUTPUT = 0 { name = "Normal Output"; desc = "normal output clock"; };
            NO_OUTPUT = 1 { name = "No Output"; desc = "no output clock"; };
        };

        field {
            name = "vpll_postdivpd";
            desc = "VPLL POSTDIV output power-down control";
            sw = rw;
            hw = r;
            encode = PERI_CRG_PLL7_vpll_postdivpd_enum;
            reset = 0x0;
        } vpll_postdivpd[21:21];

        enum PERI_CRG_PLL7_vpll_fout4phasepd_enum {
            NORMAL_OUTPUT = 0 { name = "Normal Output"; desc = "normal output clock"; };
            NO_OUTPUT = 1 { name = "No Output"; desc = "no output clock"; };
        };

        field {
            name = "vpll_fout4phasepd";
            desc = "VPLL FOUT output power-down control";
            sw = rw;
            hw = r;
            encode = PERI_CRG_PLL7_vpll_fout4phasepd_enum;
            reset = 0x0;
        } vpll_fout4phasepd[20:20];

        field {
            name = "vpll_refdiv";
            desc = "Frequency divider of the VPLL reference clock";
            sw = rw;
            hw = r;
            reset = 0x2;
        } vpll_refdiv[17:12];

        field {
            name = "vpll_fbdiv";
            desc = "Integral part of the VPLL frequency multiplication coefficient";
            sw = rw;
            hw = r;
            reset = 0x63;
        } vpll_fbdiv[11:0];
    } PERI_CRG_PLL7 @ 0x1C;

    reg {
        name = "EPLL configuration register 0";
        desc = "PERI_CRG_PLL8 is EPLL configuration register 0.

EPLL configuration register 0 (EPLL = PERI_CRG_PLL8/PERI_CRG_PLL9). Reset: postdiv2 = 1, postdiv1 = 3; with PERI_CRG_PLL9 (refdiv 2, fbdiv 125) FOUTVCO = 1500 MHz and POSTDIV = 500 MHz (source of the 500/250/125/100/50 MHz clocks of DS Table 3-2, GMAC and AIAO 1500 MHz option).

Data sheet 3.2.7 PERI_CRG_PLL8 (offset 0x20, printed page 3-19, `hi3519v101--Hi3519V101-Datasheet.txt` line 4843).";

        field {
            name = "epll_postdiv2";
            desc = "Level-2 output divider of the EPLL";
            sw = rw;
            hw = r;
            reset = 0x1;
        } epll_postdiv2[30:28];

        field {
            name = "epll_postdiv1";
            desc = "Level-1 output divider of the EPLL";
            sw = rw;
            hw = r;
            reset = 0x3;
        } epll_postdiv1[26:24];

        field {
            name = "epll_frac";
            desc = "Decimal part of the EPLL frequency multiplication coefficient";
            sw = rw;
            hw = r;
            reset = 0x0;
        } epll_frac[23:0];
    } PERI_CRG_PLL8 @ 0x20;

    reg {
        name = "EPLL configuration register 1";
        desc = "PERI_CRG_PLL9 is EPLL configuration register 1.

EPLL configuration register 1. Reset 0x0100207D: dsmpd 1, refdiv 2, fbdiv 125 (FOUTVCO 1500 MHz).

Data sheet 3.2.7 PERI_CRG_PLL9 (offset 0x24, printed page 3-20, `hi3519v101--Hi3519V101-Datasheet.txt` line 4883).";

        enum PERI_CRG_PLL9_epll_foutvco2xpd_enum {
            NORMAL_OUTPUT = 0 { name = "Normal Output"; desc = "normal output clock"; };
            NO_OUTPUT = 1 { name = "No Output"; desc = "no output clock"; };
        };

        field {
            name = "epll_foutvco2xpd";
            desc = "EPLL VCO2X output power-down control";
            sw = rw;
            hw = r;
            encode = PERI_CRG_PLL9_epll_foutvco2xpd_enum;
            reset = 0x0;
        } epll_foutvco2xpd[27:27];

        enum PERI_CRG_PLL9_epll_bypass_enum {
            NOT_BYPASSED = 0 { name = "Not Bypassed"; desc = "not bypassed"; };
            BYPASSED = 1 { name = "Bypassed"; desc = "bypassed"; };
        };

        field {
            name = "epll_bypass";
            desc = "EPLL clock frequency division bypass";
            sw = rw;
            hw = r;
            encode = PERI_CRG_PLL9_epll_bypass_enum;
            reset = 0x0;
        } epll_bypass[26:26];

        enum PERI_CRG_PLL9_epll_dacpd_enum {
            NORMAL_OPERATING_MODE = 0 { name = "Normal Operating Mode"; desc = "normal operating mode"; };
            POWER_DOWN_MODE = 1 { name = "Power Down Mode"; desc = "power-down mode"; };
        };

        field {
            name = "epll_dacpd";
            desc = "EPLL test signal control";
            sw = rw;
            hw = r;
            encode = PERI_CRG_PLL9_epll_dacpd_enum;
            reset = 0x0;
        } epll_dacpd[25:25];

        enum PERI_CRG_PLL9_epll_dsmpd_enum {
            DECIMAL_FREQUENCY_DIVISION = 0 { name = "Decimal Frequency Division"; desc = "decimal frequency-division mode"; };
            INTEGRAL_FREQUENCY_DIVISION = 1 { name = "Integral Frequency Division"; desc = "integral frequency-division mode"; };
        };

        field {
            name = "epll_dsmpd";
            desc = "EPLL decimal division control";
            sw = rw;
            hw = r;
            encode = PERI_CRG_PLL9_epll_dsmpd_enum;
            reset = 0x1;
        } epll_dsmpd[24:24];

        enum PERI_CRG_PLL9_epll_pd_enum {
            NORMAL_OPERATING_MODE = 0 { name = "Normal Operating Mode"; desc = "normal operating mode"; };
            POWER_DOWN_MODE = 1 { name = "Power Down Mode"; desc = "power-down mode"; };
        };

        field {
            name = "epll_pd";
            desc = "EPLL power-down control";
            sw = rw;
            hw = r;
            encode = PERI_CRG_PLL9_epll_pd_enum;
            reset = 0x0;
        } epll_pd[23:23];

        enum PERI_CRG_PLL9_epll_foutvcopd_enum {
            NORMAL_OUTPUT = 0 { name = "Normal Output"; desc = "normal output clock"; };
            NO_OUTPUT = 1 { name = "No Output"; desc = "no output clock"; };
        };

        field {
            name = "epll_foutvcopd";
            desc = "EPLL VCO output power-down control";
            sw = rw;
            hw = r;
            encode = PERI_CRG_PLL9_epll_foutvcopd_enum;
            reset = 0x0;
        } epll_foutvcopd[22:22];

        enum PERI_CRG_PLL9_epll_postdivpd_enum {
            NORMAL_OUTPUT = 0 { name = "Normal Output"; desc = "normal output clock"; };
            NO_OUTPUT = 1 { name = "No Output"; desc = "no output clock"; };
        };

        field {
            name = "epll_postdivpd";
            desc = "EPLL POSTDIV output power-down control";
            sw = rw;
            hw = r;
            encode = PERI_CRG_PLL9_epll_postdivpd_enum;
            reset = 0x0;
        } epll_postdivpd[21:21];

        enum PERI_CRG_PLL9_epll_fout4phasepd_enum {
            NORMAL_OUTPUT = 0 { name = "Normal Output"; desc = "normal output clock"; };
            NO_OUTPUT = 1 { name = "No Output"; desc = "no output clock"; };
        };

        field {
            name = "epll_fout4phasepd";
            desc = "EPLL FOUT output power-down control";
            sw = rw;
            hw = r;
            encode = PERI_CRG_PLL9_epll_fout4phasepd_enum;
            reset = 0x0;
        } epll_fout4phasepd[20:20];

        field {
            name = "epll_refdiv";
            desc = "Frequency divider of the EPLL reference clock";
            sw = rw;
            hw = r;
            reset = 0x2;
        } epll_refdiv[17:12];

        field {
            name = "epll_fbdiv";
            desc = "Integral part of the EPLL frequency multiplication coefficient";
            sw = rw;
            hw = r;
            reset = 0x7D;
        } epll_fbdiv[11:0];
    } PERI_CRG_PLL9 @ 0x24;

    reg {
        name = "CoreSight & A17 clock reset configuration register";
        desc = "PERI_CRG10 is a CoreSight & A17 clock reset configuration register.

CoreSight and A17 clock/reset. The header total reset value is 0x0318_0002 but the bit rows only add up to 0x0318_0000: bit 1 is reserved in the rows and 1 in the header; it is modelled as the RO field reserved_nz_18_0 (header value wins). a17_wakeup_srst_req resets to 1: the Cortex-A17 cluster is held in reset after power-on and its clock gate (a17_wakeup_clken) is off.

Data sheet 3.2.7 PERI_CRG10 (offset 0x28, printed page 3-21, `hi3519v101--Hi3519V101-Datasheet.txt` line 4947).";

        enum PERI_CRG10_cs_clken_enum {
            DISABLED = 0 { name = "Disabled"; desc = "clock disabled"; };
            ENABLED = 1 { name = "Enabled"; desc = "clock enabled"; };
        };

        field {
            name = "cs_clken";
            desc = "CoreSight TOP clock gating, valid only in manual mode";
            sw = rw;
            hw = r;
            encode = PERI_CRG10_cs_clken_enum;
            reset = 0x1;
        } cs_clken[25:25];

        enum PERI_CRG10_cs_dbg_pwrup_mode_enum {
            AUTOMATIC_MODE = 0 { name = "Automatic Mode"; desc = "automatic mode"; };
            MANUAL_MODE = 1 { name = "Manual Mode"; desc = "manual mode"; };
        };

        field {
            name = "cs_dbg_pwrup_mode";
            desc = "CoreSight TOP power-up mode";
            sw = rw;
            hw = r;
            encode = PERI_CRG10_cs_dbg_pwrup_mode_enum;
            reset = 0x1;
        } cs_dbg_pwrup_mode[24:24];

        enum PERI_CRG10_a17_wakeup_clken_enum {
            DISABLED = 0 { name = "Disabled"; desc = "clock disabled"; };
            ENABLED = 1 { name = "Enabled"; desc = "clock enabled"; };
        };

        field {
            name = "a17_wakeup_clken";
            desc = "A17 subsystem global clock gating.";
            sw = rw;
            hw = r;
            encode = PERI_CRG10_a17_wakeup_clken_enum;
            reset = 0x0;
        } a17_wakeup_clken[21:21];

        enum PERI_CRG10_a17_toppdbg_clken_enum {
            DISABLED = 0 { name = "Disabled"; desc = "clock disabled"; };
            ENABLED = 1 { name = "Enabled"; desc = "clock enabled"; };
        };

        field {
            name = "a17_toppdbg_clken";
            desc = "PCLKDBG clock gating";
            sw = rw;
            hw = r;
            encode = PERI_CRG10_a17_toppdbg_clken_enum;
            reset = 0x1;
        } a17_toppdbg_clken[20:20];

        enum PERI_CRG10_a17_wakeup_srst_req_enum {
            DEASSERT_RESET = 0 { name = "Deassert Reset"; desc = "reset deasserted"; };
            RESET = 1 { name = "Reset"; desc = "reset"; };
        };

        field {
            name = "a17_wakeup_srst_req";
            desc = "A17 subsystem global soft reset.";
            sw = rw;
            hw = r;
            encode = PERI_CRG10_a17_wakeup_srst_req_enum;
            reset = 0x1;
        } a17_wakeup_srst_req[19:19];

        field {
            name = "reserved_nz_18_0";
            desc = "Reserved in the bit table, but the data sheet total reset value of this register has these bits set (reset 0x2).";
            sw = r;
            hw = w;
            reset = 0x2;
        } reserved_nz_18_0[18:0];
    } PERI_CRG10 @ 0x28;

    reg {
        name = "A7 clock reset configuration register";
        desc = "PERI_CRG11 is an A7 clock reset configuration register.

A7 clock/reset. The header reset 0x0010_000F has the reserved bits [3:2] set (modelled as reserved_nz); a7_pcieboot_srst_req resets to 1 (a7_pcieboot_srst_req is only meaningful when the system boots from the DDR of a slave chip over PCIe, a7_wakeup_srst_req otherwise).

Data sheet 3.2.7 PERI_CRG11 (offset 0x2C, printed page 3-22, `hi3519v101--Hi3519V101-Datasheet.txt` line 5004).";

        enum PERI_CRG11_a7_pcieboot_srst_req_enum {
            DEASSERT_RESET = 0 { name = "Deassert Reset"; desc = "reset deasserted"; };
            RESET = 1 { name = "Reset"; desc = "reset"; };
        };

        field {
            name = "a7_pcieboot_srst_req";
            desc = "A7 global soft reset, valid only when the system boots from a DDR of the slave chip over the PCIe interface";
            sw = rw;
            hw = r;
            encode = PERI_CRG11_a7_pcieboot_srst_req_enum;
            reset = 0x1;
        } a7_pcieboot_srst_req[20:20];

        enum PERI_CRG11_a7_wakeup_srst_req_enum {
            DEASSERT_RESET = 0 { name = "Deassert Reset"; desc = "reset deasserted"; };
            RESET = 1 { name = "Reset"; desc = "reset"; };
        };

        field {
            name = "a7_wakeup_srst_req";
            desc = "A7 global soft reset, valid only when the system does not boot from a DDR of the slave chip over the PCIe interface";
            sw = rw;
            hw = r;
            encode = PERI_CRG11_a7_wakeup_srst_req_enum;
            reset = 0x0;
        } a7_wakeup_srst_req[11:11];

        field {
            name = "reserved_nz_10_2";
            desc = "Reserved in the bit table, but the data sheet total reset value of this register has these bits set (reset 0x3).";
            sw = r;
            hw = w;
            reset = 0x3;
        } reserved_nz_10_2[10:2];

        enum PERI_CRG11_a7_wakeup_clken_enum {
            DISABLED = 0 { name = "Disabled"; desc = "clock disabled"; };
            ENABLED = 1 { name = "Enabled"; desc = "clock enabled"; };
        };

        field {
            name = "a7_wakeup_clken";
            desc = "A7 global clock gating";
            sw = rw;
            hw = r;
            encode = PERI_CRG11_a7_wakeup_clken_enum;
            reset = 0x1;
        } a7_wakeup_clken[1:1];

        enum PERI_CRG11_pclkdbg_clken_enum {
            DISABLED = 0 { name = "Disabled"; desc = "clock disabled"; };
            ENABLED = 1 { name = "Enabled"; desc = "clock enabled"; };
        };

        field {
            name = "pclkdbg_clken";
            desc = "A7 PCLKDBG clock gating";
            sw = rw;
            hw = r;
            encode = PERI_CRG11_pclkdbg_clken_enum;
            reset = 0x1;
        } pclkdbg_clken[0:0];
    } PERI_CRG11 @ 0x2C;

    reg {
        name = "DDR clock configuration register";
        desc = "PERI_CRG12 is a DDR clock configuration register.

DDR controller clock gates and soft resets (the DDR clock source itself is selected by PERI_CRG13 ddr_clksel).

Data sheet 3.2.7 PERI_CRG12 (offset 0x30, printed page 3-23, `hi3519v101--Hi3519V101-Datasheet.txt` line 5054).";

        enum PERI_CRG12_ddr_apb_clken_enum {
            DISABLED = 0 { name = "Disabled"; desc = "disabled"; };
            ENABLED = 1 { name = "Enabled"; desc = "enabled"; };
        };

        field {
            name = "ddr_apb_clken";
            desc = "DDR APB gating";
            sw = rw;
            hw = r;
            encode = PERI_CRG12_ddr_apb_clken_enum;
            reset = 0x1;
        } ddr_apb_clken[6:6];

        enum PERI_CRG12_ddr_hipack_clken_enum {
            DISABLED = 0 { name = "Disabled"; desc = "disabled"; };
            ENABLED = 1 { name = "Enabled"; desc = "enabled"; };
        };

        field {
            name = "ddr_hipack_clken";
            desc = "DDR HiPack gating";
            sw = rw;
            hw = r;
            encode = PERI_CRG12_ddr_hipack_clken_enum;
            reset = 0x1;
        } ddr_hipack_clken[5:5];

        enum PERI_CRG12_ddr_cfg_clken_enum {
            DISABLED = 0 { name = "Disabled"; desc = "disabled"; };
            ENABLED = 1 { name = "Enabled"; desc = "enabled"; };
        };

        field {
            name = "ddr_cfg_clken";
            desc = "DDR CFG gating";
            sw = rw;
            hw = r;
            encode = PERI_CRG12_ddr_cfg_clken_enum;
            reset = 0x1;
        } ddr_cfg_clken[4:4];

        enum PERI_CRG12_ddr_apb_srst_req_enum {
            DEASSERT_RESET = 0 { name = "Deassert Reset"; desc = "reset deasserted"; };
            RESET = 1 { name = "Reset"; desc = "reset"; };
        };

        field {
            name = "ddr_apb_srst_req";
            desc = "DDR APB soft reset";
            sw = rw;
            hw = r;
            encode = PERI_CRG12_ddr_apb_srst_req_enum;
            reset = 0x0;
        } ddr_apb_srst_req[1:1];

        enum PERI_CRG12_ddr_hipack_srst_req_enum {
            DEASSERT_RESET = 0 { name = "Deassert Reset"; desc = "reset deasserted"; };
            RESET = 1 { name = "Reset"; desc = "reset"; };
        };

        field {
            name = "ddr_hipack_srst_req";
            desc = "DDR HiPack soft reset";
            sw = rw;
            hw = r;
            encode = PERI_CRG12_ddr_hipack_srst_req_enum;
            reset = 0x0;
        } ddr_hipack_srst_req[0:0];
    } PERI_CRG12 @ 0x30;

    reg {
        name = "SoC frequency configuration register";
        desc = "PERI_CRG13 is an SoC frequency configuration register.

SoC frequency configuration: the CPU/DDR/SYSAXI clock muxes (DS 3.2.5.1, Table 3-5): a7_clksel [9:7], a17_clksel [6:4], ddr_clksel [2:0], sysaxi_clksel [13:12]. Everything resets to the 24 MHz crystal (reset 0). Switch completion is reported in PERI_CRG79. The enum values are taken from the bit rows of this register: a7_clksel 011 = 792 MHz and 100 = 594 MHz, but a17_clksel 011 = 594 MHz and 100 = 792 MHz (the two are swapped relative to each other in the data sheet; PERI_CRG79 repeats the same order). DS Table 3-2 (dump line 4342) lists the A7 choices as `594 MHz 792 MHz` and the A17 choices as `792 MHz 594 MHz`, i.e. the opposite order of the rows; the rows were followed (low confidence, no vendor code uses these values). ddr_clksel 001 = DPLL POSTDIV (466 MHz at reset configuration), 011 = 396, 100 = 340, 101 = 300 MHz; value 010 is not listed (reserved).

Data sheet 3.2.7 PERI_CRG13 (offset 0x34, printed page 3-24, `hi3519v101--Hi3519V101-Datasheet.txt` line 5108).";

        enum PERI_CRG13_sysaxi_clksel_enum {
            CLK_24MHZ = 0 { name = "Clk 24Mhz"; desc = "24 MHz clock (data sheet x0)"; };
            CLK_198MHZ = 1 { name = "Clk 198Mhz"; desc = "198 MHz clock (data sheet x1)"; };
            CLK_24MHZ_2 = 2 { name = "Clk 24Mhz 2"; desc = "24 MHz clock (data sheet x0, bit 12 is a don't-care)"; };
            CLK_198MHZ_3 = 3 { name = "Clk 198Mhz 3"; desc = "198 MHz clock (data sheet x1, bit 12 is a don't-care)"; };
        };

        field {
            name = "sysaxi_clksel";
            desc = "SYSAXI clock select x0: 24 MHz clock x1: 198 MHz clock";
            sw = rw;
            hw = r;
            encode = PERI_CRG13_sysaxi_clksel_enum;
            reset = 0x0;
        } sysaxi_clksel[13:12];

        enum PERI_CRG13_a7_clksel_enum {
            CLK_24MHZ = 0 { name = "Clk 24Mhz"; desc = "24 MHz clock"; };
            RESERVED_1 = 1 { name = "Reserved 1"; desc = "reserved"; };
            APLL_POSTDIV = 2 { name = "Apll Postdiv"; desc = "APLL POSTDIV (maximum 800 MHz)"; };
            CLK_792MHZ = 3 { name = "Clk 792Mhz"; desc = "792 MHz clock"; };
            CLK_594MHZ = 4 { name = "Clk 594Mhz"; desc = "594 MHz clock"; };
            RESERVED_5 = 5 { name = "Reserved 5"; desc = "reserved"; };
            RESERVED_6 = 6 { name = "Reserved 6"; desc = "reserved"; };
            RESERVED_7 = 7 { name = "Reserved 7"; desc = "reserved"; };
        };

        field {
            name = "a7_clksel";
            desc = "A7 clock select. Other values are reserved.";
            sw = rw;
            hw = r;
            encode = PERI_CRG13_a7_clksel_enum;
            reset = 0x0;
        } a7_clksel[9:7];

        enum PERI_CRG13_a17_clksel_enum {
            CLK_24MHZ = 0 { name = "Clk 24Mhz"; desc = "24 MHz clock"; };
            APLL_FOUTVCO = 1 { name = "Apll Foutvco"; desc = "APLL FOUTVCO (minimum 800 MHz and maximum 1.25 GHz)"; };
            APLL_POSTDIV = 2 { name = "Apll Postdiv"; desc = "APLL POSTDIV (maximum 800 MHz)"; };
            CLK_594MHZ = 3 { name = "Clk 594Mhz"; desc = "594 MHz clock"; };
            CLK_792MHZ = 4 { name = "Clk 792Mhz"; desc = "792 MHz clock"; };
            RESERVED_5 = 5 { name = "Reserved 5"; desc = "reserved"; };
            RESERVED_6 = 6 { name = "Reserved 6"; desc = "reserved"; };
            RESERVED_7 = 7 { name = "Reserved 7"; desc = "reserved"; };
        };

        field {
            name = "a17_clksel";
            desc = "A17 CPU clock select. Other values are reserved.";
            sw = rw;
            hw = r;
            encode = PERI_CRG13_a17_clksel_enum;
            reset = 0x0;
        } a17_clksel[6:4];

        enum PERI_CRG13_ddr_clksel_enum {
            CLK_24MHZ = 0 { name = "Clk 24Mhz"; desc = "24 MHz crystal oscillator clock"; };
            DPLL_POSTDIV = 1 { name = "Dpll Postdiv"; desc = "DPLL POSTDIV (maximum 466 MHz)"; };
            RESERVED_2 = 2 { name = "Reserved 2"; desc = "reserved"; };
            CLK_396MHZ = 3 { name = "Clk 396Mhz"; desc = "396 MHz clock"; };
            CLK_340MHZ = 4 { name = "Clk 340Mhz"; desc = "340 MHz clock"; };
            CLK_300MHZ = 5 { name = "Clk 300Mhz"; desc = "300 MHz clock"; };
            RESERVED_6 = 6 { name = "Reserved 6"; desc = "reserved"; };
            RESERVED_7 = 7 { name = "Reserved 7"; desc = "reserved"; };
        };

        field {
            name = "ddr_clksel";
            desc = "DDR clock select. Other values are reserved.";
            sw = rw;
            hw = r;
            encode = PERI_CRG13_ddr_clksel_enum;
            reset = 0x0;
        } ddr_clksel[2:0];
    } PERI_CRG13 @ 0x34;

    reg {
        name = "VI-MIPI clock reset configuration register";
        desc = "PERI_CRG15 is a VI-MIPI clock reset configuration register.

VI-MIPI clock and reset. The header reset 0x1200_03FF has bit 7 set although the rows leave it reserved (modelled as reserved_nz_7_7). Bits [27:26] are a reserved row that the data sheet names `reverse` (typo for reserved); not modelled as a field.

Data sheet 3.2.7 PERI_CRG15 (offset 0x3C, printed page 3-25, `hi3519v101--Hi3519V101-Datasheet.txt` line 5170).";

        enum PERI_CRG15_isp1_clken_enum {
            DISABLED = 0 { name = "Disabled"; desc = "clock disabled"; };
            ENABLED = 1 { name = "Enabled"; desc = "clock enabled"; };
        };

        field {
            name = "isp1_clken";
            desc = "ISP1 clock gating";
            sw = rw;
            hw = r;
            encode = PERI_CRG15_isp1_clken_enum;
            reset = 0x0;
        } isp1_clken[29:29];

        enum PERI_CRG15_isp0_clken_enum {
            DISABLED = 0 { name = "Disabled"; desc = "clock disabled"; };
            ENABLED = 1 { name = "Enabled"; desc = "clock enabled"; };
        };

        field {
            name = "isp0_clken";
            desc = "ISP0 clock gating";
            sw = rw;
            hw = r;
            encode = PERI_CRG15_isp0_clken_enum;
            reset = 0x1;
        } isp0_clken[28:28];

        enum PERI_CRG15_vi1_pctrl_enum {
            NOT_INVERTED = 0 { name = "Not Inverted"; desc = "not inverted"; };
            INVERTED = 1 { name = "Inverted"; desc = "inverted"; };
        };

        field {
            name = "vi1_pctrl";
            desc = "Phase of the VI1 interface clock";
            sw = rw;
            hw = r;
            encode = PERI_CRG15_vi1_pctrl_enum;
            reset = 0x1;
        } vi1_pctrl[25:25];

        enum PERI_CRG15_vi1_clken_enum {
            DISABLED = 0 { name = "Disabled"; desc = "clock disabled"; };
            ENABLED = 1 { name = "Enabled"; desc = "clock enabled"; };
        };

        field {
            name = "vi1_clken";
            desc = "VI1 clock gating";
            sw = rw;
            hw = r;
            encode = PERI_CRG15_vi1_clken_enum;
            reset = 0x0;
        } vi1_clken[24:24];

        enum PERI_CRG15_mipi1_core_srst_req_enum {
            DEASSERT_RESET = 0 { name = "Deassert Reset"; desc = "reset deasserted"; };
            RESET = 1 { name = "Reset"; desc = "reset"; };
        };

        field {
            name = "mipi1_core_srst_req";
            desc = "Core soft reset of the MIPI controller channel 1 (Only the working logic is reset and the configuration logic is not reset.)";
            sw = rw;
            hw = r;
            encode = PERI_CRG15_mipi1_core_srst_req_enum;
            reset = 0x0;
        } mipi1_core_srst_req[22:22];

        enum PERI_CRG15_isp1_cfg_srst_req_enum {
            DEASSERT_RESET = 0 { name = "Deassert Reset"; desc = "reset deasserted"; };
            RESET = 1 { name = "Reset"; desc = "reset"; };
        };

        field {
            name = "isp1_cfg_srst_req";
            desc = "ISP1 CFG soft reset (Only the configuration logic is reset and the working logic is not reset.)";
            sw = rw;
            hw = r;
            encode = PERI_CRG15_isp1_cfg_srst_req_enum;
            reset = 0x0;
        } isp1_cfg_srst_req[21:21];

        enum PERI_CRG15_isp1_core_srst_req_enum {
            DEASSERT_RESET = 0 { name = "Deassert Reset"; desc = "reset deasserted"; };
            RESET = 1 { name = "Reset"; desc = "reset"; };
        };

        field {
            name = "isp1_core_srst_req";
            desc = "ISP1 core soft reset (Only the working logic is reset and the configuration logic and other logic are not reset.)";
            sw = rw;
            hw = r;
            encode = PERI_CRG15_isp1_core_srst_req_enum;
            reset = 0x0;
        } isp1_core_srst_req[20:20];

        enum PERI_CRG15_mipi1_srst_req_enum {
            DEASSERT_RESET = 0 { name = "Deassert Reset"; desc = "reset deasserted"; };
            RESET = 1 { name = "Reset"; desc = "reset"; };
        };

        field {
            name = "mipi1_srst_req";
            desc = "Soft reset of the MIPI controller channel 1 (core and CFG)";
            sw = rw;
            hw = r;
            encode = PERI_CRG15_mipi1_srst_req_enum;
            reset = 0x0;
        } mipi1_srst_req[18:18];

        enum PERI_CRG15_vi1_hrst_req_enum {
            DEASSERT_RESET = 0 { name = "Deassert Reset"; desc = "reset deasserted"; };
            RESET = 1 { name = "Reset"; desc = "reset"; };
        };

        field {
            name = "vi1_hrst_req";
            desc = "VI1 bus soft reset";
            sw = rw;
            hw = r;
            encode = PERI_CRG15_vi1_hrst_req_enum;
            reset = 0x0;
        } vi1_hrst_req[17:17];

        enum PERI_CRG15_vi1_srst_req_enum {
            DEASSERT_RESET = 0 { name = "Deassert Reset"; desc = "reset deasserted"; };
            RESET = 1 { name = "Reset"; desc = "reset"; };
        };

        field {
            name = "vi1_srst_req";
            desc = "VI1 soft reset";
            sw = rw;
            hw = r;
            encode = PERI_CRG15_vi1_srst_req_enum;
            reset = 0x0;
        } vi1_srst_req[16:16];

        enum PERI_CRG15_vi0_pctrl_enum {
            NOT_INVERTED = 0 { name = "Not Inverted"; desc = "not inverted"; };
            INVERTED = 1 { name = "Inverted"; desc = "inverted"; };
        };

        field {
            name = "vi0_pctrl";
            desc = "Phase of the VI0 interface clock";
            sw = rw;
            hw = r;
            encode = PERI_CRG15_vi0_pctrl_enum;
            reset = 0x1;
        } vi0_pctrl[9:9];

        enum PERI_CRG15_vi0_clken_enum {
            DISABLED = 0 { name = "Disabled"; desc = "clock disabled"; };
            ENABLED = 1 { name = "Enabled"; desc = "clock enabled"; };
        };

        field {
            name = "vi0_clken";
            desc = "VI0 clock gating";
            sw = rw;
            hw = r;
            encode = PERI_CRG15_vi0_clken_enum;
            reset = 0x1;
        } vi0_clken[8:8];

        field {
            name = "reserved_nz_7_7";
            desc = "Reserved in the bit table, but the data sheet total reset value of this register has these bits set (reset 0x1).";
            sw = r;
            hw = w;
            reset = 0x1;
        } reserved_nz_7_7[7:7];

        enum PERI_CRG15_mipi0_core_srst_req_enum {
            DEASSERT_RESET = 0 { name = "Deassert Reset"; desc = "reset deasserted"; };
            RESET = 1 { name = "Reset"; desc = "reset"; };
        };

        field {
            name = "mipi0_core_srst_req";
            desc = "Core soft reset of the MIPI controller channel 0 (Only the working logic is reset and the configuration logic is not reset.)";
            sw = rw;
            hw = r;
            encode = PERI_CRG15_mipi0_core_srst_req_enum;
            reset = 0x1;
        } mipi0_core_srst_req[6:6];

        enum PERI_CRG15_isp0_cfg_srst_req_enum {
            DEASSERT_RESET = 0 { name = "Deassert Reset"; desc = "reset deasserted"; };
            RESET = 1 { name = "Reset"; desc = "reset"; };
        };

        field {
            name = "isp0_cfg_srst_req";
            desc = "ISP0 CFG soft reset (Only the configuration logic is reset and the working logic is not reset.)";
            sw = rw;
            hw = r;
            encode = PERI_CRG15_isp0_cfg_srst_req_enum;
            reset = 0x1;
        } isp0_cfg_srst_req[5:5];

        enum PERI_CRG15_isp0_core_srst_req_enum {
            DEASSERT_RESET = 0 { name = "Deassert Reset"; desc = "reset deasserted"; };
            RESET = 1 { name = "Reset"; desc = "reset"; };
        };

        field {
            name = "isp0_core_srst_req";
            desc = "ISP0 core soft reset (Only the working logic is reset and the configuration logic is not reset.)";
            sw = rw;
            hw = r;
            encode = PERI_CRG15_isp0_core_srst_req_enum;
            reset = 0x1;
        } isp0_core_srst_req[4:4];

        enum PERI_CRG15_mipi_hrst_req_enum {
            DEASSERT_RESET = 0 { name = "Deassert Reset"; desc = "reset deasserted"; };
            RESET = 1 { name = "Reset"; desc = "reset"; };
        };

        field {
            name = "mipi_hrst_req";
            desc = "Soft reset of the MIPI controller bus";
            sw = rw;
            hw = r;
            encode = PERI_CRG15_mipi_hrst_req_enum;
            reset = 0x1;
        } mipi_hrst_req[3:3];

        enum PERI_CRG15_mipi0_srst_req_enum {
            DEASSERT_RESET = 0 { name = "Deassert Reset"; desc = "reset deasserted"; };
            RESET = 1 { name = "Reset"; desc = "reset"; };
        };

        field {
            name = "mipi0_srst_req";
            desc = "Core and CFG soft reset of the MIPI controller channel 0 (Both the working logic and the configuration logic are reset.)";
            sw = rw;
            hw = r;
            encode = PERI_CRG15_mipi0_srst_req_enum;
            reset = 0x1;
        } mipi0_srst_req[2:2];

        enum PERI_CRG15_vi0_hrst_req_enum {
            DEASSERT_RESET = 0 { name = "Deassert Reset"; desc = "reset deasserted"; };
            RESET = 1 { name = "Reset"; desc = "reset"; };
        };

        field {
            name = "vi0_hrst_req";
            desc = "VI0 bus soft reset";
            sw = rw;
            hw = r;
            encode = PERI_CRG15_vi0_hrst_req_enum;
            reset = 0x1;
        } vi0_hrst_req[1:1];

        enum PERI_CRG15_vi0_srst_req_enum {
            DEASSERT_RESET = 0 { name = "Deassert Reset"; desc = "reset deasserted"; };
            RESET = 1 { name = "Reset"; desc = "reset"; };
        };

        field {
            name = "vi0_srst_req";
            desc = "VI0 soft reset";
            sw = rw;
            hw = r;
            encode = PERI_CRG15_vi0_srst_req_enum;
            reset = 0x1;
        } vi0_srst_req[0:0];
    } PERI_CRG15 @ 0x3C;

    reg {
        name = "Sensor clock configuration register";
        desc = "PERI_CRG16 is a sensor clock configuration register.

Sensor0/sensor1 reference clock (clock output by the chip to the sensor): select, gate, reset, slave-mode control reset. Select rows use don't-care bits (01xx = 24 MHz, 11xx = 12 MHz); every value of the 4-bit field is listed as its own enum member.

Data sheet 3.2.7 PERI_CRG16 (offset 0x40, printed page 3-27, `hi3519v101--Hi3519V101-Datasheet.txt` line 5295).";

        enum PERI_CRG16_sensor1_ctrl_srst_req_enum {
            DEASSERT_RESET = 0 { name = "Deassert Reset"; desc = "reset deasserted"; };
            RESET = 1 { name = "Reset"; desc = "reset"; };
        };

        field {
            name = "sensor1_ctrl_srst_req";
            desc = "Soft reset on the slave mode control module of sensor1";
            sw = rw;
            hw = r;
            encode = PERI_CRG16_sensor1_ctrl_srst_req_enum;
            reset = 0x0;
        } sensor1_ctrl_srst_req[14:14];

        enum PERI_CRG16_sensor1_srst_req_enum {
            DEASSERT_RESET = 0 { name = "Deassert Reset"; desc = "reset deasserted"; };
            RESET = 1 { name = "Reset"; desc = "reset"; };
        };

        field {
            name = "sensor1_srst_req";
            desc = "Sensor1 soft reset";
            sw = rw;
            hw = r;
            encode = PERI_CRG16_sensor1_srst_req_enum;
            reset = 0x0;
        } sensor1_srst_req[13:13];

        enum PERI_CRG16_sensor1_clken_enum {
            DISABLED = 0 { name = "Disabled"; desc = "clock disabled"; };
            ENABLED = 1 { name = "Enabled"; desc = "clock enabled"; };
        };

        field {
            name = "sensor1_clken";
            desc = "Sensor1 clock (reference clock output by the chip to the sensor) gating";
            sw = rw;
            hw = r;
            encode = PERI_CRG16_sensor1_clken_enum;
            reset = 0x0;
        } sensor1_clken[12:12];

        enum PERI_CRG16_sensor1_clksel_enum {
            CLK_74P25MHZ = 0 { name = "Clk 74P25Mhz"; desc = "74.25 MHz"; };
            CLK_72MHZ = 1 { name = "Clk 72Mhz"; desc = "72 MHz"; };
            CLK_54MHZ = 2 { name = "Clk 54Mhz"; desc = "54 MHz"; };
            CLK_50MHZ = 3 { name = "Clk 50Mhz"; desc = "50 MHz"; };
            CLK_24MHZ_4 = 4 { name = "Clk 24Mhz 4"; desc = "24 MHz (data sheet 01xx)"; };
            CLK_24MHZ_5 = 5 { name = "Clk 24Mhz 5"; desc = "24 MHz (data sheet 01xx)"; };
            CLK_24MHZ_6 = 6 { name = "Clk 24Mhz 6"; desc = "24 MHz (data sheet 01xx)"; };
            CLK_24MHZ_7 = 7 { name = "Clk 24Mhz 7"; desc = "24 MHz (data sheet 01xx)"; };
            CLK_37P125MHZ = 8 { name = "Clk 37P125Mhz"; desc = "37.125 MHz"; };
            CLK_36MHZ = 9 { name = "Clk 36Mhz"; desc = "36 MHz"; };
            CLK_27MHZ = 10 { name = "Clk 27Mhz"; desc = "27 MHz"; };
            CLK_25MHZ = 11 { name = "Clk 25Mhz"; desc = "25 MHz"; };
            CLK_12MHZ_12 = 12 { name = "Clk 12Mhz 12"; desc = "12 MHz (data sheet 11xx)"; };
            CLK_12MHZ_13 = 13 { name = "Clk 12Mhz 13"; desc = "12 MHz (data sheet 11xx)"; };
            CLK_12MHZ_14 = 14 { name = "Clk 12Mhz 14"; desc = "12 MHz (data sheet 11xx)"; };
            CLK_12MHZ_15 = 15 { name = "Clk 12Mhz 15"; desc = "12 MHz (data sheet 11xx)"; };
        };

        field {
            name = "sensor1_clksel";
            desc = "Sensor1 clock (reference clock output by the chip to the sensor) select";
            sw = rw;
            hw = r;
            encode = PERI_CRG16_sensor1_clksel_enum;
            reset = 0x0;
        } sensor1_clksel[11:8];

        enum PERI_CRG16_sensor0_ctrl_srst_req_enum {
            DEASSERT_RESET = 0 { name = "Deassert Reset"; desc = "reset deasserted"; };
            RESET = 1 { name = "Reset"; desc = "reset"; };
        };

        field {
            name = "sensor0_ctrl_srst_req";
            desc = "Soft reset on the slave mode control module of sensor0";
            sw = rw;
            hw = r;
            encode = PERI_CRG16_sensor0_ctrl_srst_req_enum;
            reset = 0x0;
        } sensor0_ctrl_srst_req[6:6];

        enum PERI_CRG16_sensor0_srst_req_enum {
            DEASSERT_RESET = 0 { name = "Deassert Reset"; desc = "reset deasserted"; };
            RESET = 1 { name = "Reset"; desc = "reset"; };
        };

        field {
            name = "sensor0_srst_req";
            desc = "Sensor0 soft reset";
            sw = rw;
            hw = r;
            encode = PERI_CRG16_sensor0_srst_req_enum;
            reset = 0x0;
        } sensor0_srst_req[5:5];

        enum PERI_CRG16_sensor0_clken_enum {
            DISABLED = 0 { name = "Disabled"; desc = "clock disabled"; };
            ENABLED = 1 { name = "Enabled"; desc = "clock enabled"; };
        };

        field {
            name = "sensor0_clken";
            desc = "Sensor0 clock (reference clock output by the chip to the sensor) gating";
            sw = rw;
            hw = r;
            encode = PERI_CRG16_sensor0_clken_enum;
            reset = 0x0;
        } sensor0_clken[4:4];

        enum PERI_CRG16_sensor0_clksel_enum {
            CLK_74P25MHZ = 0 { name = "Clk 74P25Mhz"; desc = "74.25 MHz"; };
            CLK_72MHZ = 1 { name = "Clk 72Mhz"; desc = "72 MHz"; };
            CLK_54MHZ = 2 { name = "Clk 54Mhz"; desc = "54 MHz"; };
            CLK_50MHZ = 3 { name = "Clk 50Mhz"; desc = "50 MHz"; };
            CLK_24MHZ_4 = 4 { name = "Clk 24Mhz 4"; desc = "24 MHz (data sheet 01xx)"; };
            CLK_24MHZ_5 = 5 { name = "Clk 24Mhz 5"; desc = "24 MHz (data sheet 01xx)"; };
            CLK_24MHZ_6 = 6 { name = "Clk 24Mhz 6"; desc = "24 MHz (data sheet 01xx)"; };
            CLK_24MHZ_7 = 7 { name = "Clk 24Mhz 7"; desc = "24 MHz (data sheet 01xx)"; };
            CLK_37P125MHZ = 8 { name = "Clk 37P125Mhz"; desc = "37.125 MHz"; };
            CLK_36MHZ = 9 { name = "Clk 36Mhz"; desc = "36 MHz"; };
            CLK_27MHZ = 10 { name = "Clk 27Mhz"; desc = "27 MHz"; };
            CLK_25MHZ = 11 { name = "Clk 25Mhz"; desc = "25 MHz"; };
            CLK_12MHZ_12 = 12 { name = "Clk 12Mhz 12"; desc = "12 MHz (data sheet 11xx)"; };
            CLK_12MHZ_13 = 13 { name = "Clk 12Mhz 13"; desc = "12 MHz (data sheet 11xx)"; };
            CLK_12MHZ_14 = 14 { name = "Clk 12Mhz 14"; desc = "12 MHz (data sheet 11xx)"; };
            CLK_12MHZ_15 = 15 { name = "Clk 12Mhz 15"; desc = "12 MHz (data sheet 11xx)"; };
        };

        field {
            name = "sensor0_clksel";
            desc = "Sensor0 clock (reference clock output by the chip to the sensor) select";
            sw = rw;
            hw = r;
            encode = PERI_CRG16_sensor0_clksel_enum;
            reset = 0x0;
        } sensor0_clksel[3:0];
    } PERI_CRG16 @ 0x40;

    reg {
        name = "VDP clock and reset control register";
        desc = "PERI_CRG17 is a VDP clock and reset control register.

VDP clock and reset. Header total reset 0x4, but the row of vdp_srst_req (bit 0) resets to 1 (0x5 in total): the row value is used (low confidence, no vendor code relies on it at reset); DS inconsistency, header says 0x0000_0004 (dump line 5559 region).

Data sheet 3.2.7 PERI_CRG17 (offset 0x44, printed page 3-29, `hi3519v101--Hi3519V101-Datasheet.txt` line 5391).";

        enum PERI_CRG17_vdp_core_clksel_enum {
            CLK_300MHZ = 0 { name = "Clk 300Mhz"; desc = "300 MHz"; };
            CLK_198MHZ = 1 { name = "Clk 198Mhz"; desc = "198 MHz"; };
        };

        field {
            name = "vdp_core_clksel";
            desc = "VDP working clock select";
            sw = rw;
            hw = r;
            encode = PERI_CRG17_vdp_core_clksel_enum;
            reset = 0x0;
        } vdp_core_clksel[17:17];

        enum PERI_CRG17_vdp_out_clksel_enum {
            CLK_148P5MHZ = 0 { name = "Clk 148P5Mhz"; desc = "148.5 MHz"; };
            CLK_74P25MHZ = 1 { name = "Clk 74P25Mhz"; desc = "74.25 MHz"; };
            CLK_37P125MHZ = 2 { name = "Clk 37P125Mhz"; desc = "37.125 MHz"; };
            CLK_107MHZ = 3 { name = "Clk 107Mhz"; desc = "107 MHz"; };
            CLK_54MHZ = 4 { name = "Clk 54Mhz"; desc = "54 MHz"; };
            CLK_27MHZ = 5 { name = "Clk 27Mhz"; desc = "27 MHz"; };
            LCD_FREQUENCY_DIVIDER = 6 { name = "Lcd Frequency Divider"; desc = "LCD frequency divider clock"; };
            RESERVED_7 = 7 { name = "Reserved 7"; desc = "reserved"; };
        };

        field {
            name = "vdp_out_clksel";
            desc = "VDP output clock (output clock of the chip) select";
            sw = rw;
            hw = r;
            encode = PERI_CRG17_vdp_out_clksel_enum;
            reset = 0x0;
        } vdp_out_clksel[16:14];

        enum PERI_CRG17_hd_div_mode_enum {
            NO_DIVISION = 0 { name = "No Division"; desc = "no division"; };
            DIVIDED_2 = 1 { name = "Divided 2"; desc = "divided by 2"; };
            DIVIDED_3 = 2 { name = "Divided 3"; desc = "divided by 3"; };
            DIVIDED_4 = 3 { name = "Divided 4"; desc = "divided by 4"; };
        };

        field {
            name = "hd_div_mode";
            desc = "Clock divider of the VDP output clock (output clock of the chip) and the HD channel clock";
            sw = rw;
            hw = r;
            encode = PERI_CRG17_hd_div_mode_enum;
            reset = 0x0;
        } hd_div_mode[13:12];

        enum PERI_CRG17_vdac_clken_enum {
            DISABLED = 0 { name = "Disabled"; desc = "clock disabled"; };
            ENABLED = 1 { name = "Enabled"; desc = "clock enabled"; };
        };

        field {
            name = "vdac_clken";
            desc = "VDAC clock gating";
            sw = rw;
            hw = r;
            encode = PERI_CRG17_vdac_clken_enum;
            reset = 0x0;
        } vdac_clken[11:11];

        enum PERI_CRG17_vdp_sd_clken_enum {
            DISABLED = 0 { name = "Disabled"; desc = "clock disabled"; };
            ENABLED = 1 { name = "Enabled"; desc = "clock enabled"; };
        };

        field {
            name = "vdp_sd_clken";
            desc = "VDP SD clock gating";
            sw = rw;
            hw = r;
            encode = PERI_CRG17_vdp_sd_clken_enum;
            reset = 0x0;
        } vdp_sd_clken[10:10];

        enum PERI_CRG17_vdp_hd_clken_enum {
            DISABLED = 0 { name = "Disabled"; desc = "clock disabled"; };
            ENABLED = 1 { name = "Enabled"; desc = "clock enabled"; };
        };

        field {
            name = "vdp_hd_clken";
            desc = "VDP HD clock gating";
            sw = rw;
            hw = r;
            encode = PERI_CRG17_vdp_hd_clken_enum;
            reset = 0x0;
        } vdp_hd_clken[9:9];

        enum PERI_CRG17_vdp_out_clken_enum {
            DISABLED = 0 { name = "Disabled"; desc = "clock disabled"; };
            ENABLED = 1 { name = "Enabled"; desc = "clock enabled"; };
        };

        field {
            name = "vdp_out_clken";
            desc = "VDP output clock (output clock of the chip) gating";
            sw = rw;
            hw = r;
            encode = PERI_CRG17_vdp_out_clken_enum;
            reset = 0x0;
        } vdp_out_clken[8:8];

        enum PERI_CRG17_vdp_aclken_enum {
            DISABLED = 0 { name = "Disabled"; desc = "clock disabled"; };
            ENABLED = 1 { name = "Enabled"; desc = "clock enabled"; };
        };

        field {
            name = "vdp_aclken";
            desc = "VDP AXI bus clock gating";
            sw = rw;
            hw = r;
            encode = PERI_CRG17_vdp_aclken_enum;
            reset = 0x0;
        } vdp_aclken[7:7];

        enum PERI_CRG17_vdp_pclken_enum {
            DISABLED = 0 { name = "Disabled"; desc = "clock disabled"; };
            ENABLED = 1 { name = "Enabled"; desc = "clock enabled"; };
        };

        field {
            name = "vdp_pclken";
            desc = "VDP APB clock gating";
            sw = rw;
            hw = r;
            encode = PERI_CRG17_vdp_pclken_enum;
            reset = 0x0;
        } vdp_pclken[6:6];

        enum PERI_CRG17_vdp_core_clken_enum {
            DISABLED = 0 { name = "Disabled"; desc = "clock disabled"; };
            ENABLED = 1 { name = "Enabled"; desc = "clock enabled"; };
        };

        field {
            name = "vdp_core_clken";
            desc = "VDP working clock gating";
            sw = rw;
            hw = r;
            encode = PERI_CRG17_vdp_core_clken_enum;
            reset = 0x0;
        } vdp_core_clken[5:5];

        enum PERI_CRG17_vdp_cfg_clken_enum {
            DISABLED = 0 { name = "Disabled"; desc = "clock disabled"; };
            ENABLED = 1 { name = "Enabled"; desc = "clock enabled"; };
        };

        field {
            name = "vdp_cfg_clken";
            desc = "VDP CFG clock gating (internally configured)";
            sw = rw;
            hw = r;
            encode = PERI_CRG17_vdp_cfg_clken_enum;
            reset = 0x0;
        } vdp_cfg_clken[4:4];

        enum PERI_CRG17_vdac_pctrl_enum {
            NOT_INVERTED = 0 { name = "Not Inverted"; desc = "not inverted"; };
            INVERTED = 1 { name = "Inverted"; desc = "inverted"; };
        };

        field {
            name = "vdac_pctrl";
            desc = "VDAC clock phase";
            sw = rw;
            hw = r;
            encode = PERI_CRG17_vdac_pctrl_enum;
            reset = 0x0;
        } vdac_pctrl[3:3];

        enum PERI_CRG17_vdp_out_pctrl_enum {
            NOT_INVERTED = 0 { name = "Not Inverted"; desc = "not inverted"; };
            INVERTED = 1 { name = "Inverted"; desc = "inverted"; };
        };

        field {
            name = "vdp_out_pctrl";
            desc = "VDP output clock (output clock of the chip) phase. The clock is inverted by default.";
            sw = rw;
            hw = r;
            encode = PERI_CRG17_vdp_out_pctrl_enum;
            reset = 0x1;
        } vdp_out_pctrl[2:2];

        enum PERI_CRG17_vdp_srst_req_enum {
            DEASSERT_RESET = 0 { name = "Deassert Reset"; desc = "reset deasserted"; };
            RESET = 1 { name = "Reset"; desc = "reset"; };
        };

        field {
            name = "vdp_srst_req";
            desc = "VDP soft reset";
            sw = rw;
            hw = r;
            encode = PERI_CRG17_vdp_srst_req_enum;
            reset = 0x1;
        } vdp_srst_req[0:0];
    } PERI_CRG17 @ 0x44;

    reg {
        name = "LCD clock configuration register";
        desc = "PERI_CRG18 is an LCD clock configuration register.

LCD clock. lcd_mclk_div = (X / 1188) x 2^27 for a target of X MHz (the dump prints the exponent as `227`); the reset value 0x0015E4C3 = 1434819 therefore corresponds to about 12.7 MHz (low confidence about the exponent: with 2^26 the reset would be 25.4 MHz).

Data sheet 3.2.7 PERI_CRG18 (offset 0x48, printed page 3-31, `hi3519v101--Hi3519V101-Datasheet.txt` line 5493).";

        enum PERI_CRG18_lcd_clken_enum {
            DISABLED = 0 { name = "Disabled"; desc = "clock disabled"; };
            ENABLED = 1 { name = "Enabled"; desc = "clock enabled"; };
        };

        field {
            name = "lcd_clken";
            desc = "LCD frequency divider clock gating";
            sw = rw;
            hw = r;
            encode = PERI_CRG18_lcd_clken_enum;
            reset = 0x0;
        } lcd_clken[27:27];

        field {
            name = "lcd_mclk_div";
            desc = "LCD frequency division clock (configurable). Assume that the target frequency is X (MHz), the LCD frequency division clock is calculated as lcd_mclk_div = (X/1188) x 2^27 (the data sheet dump prints the exponent as `227`).";
            sw = rw;
            hw = r;
            reset = 0x0015E4C3;
        } lcd_mclk_div[26:0];
    } PERI_CRG18 @ 0x48;

    reg {
        name = "Media CBB frequency profile configuration register 1";
        desc = "PERI_CRG19 is media CBB frequency configuration register 1.

Media clock selects: IVE [21:19], GDC [18:16], VGS [15:13], VEDU [12:10], VPSS [7:5], VI0 [2:0]. DS Table 3-2 gives the defaults: IVE 300 MHz, GDC 340 MHz, VGS 300 MHz, VPSS 214 MHz, VI0 214 MHz and VEDU `reserved` (the bit rows list only 001 = 396 MHz for VEDU; select the clock before starting the module).

Data sheet 3.2.7 PERI_CRG19 (offset 0x4C, printed page 3-31, `hi3519v101--Hi3519V101-Datasheet.txt` line 5525).";

        enum PERI_CRG19_ive_clksel_enum {
            CLK_300MHZ = 0 { name = "Clk 300Mhz"; desc = "300 MHz"; };
            CLK_396MHZ = 1 { name = "Clk 396Mhz"; desc = "396 MHz"; };
            CLK_500MHZ = 2 { name = "Clk 500Mhz"; desc = "500 MHz"; };
            RESERVED_3 = 3 { name = "Reserved 3"; desc = "reserved"; };
            RESERVED_4 = 4 { name = "Reserved 4"; desc = "reserved"; };
            RESERVED_5 = 5 { name = "Reserved 5"; desc = "reserved"; };
            RESERVED_6 = 6 { name = "Reserved 6"; desc = "reserved"; };
            RESERVED_7 = 7 { name = "Reserved 7"; desc = "reserved"; };
        };

        field {
            name = "ive_clksel";
            desc = "IVE clock select. Other values are reserved.";
            sw = rw;
            hw = r;
            encode = PERI_CRG19_ive_clksel_enum;
            reset = 0x0;
        } ive_clksel[21:19];

        enum PERI_CRG19_gdc_clksel_enum {
            CLK_340MHZ = 0 { name = "Clk 340Mhz"; desc = "340 MHz"; };
            CLK_475MHZ = 1 { name = "Clk 475Mhz"; desc = "475 MHz"; };
            CLK_400MHZ = 2 { name = "Clk 400Mhz"; desc = "400 MHz"; };
            BPLL_POSTDIV = 3 { name = "Bpll Postdiv"; desc = "BPLL POSTDIV"; };
            RESERVED_4 = 4 { name = "Reserved 4"; desc = "reserved"; };
            RESERVED_5 = 5 { name = "Reserved 5"; desc = "reserved"; };
            RESERVED_6 = 6 { name = "Reserved 6"; desc = "reserved"; };
            RESERVED_7 = 7 { name = "Reserved 7"; desc = "reserved"; };
        };

        field {
            name = "gdc_clksel";
            desc = "GDC clock select. Other values are reserved.";
            sw = rw;
            hw = r;
            encode = PERI_CRG19_gdc_clksel_enum;
            reset = 0x0;
        } gdc_clksel[18:16];

        enum PERI_CRG19_vgs_clksel_enum {
            CLK_300MHZ = 0 { name = "Clk 300Mhz"; desc = "300 MHz"; };
            CLK_396MHZ = 1 { name = "Clk 396Mhz"; desc = "396 MHz"; };
            CLK_500MHZ = 2 { name = "Clk 500Mhz"; desc = "500 MHz"; };
            RESERVED_3 = 3 { name = "Reserved 3"; desc = "reserved"; };
            RESERVED_4 = 4 { name = "Reserved 4"; desc = "reserved"; };
            RESERVED_5 = 5 { name = "Reserved 5"; desc = "reserved"; };
            RESERVED_6 = 6 { name = "Reserved 6"; desc = "reserved"; };
            RESERVED_7 = 7 { name = "Reserved 7"; desc = "reserved"; };
        };

        field {
            name = "vgs_clksel";
            desc = "VGS clock select. Other values are reserved.";
            sw = rw;
            hw = r;
            encode = PERI_CRG19_vgs_clksel_enum;
            reset = 0x0;
        } vgs_clksel[15:13];

        enum PERI_CRG19_vedu_clksel_enum {
            RESERVED_0 = 0 { name = "Reserved 0"; desc = "reserved (reset value; select a clock before starting the VEDU)"; };
            CLK_396MHZ = 1 { name = "Clk 396Mhz"; desc = "396 MHz"; };
            CLK_500MHZ = 2 { name = "Clk 500Mhz"; desc = "500 MHz (Hi3519 V101 only; reserved in the Hi3516A V200 data sheet)"; };
            CLK_594MHZ = 3 { name = "Clk 594Mhz"; desc = "594 MHz (Hi3519 V101 only; reserved in the Hi3516A V200 data sheet)"; };
            RESERVED_4 = 4 { name = "Reserved 4"; desc = "reserved"; };
            RESERVED_5 = 5 { name = "Reserved 5"; desc = "reserved"; };
            RESERVED_6 = 6 { name = "Reserved 6"; desc = "reserved"; };
            RESERVED_7 = 7 { name = "Reserved 7"; desc = "reserved"; };
        };

        field {
            name = "vedu_clksel";
            desc = "VEDU clock select. Other values are reserved. This is the one CRG difference between the Hi3519 V101 and Hi3516A V200 data sheets (checked 2026-11-10): the Hi3519 V101 sheet (PERI_CRG19 bit table, dump line 5572) lists 001 = 396 MHz, 010 = 500 MHz, 011 = 594 MHz (Table 3-2: VEDU H.265 594 MHz); the Hi3516A V200 sheet (dump line 5739) lists only 001 = 396 MHz (Table 3-2: VEDU 396 MHz). Codes 2 and 3 are therefore Hi3519-only.";
            sw = rw;
            hw = r;
            encode = PERI_CRG19_vedu_clksel_enum;
            reset = 0x0;
        } vedu_clksel[12:10];

        enum PERI_CRG19_vpss_clksel_enum {
            CLK_214MHZ = 0 { name = "Clk 214Mhz"; desc = "214 MHz"; };
            CLK_300MHZ = 1 { name = "Clk 300Mhz"; desc = "300 MHz"; };
            CLK_396MHZ = 2 { name = "Clk 396Mhz"; desc = "396 MHz"; };
            RESERVED_3 = 3 { name = "Reserved 3"; desc = "reserved"; };
            RESERVED_4 = 4 { name = "Reserved 4"; desc = "reserved"; };
            RESERVED_5 = 5 { name = "Reserved 5"; desc = "reserved"; };
            RESERVED_6 = 6 { name = "Reserved 6"; desc = "reserved"; };
            RESERVED_7 = 7 { name = "Reserved 7"; desc = "reserved"; };
        };

        field {
            name = "vpss_clksel";
            desc = "VPSS clock select. Other values are reserved.";
            sw = rw;
            hw = r;
            encode = PERI_CRG19_vpss_clksel_enum;
            reset = 0x0;
        } vpss_clksel[7:5];

        enum PERI_CRG19_vi0_clksel_enum {
            CLK_214MHZ = 0 { name = "Clk 214Mhz"; desc = "214 MHz"; };
            CLK_300MHZ = 1 { name = "Clk 300Mhz"; desc = "300 MHz"; };
            CLK_500MHZ = 2 { name = "Clk 500Mhz"; desc = "500 MHz"; };
            CLK_600MHZ = 3 { name = "Clk 600Mhz"; desc = "600 MHz"; };
            CLK_340MHZ = 4 { name = "Clk 340Mhz"; desc = "340 MHz"; };
            CLK_396MHZ = 5 { name = "Clk 396Mhz"; desc = "396 MHz"; };
            RESERVED_6 = 6 { name = "Reserved 6"; desc = "reserved"; };
            RESERVED_7 = 7 { name = "Reserved 7"; desc = "reserved"; };
        };

        field {
            name = "vi0_clksel";
            desc = "VI0 clock select. Other values are reserved.";
            sw = rw;
            hw = r;
            encode = PERI_CRG19_vi0_clksel_enum;
            reset = 0x0;
        } vi0_clksel[2:0];
    } PERI_CRG19 @ 0x4C;

    reg {
        name = "VEDU clock and soft reset control register";
        desc = "PERI_CRG20 is a VEDU clock and soft reset control register.

VEDU gate and reset; reset 0x3 = clock on, module in reset.

Data sheet 3.2.7 PERI_CRG20 (offset 0x50, printed page 3-33, `hi3519v101--Hi3519V101-Datasheet.txt` line 5609).";

        enum PERI_CRG20_vedu_clken_enum {
            DISABLED = 0 { name = "Disabled"; desc = "clock disabled"; };
            ENABLED = 1 { name = "Enabled"; desc = "clock enabled"; };
        };

        field {
            name = "vedu_clken";
            desc = "VEDU clock gating";
            sw = rw;
            hw = r;
            encode = PERI_CRG20_vedu_clken_enum;
            reset = 0x1;
        } vedu_clken[1:1];

        enum PERI_CRG20_vedu_srst_req_enum {
            DEASSERT_RESET = 0 { name = "Deassert Reset"; desc = "reset deasserted"; };
            RESET = 1 { name = "Reset"; desc = "reset"; };
        };

        field {
            name = "vedu_srst_req";
            desc = "VEDU soft reset";
            sw = rw;
            hw = r;
            encode = PERI_CRG20_vedu_srst_req_enum;
            reset = 0x1;
        } vedu_srst_req[0:0];
    } PERI_CRG20 @ 0x50;

    reg {
        name = "Media CBB frequency configuration register 2";
        desc = "PERI_CRG21 is media CBB frequency configuration register 2.

ISP0/ISP1 clock selects [18:14]/[10:6] and VI1 clock select [2:0]. ISPn choices: 00000 = 214 MHz, 00001 = 300 MHz, 00010 = 340 MHz (ISP0 only), 01xxx = VIn clock, 10xxx = VIn clock divided by 2 (maximum VI0 frequency 600 MHz, VI1 300 MHz when PERI_CRG21[2:0] selects it, 600 MHz with the divider); every value is listed as an enum member.

Data sheet 3.2.7 PERI_CRG21 (offset 0x54, printed page 3-33, `hi3519v101--Hi3519V101-Datasheet.txt` line 5641).";

        enum PERI_CRG21_isp0_clksel_enum {
            CLK_214MHZ = 0x0 { name = "Clk 214Mhz"; desc = "214 MHz"; };
            CLK_300MHZ = 0x1 { name = "Clk 300Mhz"; desc = "300 MHz"; };
            CLK_340MHZ = 0x2 { name = "Clk 340Mhz"; desc = "340 MHz"; };
            RESERVED_3 = 0x3 { name = "Reserved 3"; desc = "reserved"; };
            RESERVED_4 = 0x4 { name = "Reserved 4"; desc = "reserved"; };
            RESERVED_5 = 0x5 { name = "Reserved 5"; desc = "reserved"; };
            RESERVED_6 = 0x6 { name = "Reserved 6"; desc = "reserved"; };
            RESERVED_7 = 0x7 { name = "Reserved 7"; desc = "reserved"; };
            ISP0_CLK_8 = 0x8 { name = "Isp0 Clk 8"; desc = "VI0 clock (data sheet 01xxx)"; };
            ISP0_CLK_9 = 0x9 { name = "Isp0 Clk 9"; desc = "VI0 clock (data sheet 01xxx)"; };
            ISP0_CLK_10 = 0xA { name = "Isp0 Clk 10"; desc = "VI0 clock (data sheet 01xxx)"; };
            ISP0_CLK_11 = 0xB { name = "Isp0 Clk 11"; desc = "VI0 clock (data sheet 01xxx)"; };
            ISP0_CLK_12 = 0xC { name = "Isp0 Clk 12"; desc = "VI0 clock (data sheet 01xxx)"; };
            ISP0_CLK_13 = 0xD { name = "Isp0 Clk 13"; desc = "VI0 clock (data sheet 01xxx)"; };
            ISP0_CLK_14 = 0xE { name = "Isp0 Clk 14"; desc = "VI0 clock (data sheet 01xxx)"; };
            ISP0_CLK_15 = 0xF { name = "Isp0 Clk 15"; desc = "VI0 clock (data sheet 01xxx)"; };
            ISP0_CLK_DIV2_16 = 0x10 { name = "Isp0 Clk Div2 16"; desc = "VI0 clock divided by 2 (data sheet 10xxx)"; };
            ISP0_CLK_DIV2_17 = 0x11 { name = "Isp0 Clk Div2 17"; desc = "VI0 clock divided by 2 (data sheet 10xxx)"; };
            ISP0_CLK_DIV2_18 = 0x12 { name = "Isp0 Clk Div2 18"; desc = "VI0 clock divided by 2 (data sheet 10xxx)"; };
            ISP0_CLK_DIV2_19 = 0x13 { name = "Isp0 Clk Div2 19"; desc = "VI0 clock divided by 2 (data sheet 10xxx)"; };
            ISP0_CLK_DIV2_20 = 0x14 { name = "Isp0 Clk Div2 20"; desc = "VI0 clock divided by 2 (data sheet 10xxx)"; };
            ISP0_CLK_DIV2_21 = 0x15 { name = "Isp0 Clk Div2 21"; desc = "VI0 clock divided by 2 (data sheet 10xxx)"; };
            ISP0_CLK_DIV2_22 = 0x16 { name = "Isp0 Clk Div2 22"; desc = "VI0 clock divided by 2 (data sheet 10xxx)"; };
            ISP0_CLK_DIV2_23 = 0x17 { name = "Isp0 Clk Div2 23"; desc = "VI0 clock divided by 2 (data sheet 10xxx)"; };
            RESERVED_24 = 0x18 { name = "Reserved 24"; desc = "reserved"; };
            RESERVED_25 = 0x19 { name = "Reserved 25"; desc = "reserved"; };
            RESERVED_26 = 0x1A { name = "Reserved 26"; desc = "reserved"; };
            RESERVED_27 = 0x1B { name = "Reserved 27"; desc = "reserved"; };
            RESERVED_28 = 0x1C { name = "Reserved 28"; desc = "reserved"; };
            RESERVED_29 = 0x1D { name = "Reserved 29"; desc = "reserved"; };
            RESERVED_30 = 0x1E { name = "Reserved 30"; desc = "reserved"; };
            RESERVED_31 = 0x1F { name = "Reserved 31"; desc = "reserved"; };
        };

        field {
            name = "isp0_clksel";
            desc = "ISP0 clock select (maximum 600 MHz) Other values are reserved.";
            sw = rw;
            hw = r;
            encode = PERI_CRG21_isp0_clksel_enum;
            reset = 0x0;
        } isp0_clksel[18:14];

        enum PERI_CRG21_isp1_clksel_enum {
            CLK_214MHZ = 0x0 { name = "Clk 214Mhz"; desc = "214 MHz"; };
            CLK_300MHZ = 0x1 { name = "Clk 300Mhz"; desc = "300 MHz"; };
            RESERVED_2 = 0x2 { name = "Reserved 2"; desc = "reserved"; };
            RESERVED_3 = 0x3 { name = "Reserved 3"; desc = "reserved"; };
            RESERVED_4 = 0x4 { name = "Reserved 4"; desc = "reserved"; };
            RESERVED_5 = 0x5 { name = "Reserved 5"; desc = "reserved"; };
            RESERVED_6 = 0x6 { name = "Reserved 6"; desc = "reserved"; };
            RESERVED_7 = 0x7 { name = "Reserved 7"; desc = "reserved"; };
            ISP1_CLK_8 = 0x8 { name = "Isp1 Clk 8"; desc = "VI1 clock (data sheet 01xxx)"; };
            ISP1_CLK_9 = 0x9 { name = "Isp1 Clk 9"; desc = "VI1 clock (data sheet 01xxx)"; };
            ISP1_CLK_10 = 0xA { name = "Isp1 Clk 10"; desc = "VI1 clock (data sheet 01xxx)"; };
            ISP1_CLK_11 = 0xB { name = "Isp1 Clk 11"; desc = "VI1 clock (data sheet 01xxx)"; };
            ISP1_CLK_12 = 0xC { name = "Isp1 Clk 12"; desc = "VI1 clock (data sheet 01xxx)"; };
            ISP1_CLK_13 = 0xD { name = "Isp1 Clk 13"; desc = "VI1 clock (data sheet 01xxx)"; };
            ISP1_CLK_14 = 0xE { name = "Isp1 Clk 14"; desc = "VI1 clock (data sheet 01xxx)"; };
            ISP1_CLK_15 = 0xF { name = "Isp1 Clk 15"; desc = "VI1 clock (data sheet 01xxx)"; };
            ISP1_CLK_DIV2_16 = 0x10 { name = "Isp1 Clk Div2 16"; desc = "VI1 clock divided by 2 (data sheet 10xxx)"; };
            ISP1_CLK_DIV2_17 = 0x11 { name = "Isp1 Clk Div2 17"; desc = "VI1 clock divided by 2 (data sheet 10xxx)"; };
            ISP1_CLK_DIV2_18 = 0x12 { name = "Isp1 Clk Div2 18"; desc = "VI1 clock divided by 2 (data sheet 10xxx)"; };
            ISP1_CLK_DIV2_19 = 0x13 { name = "Isp1 Clk Div2 19"; desc = "VI1 clock divided by 2 (data sheet 10xxx)"; };
            ISP1_CLK_DIV2_20 = 0x14 { name = "Isp1 Clk Div2 20"; desc = "VI1 clock divided by 2 (data sheet 10xxx)"; };
            ISP1_CLK_DIV2_21 = 0x15 { name = "Isp1 Clk Div2 21"; desc = "VI1 clock divided by 2 (data sheet 10xxx)"; };
            ISP1_CLK_DIV2_22 = 0x16 { name = "Isp1 Clk Div2 22"; desc = "VI1 clock divided by 2 (data sheet 10xxx)"; };
            ISP1_CLK_DIV2_23 = 0x17 { name = "Isp1 Clk Div2 23"; desc = "VI1 clock divided by 2 (data sheet 10xxx)"; };
            RESERVED_24 = 0x18 { name = "Reserved 24"; desc = "reserved"; };
            RESERVED_25 = 0x19 { name = "Reserved 25"; desc = "reserved"; };
            RESERVED_26 = 0x1A { name = "Reserved 26"; desc = "reserved"; };
            RESERVED_27 = 0x1B { name = "Reserved 27"; desc = "reserved"; };
            RESERVED_28 = 0x1C { name = "Reserved 28"; desc = "reserved"; };
            RESERVED_29 = 0x1D { name = "Reserved 29"; desc = "reserved"; };
            RESERVED_30 = 0x1E { name = "Reserved 30"; desc = "reserved"; };
            RESERVED_31 = 0x1F { name = "Reserved 31"; desc = "reserved"; };
        };

        field {
            name = "isp1_clksel";
            desc = "ISP1 clock select (maximum 300 MHz) Other values are reserved.";
            sw = rw;
            hw = r;
            encode = PERI_CRG21_isp1_clksel_enum;
            reset = 0x0;
        } isp1_clksel[10:6];

        enum PERI_CRG21_vi1_clksel_enum {
            CLK_214MHZ = 0 { name = "Clk 214Mhz"; desc = "214 MHz"; };
            CLK_300MHZ = 1 { name = "Clk 300Mhz"; desc = "300 MHz"; };
            CLK_500MHZ = 2 { name = "Clk 500Mhz"; desc = "500 MHz"; };
            CLK_600MHZ = 3 { name = "Clk 600Mhz"; desc = "600 MHz"; };
            CLK_340MHZ = 4 { name = "Clk 340Mhz"; desc = "340 MHz"; };
            CLK_396MHZ = 5 { name = "Clk 396Mhz"; desc = "396 MHz"; };
            RESERVED_6 = 6 { name = "Reserved 6"; desc = "reserved"; };
            RESERVED_7 = 7 { name = "Reserved 7"; desc = "reserved"; };
        };

        field {
            name = "vi1_clksel";
            desc = "VI1 clock select. Other values are reserved.";
            sw = rw;
            hw = r;
            encode = PERI_CRG21_vi1_clksel_enum;
            reset = 0x0;
        } vi1_clksel[2:0];
    } PERI_CRG21 @ 0x54;

    reg {
        name = "LCD clock configuration register";
        desc = "PERI_CRG22 is a VPSS clock and soft reset control register.

VPSS gate and reset. The description block of this register prints `Offset Address 0x0048` (dump line 5886), which is PERI_CRG18's offset (LCD, dump line 5661); the summary table (dump line 4638) puts PERI_CRG22 at 0x58, which follows the sequence of PERI_CRG20/21/23 and is used here (DS typo).

Data sheet 3.2.7 PERI_CRG22 (offset 0x58, printed page 3-35, `hi3519v101--Hi3519V101-Datasheet.txt` line 5720).";

        enum PERI_CRG22_vpss_clken_enum {
            DISABLED = 0 { name = "Disabled"; desc = "clock disabled"; };
            ENABLED = 1 { name = "Enabled"; desc = "clock enabled"; };
        };

        field {
            name = "vpss_clken";
            desc = "VPSS clock gating";
            sw = rw;
            hw = r;
            encode = PERI_CRG22_vpss_clken_enum;
            reset = 0x1;
        } vpss_clken[1:1];

        enum PERI_CRG22_vpss_srst_req_enum {
            DEASSERT_RESET = 0 { name = "Deassert Reset"; desc = "reset deasserted"; };
            RESET = 1 { name = "Reset"; desc = "reset"; };
        };

        field {
            name = "vpss_srst_req";
            desc = "VPSS soft reset";
            sw = rw;
            hw = r;
            encode = PERI_CRG22_vpss_srst_req_enum;
            reset = 0x1;
        } vpss_srst_req[0:0];
    } PERI_CRG22 @ 0x58;

    reg {
        name = "VGS clock and soft reset control register";
        desc = "PERI_CRG23 is a VGS clock and soft reset control register.

Data sheet 3.2.7 PERI_CRG23 (offset 0x5C, printed page 3-35, `hi3519v101--Hi3519V101-Datasheet.txt` line 5752).";

        enum PERI_CRG23_vgs_clken_enum {
            DISABLED = 0 { name = "Disabled"; desc = "clock disabled"; };
            ENABLED = 1 { name = "Enabled"; desc = "clock enabled"; };
        };

        field {
            name = "vgs_clken";
            desc = "VGS clock gating";
            sw = rw;
            hw = r;
            encode = PERI_CRG23_vgs_clken_enum;
            reset = 0x0;
        } vgs_clken[1:1];

        enum PERI_CRG23_vgs_srst_req_enum {
            DEASSERT_RESET = 0 { name = "Deassert Reset"; desc = "reset deasserted"; };
            RESET = 1 { name = "Reset"; desc = "reset"; };
        };

        field {
            name = "vgs_srst_req";
            desc = "VGS soft reset";
            sw = rw;
            hw = r;
            encode = PERI_CRG23_vgs_srst_req_enum;
            reset = 0x0;
        } vgs_srst_req[0:0];
    } PERI_CRG23 @ 0x5C;

    reg {
        name = "JPGE clock and soft reset control register";
        desc = "PERI_CRG24 is a JPGE clock and soft reset control register.

Data sheet 3.2.7 PERI_CRG24 (offset 0x60, printed page 3-36, `hi3519v101--Hi3519V101-Datasheet.txt` line 5794).";

        enum PERI_CRG24_jpge_clken_enum {
            DISABLED = 0 { name = "Disabled"; desc = "clock disabled"; };
            ENABLED = 1 { name = "Enabled"; desc = "clock enabled"; };
        };

        field {
            name = "jpge_clken";
            desc = "JPGE clock gating";
            sw = rw;
            hw = r;
            encode = PERI_CRG24_jpge_clken_enum;
            reset = 0x0;
        } jpge_clken[1:1];

        enum PERI_CRG24_jpge_srst_req_enum {
            DEASSERT_RESET = 0 { name = "Deassert Reset"; desc = "reset deasserted"; };
            RESET = 1 { name = "Reset"; desc = "reset"; };
        };

        field {
            name = "jpge_srst_req";
            desc = "JPGE soft reset";
            sw = rw;
            hw = r;
            encode = PERI_CRG24_jpge_srst_req_enum;
            reset = 0x0;
        } jpge_srst_req[0:0];
    } PERI_CRG24 @ 0x60;

    reg {
        name = "TDE clock and soft reset control register";
        desc = "PERI_CRG25 is a TDE clock and soft reset control register.

Data sheet 3.2.7 PERI_CRG25 (offset 0x64, printed page 3-37, `hi3519v101--Hi3519V101-Datasheet.txt` line 5836).";

        enum PERI_CRG25_tde_clken_enum {
            DISABLED = 0 { name = "Disabled"; desc = "clock disabled"; };
            ENABLED = 1 { name = "Enabled"; desc = "clock enabled"; };
        };

        field {
            name = "tde_clken";
            desc = "TDE clock gating";
            sw = rw;
            hw = r;
            encode = PERI_CRG25_tde_clken_enum;
            reset = 0x0;
        } tde_clken[1:1];

        enum PERI_CRG25_tde_srst_req_enum {
            DEASSERT_RESET = 0 { name = "Deassert Reset"; desc = "reset deasserted"; };
            RESET = 1 { name = "Reset"; desc = "reset"; };
        };

        field {
            name = "tde_srst_req";
            desc = "TDE soft reset";
            sw = rw;
            hw = r;
            encode = PERI_CRG25_tde_srst_req_enum;
            reset = 0x0;
        } tde_srst_req[0:0];
    } PERI_CRG25 @ 0x64;

    reg {
        name = "IVE clock and soft reset control register";
        desc = "PERI_CRG27 is an IVE clock and soft reset control register.

Data sheet 3.2.7 PERI_CRG27 (offset 0x6C, printed page 3-37, `hi3519v101--Hi3519V101-Datasheet.txt` line 5868).";

        enum PERI_CRG27_ive_clken_enum {
            DISABLED = 0 { name = "Disabled"; desc = "clock disabled"; };
            ENABLED = 1 { name = "Enabled"; desc = "clock enabled"; };
        };

        field {
            name = "ive_clken";
            desc = "IVE clock gating";
            sw = rw;
            hw = r;
            encode = PERI_CRG27_ive_clken_enum;
            reset = 0x0;
        } ive_clken[1:1];

        enum PERI_CRG27_ive_srst_req_enum {
            DEASSERT_RESET = 0 { name = "Deassert Reset"; desc = "reset deasserted"; };
            RESET = 1 { name = "Reset"; desc = "reset"; };
        };

        field {
            name = "ive_srst_req";
            desc = "IVE soft reset";
            sw = rw;
            hw = r;
            encode = PERI_CRG27_ive_srst_req_enum;
            reset = 0x0;
        } ive_srst_req[0:0];
    } PERI_CRG27 @ 0x6C;

    reg {
        name = "GDC clock and soft reset control register";
        desc = "PERI_CRG29 is a GDC clock and soft reset control register.

Data sheet 3.2.7 PERI_CRG29 (offset 0x74, printed page 3-38, `hi3519v101--Hi3519V101-Datasheet.txt` line 5911).";

        enum PERI_CRG29_gdc_clken_enum {
            DISABLED = 0 { name = "Disabled"; desc = "clock disabled"; };
            ENABLED = 1 { name = "Enabled"; desc = "clock enabled"; };
        };

        field {
            name = "gdc_clken";
            desc = "GDC clock gating";
            sw = rw;
            hw = r;
            encode = PERI_CRG29_gdc_clken_enum;
            reset = 0x0;
        } gdc_clken[1:1];

        enum PERI_CRG29_gdc_srst_req_enum {
            DEASSERT_RESET = 0 { name = "Deassert Reset"; desc = "reset deasserted"; };
            RESET = 1 { name = "Reset"; desc = "reset"; };
        };

        field {
            name = "gdc_srst_req";
            desc = "GDC soft reset";
            sw = rw;
            hw = r;
            encode = PERI_CRG29_gdc_srst_req_enum;
            reset = 0x0;
        } gdc_srst_req[0:0];
    } PERI_CRG29 @ 0x74;

    reg {
        name = "Hash/LSADC/Cipher clock and soft reset control register";
        desc = "PERI_CRG31 is a hash/LSADC/cipher clock and soft reset control register.

Hash, LSADC and cipher clock/reset; ca_clksel [6] selects the cipher clock (198/250 MHz).

Data sheet 3.2.7 PERI_CRG31 (offset 0x7C, printed page 3-39, `hi3519v101--Hi3519V101-Datasheet.txt` line 5953).";

        enum PERI_CRG31_ca_clksel_enum {
            CLK_198MHZ = 0 { name = "Clk 198Mhz"; desc = "198 MHz"; };
            CLK_250MHZ = 1 { name = "Clk 250Mhz"; desc = "250 MHz"; };
        };

        field {
            name = "ca_clksel";
            desc = "Cipher clock select";
            sw = rw;
            hw = r;
            encode = PERI_CRG31_ca_clksel_enum;
            reset = 0x0;
        } ca_clksel[6:6];

        enum PERI_CRG31_hash_clken_enum {
            DISABLED = 0 { name = "Disabled"; desc = "clock disabled"; };
            ENABLED = 1 { name = "Enabled"; desc = "clock enabled"; };
        };

        field {
            name = "hash_clken";
            desc = "Hash clock gating";
            sw = rw;
            hw = r;
            encode = PERI_CRG31_hash_clken_enum;
            reset = 0x0;
        } hash_clken[5:5];

        enum PERI_CRG31_hash_srst_req_enum {
            DEASSERT_RESET = 0 { name = "Deassert Reset"; desc = "reset deasserted"; };
            RESET = 1 { name = "Reset"; desc = "reset"; };
        };

        field {
            name = "hash_srst_req";
            desc = "HASH soft reset";
            sw = rw;
            hw = r;
            encode = PERI_CRG31_hash_srst_req_enum;
            reset = 0x0;
        } hash_srst_req[4:4];

        enum PERI_CRG31_lsadc_clken_enum {
            DISABLED = 0 { name = "Disabled"; desc = "clock disabled"; };
            ENABLED = 1 { name = "Enabled"; desc = "clock enabled"; };
        };

        field {
            name = "lsadc_clken";
            desc = "LSADC clock gating";
            sw = rw;
            hw = r;
            encode = PERI_CRG31_lsadc_clken_enum;
            reset = 0x0;
        } lsadc_clken[3:3];

        enum PERI_CRG31_lsadc_srst_req_enum {
            DEASSERT_RESET = 0 { name = "Deassert Reset"; desc = "reset deasserted"; };
            RESET = 1 { name = "Reset"; desc = "reset"; };
        };

        field {
            name = "lsadc_srst_req";
            desc = "LSADC soft reset";
            sw = rw;
            hw = r;
            encode = PERI_CRG31_lsadc_srst_req_enum;
            reset = 0x0;
        } lsadc_srst_req[2:2];

        enum PERI_CRG31_cipher_clken_enum {
            DISABLED = 0 { name = "Disabled"; desc = "clock disabled"; };
            ENABLED = 1 { name = "Enabled"; desc = "clock enabled"; };
        };

        field {
            name = "cipher_clken";
            desc = "Cipher clock gating";
            sw = rw;
            hw = r;
            encode = PERI_CRG31_cipher_clken_enum;
            reset = 0x0;
        } cipher_clken[1:1];

        enum PERI_CRG31_cipher_srst_req_enum {
            DEASSERT_RESET = 0 { name = "Deassert Reset"; desc = "reset deasserted"; };
            RESET = 1 { name = "Reset"; desc = "reset"; };
        };

        field {
            name = "cipher_srst_req";
            desc = "Cipher soft reset";
            sw = rw;
            hw = r;
            encode = PERI_CRG31_cipher_srst_req_enum;
            reset = 0x0;
        } cipher_srst_req[0:0];
    } PERI_CRG31 @ 0x7C;

    reg {
        name = "AIAO clock reset control register";
        desc = "PERI_CRG32 is an AIAO clock reset control register.

AIAO clock/reset; aiao_clksel [3:2] selects the PLL used for the AIAO MCLK (1188 MHz VPLL VCO or 1500 MHz EPLL VCO); the actual working clock is a division of it.

Data sheet 3.2.7 PERI_CRG32 (offset 0x80, printed page 3-40, `hi3519v101--Hi3519V101-Datasheet.txt` line 6011).";

        enum PERI_CRG32_aiao_clksel_enum {
            CLK_1188MHZ = 0 { name = "Clk 1188Mhz"; desc = "1188 MHz"; };
            CLK_1500MHZ = 1 { name = "Clk 1500Mhz"; desc = "1500 MHz"; };
            RESERVED_2 = 2 { name = "Reserved 2"; desc = "reserved"; };
            RESERVED_3 = 3 { name = "Reserved 3"; desc = "reserved"; };
        };

        field {
            name = "aiao_clksel";
            desc = "AIAO MCLK PLL clock source select. Other values are reserved.";
            sw = rw;
            hw = r;
            encode = PERI_CRG32_aiao_clksel_enum;
            reset = 0x0;
        } aiao_clksel[3:2];

        enum PERI_CRG32_aiao_clken_enum {
            DISABLED = 0 { name = "Disabled"; desc = "clock disabled"; };
            ENABLED = 1 { name = "Enabled"; desc = "clock enabled"; };
        };

        field {
            name = "aiao_clken";
            desc = "AIAO bus clock gating";
            sw = rw;
            hw = r;
            encode = PERI_CRG32_aiao_clken_enum;
            reset = 0x0;
        } aiao_clken[1:1];

        enum PERI_CRG32_aiao_srst_req_enum {
            DEASSERT_RESET = 0 { name = "Deassert Reset"; desc = "reset deasserted"; };
            RESET = 1 { name = "Reset"; desc = "reset"; };
        };

        field {
            name = "aiao_srst_req";
            desc = "AIAO bus soft reset";
            sw = rw;
            hw = r;
            encode = PERI_CRG32_aiao_srst_req_enum;
            reset = 0x0;
        } aiao_srst_req[0:0];
    } PERI_CRG32 @ 0x80;

    reg {
        name = "GZIP clock and soft reset control register";
        desc = "PERI_CRG33 is a GZIP clock and soft reset control register.

Data sheet 3.2.7 PERI_CRG33 (offset 0x84, printed page 3-41, `hi3519v101--Hi3519V101-Datasheet.txt` line 6058).";

        enum PERI_CRG33_gzip_clken_enum {
            DISABLED = 0 { name = "Disabled"; desc = "clock disabled"; };
            ENABLED = 1 { name = "Enabled"; desc = "clock enabled"; };
        };

        field {
            name = "gzip_clken";
            desc = "GZIP clock gating";
            sw = rw;
            hw = r;
            encode = PERI_CRG33_gzip_clken_enum;
            reset = 0x1;
        } gzip_clken[1:1];

        enum PERI_CRG33_gzip_srst_req_enum {
            DEASSERT_RESET = 0 { name = "Deassert Reset"; desc = "reset deasserted"; };
            RESET = 1 { name = "Reset"; desc = "reset"; };
        };

        field {
            name = "gzip_srst_req";
            desc = "GZIP soft reset";
            sw = rw;
            hw = r;
            encode = PERI_CRG33_gzip_srst_req_enum;
            reset = 0x0;
        } gzip_srst_req[0:0];
    } PERI_CRG33 @ 0x84;

    reg {
        name = "COMB PHY clock reset control register";
        desc = "PERI_CRG43 is a COMB PHY clock reset control register.

COMB PHY (PCIe/USB 3.0 shared PHY) clock and reset. The vendor U-Boot (board/hi3519v101/board.c set_pcie_para) clears combphy_srst_req (bit 0) and sets combphy_srst_req_sel (bit 1) in PERI_CRG43 (offset 0xAC, platform.h PERI_CRG43) before writing the PHY test registers in MISC_CTRL33.

Data sheet 3.2.7 PERI_CRG43 (offset 0xAC, printed page 3-41, `hi3519v101--Hi3519V101-Datasheet.txt` line 6090).";

        enum PERI_CRG43_combphy_refclk_sel_enum {
            CLK_100MHZ = 0 { name = "Clk 100Mhz"; desc = "100 MHz clock"; };
            CLK_25MHZ = 1 { name = "Clk 25Mhz"; desc = "25 MHz clock"; };
        };

        field {
            name = "combphy_refclk_sel";
            desc = "Internal clock source select for the COMB PHY reference clock";
            sw = rw;
            hw = r;
            encode = PERI_CRG43_combphy_refclk_sel_enum;
            reset = 0x0;
        } combphy_refclk_sel[9:9];

        enum PERI_CRG43_combphy_ref_clken_enum {
            DISABLED = 0 { name = "Disabled"; desc = "clock disabled"; };
            ENABLED = 1 { name = "Enabled"; desc = "clock enabled"; };
        };

        field {
            name = "combphy_ref_clken";
            desc = "COMB PHY reference clock gating (the same for PCIe mode and USB mode)";
            sw = rw;
            hw = r;
            encode = PERI_CRG43_combphy_ref_clken_enum;
            reset = 0x1;
        } combphy_ref_clken[8:8];

        enum PERI_CRG43_combphy_srst_req_sel_enum {
            RESERVED_0 = 0 { name = "Reserved 0"; desc = "reserved"; };
            SOFT_RESET_MODE = 1 { name = "Soft Reset Mode"; desc = "The soft reset mode is controlled by PERI_CRG43 bit[0]."; };
        };

        field {
            name = "combphy_srst_req_sel";
            desc = "Soft reset mode for the COMB PHY port (This bit needs to be set to 1 before working.)";
            sw = rw;
            hw = r;
            encode = PERI_CRG43_combphy_srst_req_sel_enum;
            reset = 0x0;
        } combphy_srst_req_sel[1:1];

        enum PERI_CRG43_combphy_srst_req_enum {
            DEASSERT_RESET = 0 { name = "Deassert Reset"; desc = "reset deasserted"; };
            RESET = 1 { name = "Reset"; desc = "reset"; };
        };

        field {
            name = "combphy_srst_req";
            desc = "Soft reset for the COMB PHY port";
            sw = rw;
            hw = r;
            encode = PERI_CRG43_combphy_srst_req_enum;
            reset = 0x1;
        } combphy_srst_req[0:0];
    } PERI_CRG43 @ 0xAC;

    reg {
        name = "PCIe CTRL clock and soft reset control register";
        desc = "PERI_CRG44 is a PCIe CTRL clock and soft reset control register.

PCIe controller gates and resets; reset 0xF0 = AUX/PIPE/SYS/BUS clocks on, controller not in reset.

Data sheet 3.2.7 PERI_CRG44 (offset 0xB0, printed page 3-42, `hi3519v101--Hi3519V101-Datasheet.txt` line 6148).";

        enum PERI_CRG44_pcie_pad_oe_enum {
            ENABLED = 0 { name = "Enabled"; desc = "PAD OE control is forcibly enabled."; };
            DISABLED = 1 { name = "Disabled"; desc = "PAD OE control is forcibly disabled."; };
            RESERVED_2 = 2 { name = "Reserved 2"; desc = "reserved"; };
            RESERVED_3 = 3 { name = "Reserved 3"; desc = "reserved"; };
            RESERVED_4 = 4 { name = "Reserved 4"; desc = "reserved"; };
            RESERVED_5 = 5 { name = "Reserved 5"; desc = "reserved"; };
            RESERVED_6 = 6 { name = "Reserved 6"; desc = "reserved"; };
            RESERVED_7 = 7 { name = "Reserved 7"; desc = "reserved"; };
        };

        field {
            name = "pcie_pad_oe";
            desc = "PAD OE control mode for the PCIe output differential clock. Other values are reserved.";
            sw = rw;
            hw = r;
            encode = PERI_CRG44_pcie_pad_oe_enum;
            reset = 0x0;
        } pcie_pad_oe[10:8];

        enum PERI_CRG44_pcie_aux_clken_enum {
            DISABLED = 0 { name = "Disabled"; desc = "clock disabled"; };
            ENABLED = 1 { name = "Enabled"; desc = "clock enabled"; };
        };

        field {
            name = "pcie_aux_clken";
            desc = "PCIe CTRL AUX clock gating";
            sw = rw;
            hw = r;
            encode = PERI_CRG44_pcie_aux_clken_enum;
            reset = 0x1;
        } pcie_aux_clken[7:7];

        enum PERI_CRG44_pcie_pipe_clken_enum {
            DISABLED = 0 { name = "Disabled"; desc = "clock disabled"; };
            ENABLED = 1 { name = "Enabled"; desc = "clock enabled"; };
        };

        field {
            name = "pcie_pipe_clken";
            desc = "PCIe CTRL PIPE clock gating";
            sw = rw;
            hw = r;
            encode = PERI_CRG44_pcie_pipe_clken_enum;
            reset = 0x1;
        } pcie_pipe_clken[6:6];

        enum PERI_CRG44_pcie_sys_clken_enum {
            DISABLED = 0 { name = "Disabled"; desc = "clock disabled"; };
            ENABLED = 1 { name = "Enabled"; desc = "clock enabled"; };
        };

        field {
            name = "pcie_sys_clken";
            desc = "PCIe CTRL SYS clock gating";
            sw = rw;
            hw = r;
            encode = PERI_CRG44_pcie_sys_clken_enum;
            reset = 0x1;
        } pcie_sys_clken[5:5];

        enum PERI_CRG44_pcie_bus_clken_enum {
            DISABLED = 0 { name = "Disabled"; desc = "clock disabled"; };
            ENABLED = 1 { name = "Enabled"; desc = "clock enabled"; };
        };

        field {
            name = "pcie_bus_clken";
            desc = "PCIe CTRL bus clock gating";
            sw = rw;
            hw = r;
            encode = PERI_CRG44_pcie_bus_clken_enum;
            reset = 0x1;
        } pcie_bus_clken[4:4];

        enum PERI_CRG44_pcie_srst_req_enum {
            DEASSERT_RESET = 0 { name = "Deassert Reset"; desc = "reset deasserted"; };
            RESET = 1 { name = "Reset"; desc = "reset"; };
        };

        field {
            name = "pcie_srst_req";
            desc = "PCIe CTRL soft reset";
            sw = rw;
            hw = r;
            encode = PERI_CRG44_pcie_srst_req_enum;
            reset = 0x0;
        } pcie_srst_req[2:2];

        enum PERI_CRG44_pcie_sys_srst_req_enum {
            DEASSERT_RESET = 0 { name = "Deassert Reset"; desc = "reset deasserted"; };
            RESET = 1 { name = "Reset"; desc = "reset"; };
        };

        field {
            name = "pcie_sys_srst_req";
            desc = "PCIe CTRL SYS soft reset";
            sw = rw;
            hw = r;
            encode = PERI_CRG44_pcie_sys_srst_req_enum;
            reset = 0x0;
        } pcie_sys_srst_req[1:1];

        enum PERI_CRG44_pcie_bus_srst_req_enum {
            DEASSERT_RESET = 0 { name = "Deassert Reset"; desc = "reset deasserted"; };
            RESET = 1 { name = "Reset"; desc = "reset"; };
        };

        field {
            name = "pcie_bus_srst_req";
            desc = "PCIe CTRL bus soft reset";
            sw = rw;
            hw = r;
            encode = PERI_CRG44_pcie_bus_srst_req_enum;
            reset = 0x0;
        } pcie_bus_srst_req[0:0];
    } PERI_CRG44 @ 0xB0;

    reg {
        name = "USB 2.0 clock and soft reset control register";
        desc = "PERI_CRG45 is a USB 2.0 clock and soft reset control register.

USB 2.0 clock and reset. The header reset 0x0000_00FF has the reserved bits 6 and 3 set (modelled as reserved_nz fields); reset 1 on the controller/PHY reset bits means everything starts in reset and the PHY reference clock is on.

Data sheet 3.2.7 PERI_CRG45 (offset 0xB4, printed page 3-44, `hi3519v101--Hi3519V101-Datasheet.txt` line 6223).";

        enum PERI_CRG45_usb2_device_ctrl_srst_req_enum {
            DEASSERT_RESET = 0 { name = "Deassert Reset"; desc = "reset deasserted"; };
            RESET = 1 { name = "Reset"; desc = "reset"; };
        };

        field {
            name = "usb2_device_ctrl_srst_req";
            desc = "Soft reset on USB2.0 device controller.";
            sw = rw;
            hw = r;
            encode = PERI_CRG45_usb2_device_ctrl_srst_req_enum;
            reset = 0x0;
        } usb2_device_ctrl_srst_req[8:8];

        enum PERI_CRG45_usb2_clken_enum {
            DISABLED = 0 { name = "Disabled"; desc = "disabled"; };
            ENABLED = 1 { name = "Enabled"; desc = "enabled"; };
        };

        field {
            name = "usb2_clken";
            desc = "Clock gating of the USB2.0 PHY reference clock";
            sw = rw;
            hw = r;
            encode = PERI_CRG45_usb2_clken_enum;
            reset = 0x1;
        } usb2_clken[7:7];

        field {
            name = "reserved_nz_6_6";
            desc = "Reserved in the bit table, but the data sheet total reset value of this register has these bits set (reset 0x1).";
            sw = r;
            hw = w;
            reset = 0x1;
        } reserved_nz_6_6[6:6];

        enum PERI_CRG45_usb2_ctrl_utmi_req_enum {
            DEASSERT_RESET = 0 { name = "Deassert Reset"; desc = "reset deasserted"; };
            RESET = 1 { name = "Reset"; desc = "reset"; };
        };

        field {
            name = "usb2_ctrl_utmi_req";
            desc = "Soft reset on USB2.0 controller";
            sw = rw;
            hw = r;
            encode = PERI_CRG45_usb2_ctrl_utmi_req_enum;
            reset = 0x1;
        } usb2_ctrl_utmi_req[5:5];

        enum PERI_CRG45_usb2_ctrl_hub_req_enum {
            DEASSERT_RESET = 0 { name = "Deassert Reset"; desc = "reset deasserted"; };
            RESET = 1 { name = "Reset"; desc = "reset"; };
        };

        field {
            name = "usb2_ctrl_hub_req";
            desc = "Soft reset on USB2.0 controller hub";
            sw = rw;
            hw = r;
            encode = PERI_CRG45_usb2_ctrl_hub_req_enum;
            reset = 0x1;
        } usb2_ctrl_hub_req[4:4];

        field {
            name = "reserved_nz_3_3";
            desc = "Reserved in the bit table, but the data sheet total reset value of this register has these bits set (reset 0x1).";
            sw = r;
            hw = w;
            reset = 0x1;
        } reserved_nz_3_3[3:3];

        enum PERI_CRG45_usb2_phy_port_treq_enum {
            DEASSERT_RESET = 0 { name = "Deassert Reset"; desc = "reset deasserted"; };
            RESET = 1 { name = "Reset"; desc = "reset"; };
        };

        field {
            name = "usb2_phy_port_treq";
            desc = "Soft reset on USB2.0 PHY";
            sw = rw;
            hw = r;
            encode = PERI_CRG45_usb2_phy_port_treq_enum;
            reset = 0x1;
        } usb2_phy_port_treq[2:2];

        enum PERI_CRG45_usb2_phy_req_enum {
            DEASSERT_RESET = 0 { name = "Deassert Reset"; desc = "reset deasserted"; };
            RESET = 1 { name = "Reset"; desc = "reset"; };
        };

        field {
            name = "usb2_phy_req";
            desc = "Soft reset on USB2.0 PHY.";
            sw = rw;
            hw = r;
            encode = PERI_CRG45_usb2_phy_req_enum;
            reset = 0x1;
        } usb2_phy_req[1:1];

        enum PERI_CRG45_usb2_hrst_req_enum {
            DEASSERT_RESET = 0 { name = "Deassert Reset"; desc = "reset deasserted"; };
            RESET = 1 { name = "Reset"; desc = "reset"; };
        };

        field {
            name = "usb2_hrst_req";
            desc = "Soft reset on the USB2.0 controller bus.";
            sw = rw;
            hw = r;
            encode = PERI_CRG45_usb2_hrst_req_enum;
            reset = 0x1;
        } usb2_hrst_req[0:0];
    } PERI_CRG45 @ 0xB4;

    reg {
        name = "USB 3.0 CTRL clock and soft reset control register";
        desc = "PERI_CRG46 is a USB 3.0 CTRL clock and soft reset control register.

USB 3.0 controller clock and reset. usb3_utmi_clksel [13] chooses the UTMI clock (0: the USB 2.0 PHY clock, 1: internal 60 MHz clock, reset).

Data sheet 3.2.7 PERI_CRG46 (offset 0xB8, printed page 3-45, `hi3519v101--Hi3519V101-Datasheet.txt` line 6285).";

        enum PERI_CRG46_usb3_utmi_clksel_enum {
            USB2_PHY_CLK = 0 { name = "Usb2 Phy Clk"; desc = "the USB 2.0 PHY clock is selected"; };
            INTERNAL_60MHZ = 1 { name = "Internal 60Mhz"; desc = "the internal 60 MHz clock is selected"; };
        };

        field {
            name = "usb3_utmi_clksel";
            desc = "USB 3.0 UTMI clock source select";
            sw = rw;
            hw = r;
            encode = PERI_CRG46_usb3_utmi_clksel_enum;
            reset = 0x1;
        } usb3_utmi_clksel[13:13];

        enum PERI_CRG46_usb3_utmi_clken_enum {
            DISABLED = 0 { name = "Disabled"; desc = "clock disabled"; };
            ENABLED = 1 { name = "Enabled"; desc = "clock enabled"; };
        };

        field {
            name = "usb3_utmi_clken";
            desc = "USB 3.0 controller UTMI clock gating";
            sw = rw;
            hw = r;
            encode = PERI_CRG46_usb3_utmi_clken_enum;
            reset = 0x1;
        } usb3_utmi_clken[12:12];

        enum PERI_CRG46_usb3_pipe_clken_enum {
            DISABLED = 0 { name = "Disabled"; desc = "clock disabled"; };
            ENABLED = 1 { name = "Enabled"; desc = "clock enabled"; };
        };

        field {
            name = "usb3_pipe_clken";
            desc = "USB 3.0 controller PIPE clock gating";
            sw = rw;
            hw = r;
            encode = PERI_CRG46_usb3_pipe_clken_enum;
            reset = 0x1;
        } usb3_pipe_clken[11:11];

        enum PERI_CRG46_usb3_suspend_clken_enum {
            DISABLED = 0 { name = "Disabled"; desc = "clock disabled"; };
            ENABLED = 1 { name = "Enabled"; desc = "clock enabled"; };
        };

        field {
            name = "usb3_suspend_clken";
            desc = "USB 3.0 controller suspend clock gating";
            sw = rw;
            hw = r;
            encode = PERI_CRG46_usb3_suspend_clken_enum;
            reset = 0x1;
        } usb3_suspend_clken[10:10];

        enum PERI_CRG46_usb3_ref_clken_enum {
            DISABLED = 0 { name = "Disabled"; desc = "clock disabled"; };
            ENABLED = 1 { name = "Enabled"; desc = "clock enabled"; };
        };

        field {
            name = "usb3_ref_clken";
            desc = "USB 3.0 controller REF clock gating";
            sw = rw;
            hw = r;
            encode = PERI_CRG46_usb3_ref_clken_enum;
            reset = 0x1;
        } usb3_ref_clken[9:9];

        enum PERI_CRG46_usb3_bus_clken_enum {
            DISABLED = 0 { name = "Disabled"; desc = "clock disabled"; };
            ENABLED = 1 { name = "Enabled"; desc = "clock enabled"; };
        };

        field {
            name = "usb3_bus_clken";
            desc = "USB 3.0 controller bus clock gating";
            sw = rw;
            hw = r;
            encode = PERI_CRG46_usb3_bus_clken_enum;
            reset = 0x1;
        } usb3_bus_clken[8:8];

        enum PERI_CRG46_usb3_vcc_srst_req_enum {
            DEASSERT_RESET = 0 { name = "Deassert Reset"; desc = "reset deasserted"; };
            RESET = 1 { name = "Reset"; desc = "reset"; };
        };

        field {
            name = "usb3_vcc_srst_req";
            desc = "Soft reset on the USB 3.0 controller VCC";
            sw = rw;
            hw = r;
            encode = PERI_CRG46_usb3_vcc_srst_req_enum;
            reset = 0x1;
        } usb3_vcc_srst_req[0:0];
    } PERI_CRG46 @ 0xB8;

    reg {
        name = "FMC clock and soft reset control register";
        desc = "PERI_CRG48 is an FMC clock and soft reset control register.

FMC (SPI NOR/NAND flash controller) clock and reset; reset 0x2 = 24 MHz, clock on, not in reset. fmc_clksel [4:2]: the vendor U-Boot (platform.h FMC_CLK_24M/75M/125M/150M/200M/250M/300M/400M = 0..7, FMC_CLK_SEL shift 2 mask 0x7) and the vendor Linux clk-hi3519.c fmc mux {24m, 75m, 125m, 150m, 200m, 250m, 300m, 400m} at 0xC0 [4:2] with a straight 0..7 table, and the gate at 0xC0 bit 1, agree with the data sheet rows (the data sheet writes 198/396 MHz for the PLL-derived 200/400 MHz clocks of its Table 3-2).

Data sheet 3.2.7 PERI_CRG48 (offset 0xC0, printed page 3-46, `hi3519v101--Hi3519V101-Datasheet.txt` line 6347).";

        enum PERI_CRG48_fmc_clksel_enum {
            CLK_24MHZ = 0 { name = "Clk 24Mhz"; desc = "24 MHz clock"; };
            CLK_75MHZ = 1 { name = "Clk 75Mhz"; desc = "75 MHz clock"; };
            CLK_125MHZ = 2 { name = "Clk 125Mhz"; desc = "125 MHz clock"; };
            CLK_150MHZ = 3 { name = "Clk 150Mhz"; desc = "150 MHz clock"; };
            CLK_198MHZ = 4 { name = "Clk 198Mhz"; desc = "198 MHz clock (for the component that supports 3.3 V I/O voltage)"; };
            CLK_250MHZ = 5 { name = "Clk 250Mhz"; desc = "250 MHz clock (available only in DDR mode)"; };
            CLK_300MHZ = 6 { name = "Clk 300Mhz"; desc = "300 MHz clock (available only in DDR mode)"; };
            CLK_396MHZ = 7 { name = "Clk 396Mhz"; desc = "396 MHz clock (available only in DDR mode)"; };
        };

        field {
            name = "fmc_clksel";
            desc = "FMC clock source select (In SDR mode, the frequency of the FMC clock output by the chip is divided by 2 and the maximum frequency of the output clock is 100 MHz. In DDR mode, the frequency of the FMC clock output by the chip is divided by 4 and the maximum frequency of the output clock is 100 MHz.)";
            sw = rw;
            hw = r;
            encode = PERI_CRG48_fmc_clksel_enum;
            reset = 0x0;
        } fmc_clksel[4:2];

        enum PERI_CRG48_fmc_clken_enum {
            DISABLED = 0 { name = "Disabled"; desc = "clock disabled"; };
            ENABLED = 1 { name = "Enabled"; desc = "clock enabled"; };
        };

        field {
            name = "fmc_clken";
            desc = "FMC clock gating";
            sw = rw;
            hw = r;
            encode = PERI_CRG48_fmc_clken_enum;
            reset = 0x1;
        } fmc_clken[1:1];

        enum PERI_CRG48_fmc_srst_req_enum {
            DEASSERT_RESET = 0 { name = "Deassert Reset"; desc = "reset deasserted"; };
            RESET = 1 { name = "Reset"; desc = "reset"; };
        };

        field {
            name = "fmc_srst_req";
            desc = "FMC soft reset";
            sw = rw;
            hw = r;
            encode = PERI_CRG48_fmc_srst_req_enum;
            reset = 0x0;
        } fmc_srst_req[0:0];
    } PERI_CRG48 @ 0xC0;

    reg {
        name = "MMC0/1/2 clock and soft reset control register";
        desc = "PERI_CRG49 is an MMC0/1/2 clock and soft reset control register.

MMC0/MMC1/MMC2 clock and reset. Header total reset 0x0002_0200 but the rows give 0x0002_0202: mmc1_clken (bit 1) resets to 1 in the rows; mmc0_clken and mmc2_clken are 1 in both. The row value is used (DS inconsistency, low confidence; no vendor code depends on it). mmc*_clk_mode must be set to 1 (divided by 8, 16-phase tuning) before use; mmc*_clksel selects the source clock (000 = 100 MHz, 001 = 198, 011 = 396, 100 = 594, 101 = 792, 111 = 1188 MHz; 010 and 110 reserved), the actual MMC clock is the source divided by 8.

Data sheet 3.2.7 PERI_CRG49 (offset 0xC4, printed page 3-47, `hi3519v101--Hi3519V101-Datasheet.txt` line 6402).";

        enum PERI_CRG49_mmc2_dll_srst_req_enum {
            DEASSERT_RESET = 0 { name = "Deassert Reset"; desc = "reset deasserted"; };
            RESET = 1 { name = "Reset"; desc = "reset"; };
        };

        field {
            name = "mmc2_dll_srst_req";
            desc = "MMC2 DLL soft reset";
            sw = rw;
            hw = r;
            encode = PERI_CRG49_mmc2_dll_srst_req_enum;
            reset = 0x0;
        } mmc2_dll_srst_req[23:23];

        enum PERI_CRG49_mmc2_dll_clken_enum {
            DISABLED = 0 { name = "Disabled"; desc = "disabled"; };
            ENABLED = 1 { name = "Enabled"; desc = "enabled"; };
        };

        field {
            name = "mmc2_dll_clken";
            desc = "MMC2 DLL clock gating";
            sw = rw;
            hw = r;
            encode = PERI_CRG49_mmc2_dll_clken_enum;
            reset = 0x0;
        } mmc2_dll_clken[22:22];

        enum PERI_CRG49_mmc2_clk_mode_enum {
            RESERVED_0 = 0 { name = "Reserved 0"; desc = "reserved"; };
            DIVIDED_8 = 1 { name = "Divided 8"; desc = "divided by 8 (corresponding to 16-phase tuning)"; };
        };

        field {
            name = "mmc2_clk_mode";
            desc = "MMC2 clock frequency division mode (This bit needs to be set to 1 before working.)";
            sw = rw;
            hw = r;
            encode = PERI_CRG49_mmc2_clk_mode_enum;
            reset = 0x0;
        } mmc2_clk_mode[21:21];

        enum PERI_CRG49_mmc2_clksel_enum {
            CLK_100MHZ = 0 { name = "Clk 100Mhz"; desc = "100 MHz"; };
            CLK_198MHZ = 1 { name = "Clk 198Mhz"; desc = "198 MHz"; };
            RESERVED_2 = 2 { name = "Reserved 2"; desc = "reserved"; };
            CLK_396MHZ = 3 { name = "Clk 396Mhz"; desc = "396 MHz"; };
            CLK_594MHZ = 4 { name = "Clk 594Mhz"; desc = "594 MHz"; };
            CLK_792MHZ = 5 { name = "Clk 792Mhz"; desc = "792 MHz"; };
            RESERVED_6 = 6 { name = "Reserved 6"; desc = "reserved"; };
            CLK_1188MHZ = 7 { name = "Clk 1188Mhz"; desc = "1188 MHz"; };
        };

        field {
            name = "mmc2_clksel";
            desc = "MMC2 clock source. The actual working clock is obtained after the frequency of the source clock is divided (the frequency division is controlled by mmc2_clk_mode).";
            sw = rw;
            hw = r;
            encode = PERI_CRG49_mmc2_clksel_enum;
            reset = 0x0;
        } mmc2_clksel[20:18];

        enum PERI_CRG49_mmc2_clken_enum {
            DISABLED = 0 { name = "Disabled"; desc = "disabled"; };
            ENABLED = 1 { name = "Enabled"; desc = "enabled"; };
        };

        field {
            name = "mmc2_clken";
            desc = "MMC2 clock gating";
            sw = rw;
            hw = r;
            encode = PERI_CRG49_mmc2_clken_enum;
            reset = 0x1;
        } mmc2_clken[17:17];

        enum PERI_CRG49_mmc2_srst_req_enum {
            DEASSERT_RESET = 0 { name = "Deassert Reset"; desc = "reset deasserted"; };
            RESET = 1 { name = "Reset"; desc = "reset"; };
        };

        field {
            name = "mmc2_srst_req";
            desc = "MMC2 soft reset";
            sw = rw;
            hw = r;
            encode = PERI_CRG49_mmc2_srst_req_enum;
            reset = 0x0;
        } mmc2_srst_req[16:16];

        enum PERI_CRG49_mmc0_clk_mode_enum {
            RESERVED_0 = 0 { name = "Reserved 0"; desc = "reserved"; };
            DIVIDED_8 = 1 { name = "Divided 8"; desc = "divided by 8 (corresponding to 16-phase tuning)"; };
        };

        field {
            name = "mmc0_clk_mode";
            desc = "MMC0 clock frequency division mode (This bit needs to be set to 1 before working.)";
            sw = rw;
            hw = r;
            encode = PERI_CRG49_mmc0_clk_mode_enum;
            reset = 0x0;
        } mmc0_clk_mode[13:13];

        enum PERI_CRG49_mmc0_clksel_enum {
            CLK_100MHZ = 0 { name = "Clk 100Mhz"; desc = "100 MHz"; };
            CLK_198MHZ = 1 { name = "Clk 198Mhz"; desc = "198 MHz"; };
            RESERVED_2 = 2 { name = "Reserved 2"; desc = "reserved"; };
            CLK_396MHZ = 3 { name = "Clk 396Mhz"; desc = "396 MHz"; };
            CLK_594MHZ = 4 { name = "Clk 594Mhz"; desc = "594 MHz"; };
            CLK_792MHZ = 5 { name = "Clk 792Mhz"; desc = "792 MHz"; };
            RESERVED_6 = 6 { name = "Reserved 6"; desc = "reserved"; };
            CLK_1188MHZ = 7 { name = "Clk 1188Mhz"; desc = "1188 MHz"; };
        };

        field {
            name = "mmc0_clksel";
            desc = "MMC0 clock source. The actual working clock is obtained after the frequency of the source clock is divided (the frequency division is controlled by mmc0_clk_mode).";
            sw = rw;
            hw = r;
            encode = PERI_CRG49_mmc0_clksel_enum;
            reset = 0x0;
        } mmc0_clksel[12:10];

        enum PERI_CRG49_mmc0_clken_enum {
            DISABLED = 0 { name = "Disabled"; desc = "disabled"; };
            ENABLED = 1 { name = "Enabled"; desc = "enabled"; };
        };

        field {
            name = "mmc0_clken";
            desc = "MMC0 clock gating";
            sw = rw;
            hw = r;
            encode = PERI_CRG49_mmc0_clken_enum;
            reset = 0x1;
        } mmc0_clken[9:9];

        enum PERI_CRG49_mmc0_srst_req_enum {
            DEASSERT_RESET = 0 { name = "Deassert Reset"; desc = "reset deasserted"; };
            RESET = 1 { name = "Reset"; desc = "reset"; };
        };

        field {
            name = "mmc0_srst_req";
            desc = "MMC0 soft reset";
            sw = rw;
            hw = r;
            encode = PERI_CRG49_mmc0_srst_req_enum;
            reset = 0x0;
        } mmc0_srst_req[8:8];

        enum PERI_CRG49_mmc1_clk_mode_enum {
            RESERVED_0 = 0 { name = "Reserved 0"; desc = "reserved"; };
            DIVIDED_8 = 1 { name = "Divided 8"; desc = "divided by 8 (corresponding to 16-phase tuning)"; };
        };

        field {
            name = "mmc1_clk_mode";
            desc = "MMC1 clock frequency division mode (This bit needs to be set to 1 before working)";
            sw = rw;
            hw = r;
            encode = PERI_CRG49_mmc1_clk_mode_enum;
            reset = 0x0;
        } mmc1_clk_mode[5:5];

        enum PERI_CRG49_mmc1_clksel_enum {
            CLK_100MHZ = 0 { name = "Clk 100Mhz"; desc = "100 MHz"; };
            CLK_198MHZ = 1 { name = "Clk 198Mhz"; desc = "198 MHz"; };
            RESERVED_2 = 2 { name = "Reserved 2"; desc = "reserved"; };
            CLK_396MHZ = 3 { name = "Clk 396Mhz"; desc = "396 MHz"; };
            CLK_594MHZ = 4 { name = "Clk 594Mhz"; desc = "594 MHz"; };
            CLK_792MHZ = 5 { name = "Clk 792Mhz"; desc = "792 MHz"; };
            RESERVED_6 = 6 { name = "Reserved 6"; desc = "reserved"; };
            CLK_1188MHZ = 7 { name = "Clk 1188Mhz"; desc = "1188 MHz"; };
        };

        field {
            name = "mmc1_clksel";
            desc = "MMC1 clock source. The actual working clock is obtained after the frequency of the source clock is divided (the frequency division is controlled by mmc1_clk_mode).";
            sw = rw;
            hw = r;
            encode = PERI_CRG49_mmc1_clksel_enum;
            reset = 0x0;
        } mmc1_clksel[4:2];

        enum PERI_CRG49_mmc1_clken_enum {
            DISABLED = 0 { name = "Disabled"; desc = "disabled"; };
            ENABLED = 1 { name = "Enabled"; desc = "enabled"; };
        };

        field {
            name = "mmc1_clken";
            desc = "MMC1 clock gating";
            sw = rw;
            hw = r;
            encode = PERI_CRG49_mmc1_clken_enum;
            reset = 0x1;
        } mmc1_clken[1:1];

        enum PERI_CRG49_mmc1_srst_req_enum {
            DEASSERT_RESET = 0 { name = "Deassert Reset"; desc = "reset deasserted"; };
            RESET = 1 { name = "Reset"; desc = "reset"; };
        };

        field {
            name = "mmc1_srst_req";
            desc = "MMC1 soft reset";
            sw = rw;
            hw = r;
            encode = PERI_CRG49_mmc1_srst_req_enum;
            reset = 0x0;
        } mmc1_srst_req[0:0];
    } PERI_CRG49 @ 0xC4;

    reg {
        name = "GSF/GMAC clock and soft reset control register";
        desc = "PERI_CRG51 is a GSF/GMAC clock and soft reset control register.

GSF/GMAC clock and reset (REG_ETH_CRG = 0xCC in the vendor U-Boot platform.h; drivers/net/hisfv300/sys.c uses it). Reset 0xA = GMAC interface clock and GSF clock on.

Data sheet 3.2.7 PERI_CRG51 (offset 0xCC, printed page 3-49, `hi3519v101--Hi3519V101-Datasheet.txt` line 6524).";

        enum PERI_CRG51_ext_fephy_srst_req_enum {
            DEASSERT_RESET = 0 { name = "Deassert Reset"; desc = "reset deasserted"; };
            RESET = 1 { name = "Reset"; desc = "reset"; };
        };

        field {
            name = "ext_fephy_srst_req";
            desc = "External FE PHY soft reset";
            sw = rw;
            hw = r;
            encode = PERI_CRG51_ext_fephy_srst_req_enum;
            reset = 0x0;
        } ext_fephy_srst_req[7:7];

        enum PERI_CRG51_ext_fephy_clksel_enum {
            CLK_25MHZ = 0 { name = "Clk 25Mhz"; desc = "25 MHz clock"; };
            CLK_50MHZ = 1 { name = "Clk 50Mhz"; desc = "50 MHz clock"; };
        };

        field {
            name = "ext_fephy_clksel";
            desc = "Clock select for the external FE PHY";
            sw = rw;
            hw = r;
            encode = PERI_CRG51_ext_fephy_clksel_enum;
            reset = 0x0;
        } ext_fephy_clksel[6:6];

        enum PERI_CRG51_rmii_clksel_enum {
            CRG = 0 { name = "Crg"; desc = "CRG clock"; };
            PAD_INPUT = 1 { name = "Pad Input"; desc = "PAD input clock"; };
        };

        field {
            name = "rmii_clksel";
            desc = "RMII clock select";
            sw = rw;
            hw = r;
            encode = PERI_CRG51_rmii_clksel_enum;
            reset = 0x0;
        } rmii_clksel[4:4];

        enum PERI_CRG51_gmac_if_clken_enum {
            DISABLED = 0 { name = "Disabled"; desc = "clock disabled"; };
            ENABLED = 1 { name = "Enabled"; desc = "clock enabled"; };
        };

        field {
            name = "gmac_if_clken";
            desc = "MAC_IF clock gating";
            sw = rw;
            hw = r;
            encode = PERI_CRG51_gmac_if_clken_enum;
            reset = 0x1;
        } gmac_if_clken[3:3];

        enum PERI_CRG51_gmac_if_srst_req_enum {
            DEASSERT_RESET = 0 { name = "Deassert Reset"; desc = "reset deasserted"; };
            RESET = 1 { name = "Reset"; desc = "reset"; };
        };

        field {
            name = "gmac_if_srst_req";
            desc = "MAC_IF soft reset";
            sw = rw;
            hw = r;
            encode = PERI_CRG51_gmac_if_srst_req_enum;
            reset = 0x0;
        } gmac_if_srst_req[2:2];

        enum PERI_CRG51_gsf_clken_enum {
            DISABLED = 0 { name = "Disabled"; desc = "clock disabled"; };
            ENABLED = 1 { name = "Enabled"; desc = "clock enabled"; };
        };

        field {
            name = "gsf_clken";
            desc = "GSF clock gating";
            sw = rw;
            hw = r;
            encode = PERI_CRG51_gsf_clken_enum;
            reset = 0x1;
        } gsf_clken[1:1];

        enum PERI_CRG51_gsf_srst_req_enum {
            DEASSERT_RESET = 0 { name = "Deassert Reset"; desc = "reset deasserted"; };
            RESET = 1 { name = "Reset"; desc = "reset"; };
        };

        field {
            name = "gsf_srst_req";
            desc = "GSF soft reset";
            sw = rw;
            hw = r;
            encode = PERI_CRG51_gsf_srst_req_enum;
            reset = 0x0;
        } gsf_srst_req[0:0];
    } PERI_CRG51 @ 0xCC;

    reg {
        name = "DDRT and IO_HPM clock and soft reset control register";
        desc = "PERI_CRG54 is a DDRT and IO_HPM clock and soft reset control register.

DDRT clock/reset. The header reset 0x0000_0002 has the reserved bit 1 set (modelled as reserved_nz_1_1).

Data sheet 3.2.7 PERI_CRG54 (offset 0xD8, printed page 3-50, `hi3519v101--Hi3519V101-Datasheet.txt` line 6584).";

        enum PERI_CRG54_ddrt_clken_enum {
            DISABLED = 0 { name = "Disabled"; desc = "clock disabled"; };
            ENABLED = 1 { name = "Enabled"; desc = "clock enabled"; };
        };

        field {
            name = "ddrt_clken";
            desc = "DDRT clock gating";
            sw = rw;
            hw = r;
            encode = PERI_CRG54_ddrt_clken_enum;
            reset = 0x0;
        } ddrt_clken[3:3];

        enum PERI_CRG54_ddrt_srst_req_enum {
            DEASSERT_RESET = 0 { name = "Deassert Reset"; desc = "reset deasserted"; };
            RESET = 1 { name = "Reset"; desc = "reset"; };
        };

        field {
            name = "ddrt_srst_req";
            desc = "DDRT soft reset";
            sw = rw;
            hw = r;
            encode = PERI_CRG54_ddrt_srst_req_enum;
            reset = 0x0;
        } ddrt_srst_req[2:2];

        field {
            name = "reserved_nz_1_0";
            desc = "Reserved in the bit table, but the data sheet total reset value of this register has these bits set (reset 0x2).";
            sw = r;
            hw = w;
            reset = 0x2;
        } reserved_nz_1_0[1:0];
    } PERI_CRG54 @ 0xD8;

    reg {
        name = "PWM clock and reset control register";
        desc = "PERI_CRG55 is a PWM clock and reset control register.

PWM clock select (pwm_clksel [3:2] = 3 MHz / 50 MHz / 24 MHz), gate and reset.

Data sheet 3.2.7 PERI_CRG55 (offset 0xDC, printed page 3-51, `hi3519v101--Hi3519V101-Datasheet.txt` line 6628).";

        enum PERI_CRG55_pwm_clksel_enum {
            CLK_3MHZ = 0 { name = "Clk 3Mhz"; desc = "3 MHz clock"; };
            CLK_50MHZ = 1 { name = "Clk 50Mhz"; desc = "50 MHz clock"; };
            CLK_24MHZ = 2 { name = "Clk 24Mhz"; desc = "24 MHz clock (data sheet 1X)"; };
            CLK_24MHZ_3 = 3 { name = "Clk 24Mhz 3"; desc = "24 MHz clock (data sheet 1X)"; };
        };

        field {
            name = "pwm_clksel";
            desc = "PWM clock select";
            sw = rw;
            hw = r;
            encode = PERI_CRG55_pwm_clksel_enum;
            reset = 0x0;
        } pwm_clksel[3:2];

        enum PERI_CRG55_pwm_clken_enum {
            DISABLED = 0 { name = "Disabled"; desc = "clock disabled"; };
            ENABLED = 1 { name = "Enabled"; desc = "clock enabled"; };
        };

        field {
            name = "pwm_clken";
            desc = "PWM clock gating";
            sw = rw;
            hw = r;
            encode = PERI_CRG55_pwm_clken_enum;
            reset = 0x0;
        } pwm_clken[1:1];

        enum PERI_CRG55_pwm_srst_req_enum {
            DEASSERT_RESET = 0 { name = "Deassert Reset"; desc = "reset deasserted"; };
            RESET = 1 { name = "Reset"; desc = "reset"; };
        };

        field {
            name = "pwm_srst_req";
            desc = "PWM soft reset";
            sw = rw;
            hw = r;
            encode = PERI_CRG55_pwm_srst_req_enum;
            reset = 0x0;
        } pwm_srst_req[0:0];
    } PERI_CRG55 @ 0xDC;

    reg {
        name = "RSA/TRNG/KLAD/DMA clock and soft reset control register";
        desc = "PERI_CRG56 is an RSA/TRNG/KLAD/DMA clock and soft reset control register.

RSA, TRNG, KLAD and DMAC clock/reset; reset 0x8 = KLAD clock on.

Data sheet 3.2.7 PERI_CRG56 (offset 0xE0, printed page 3-52, `hi3519v101--Hi3519V101-Datasheet.txt` line 6674).";

        enum PERI_CRG56_rsa_clken_enum {
            DISABLED = 0 { name = "Disabled"; desc = "clock disabled"; };
            ENABLED = 1 { name = "Enabled"; desc = "clock enabled"; };
        };

        field {
            name = "rsa_clken";
            desc = "RSA clock gating";
            sw = rw;
            hw = r;
            encode = PERI_CRG56_rsa_clken_enum;
            reset = 0x0;
        } rsa_clken[7:7];

        enum PERI_CRG56_rsa_srst_req_enum {
            DEASSERT_RESET = 0 { name = "Deassert Reset"; desc = "reset deasserted"; };
            RESET = 1 { name = "Reset"; desc = "reset"; };
        };

        field {
            name = "rsa_srst_req";
            desc = "RSA soft reset";
            sw = rw;
            hw = r;
            encode = PERI_CRG56_rsa_srst_req_enum;
            reset = 0x0;
        } rsa_srst_req[6:6];

        enum PERI_CRG56_trng_clken_enum {
            DISABLED = 0 { name = "Disabled"; desc = "clock disabled"; };
            ENABLED = 1 { name = "Enabled"; desc = "clock enabled"; };
        };

        field {
            name = "trng_clken";
            desc = "TRNG clock gating";
            sw = rw;
            hw = r;
            encode = PERI_CRG56_trng_clken_enum;
            reset = 0x0;
        } trng_clken[5:5];

        enum PERI_CRG56_trng_srst_req_enum {
            DEASSERT_RESET = 0 { name = "Deassert Reset"; desc = "reset deasserted"; };
            RESET = 1 { name = "Reset"; desc = "reset"; };
        };

        field {
            name = "trng_srst_req";
            desc = "TRNG soft reset";
            sw = rw;
            hw = r;
            encode = PERI_CRG56_trng_srst_req_enum;
            reset = 0x0;
        } trng_srst_req[4:4];

        enum PERI_CRG56_klad_clken_enum {
            DISABLED = 0 { name = "Disabled"; desc = "clock disabled"; };
            ENABLED = 1 { name = "Enabled"; desc = "clock enabled"; };
        };

        field {
            name = "klad_clken";
            desc = "KLAD clock gating";
            sw = rw;
            hw = r;
            encode = PERI_CRG56_klad_clken_enum;
            reset = 0x1;
        } klad_clken[3:3];

        enum PERI_CRG56_klad_srst_req_enum {
            DEASSERT_RESET = 0 { name = "Deassert Reset"; desc = "reset deasserted"; };
            RESET = 1 { name = "Reset"; desc = "reset"; };
        };

        field {
            name = "klad_srst_req";
            desc = "KLAD soft reset";
            sw = rw;
            hw = r;
            encode = PERI_CRG56_klad_srst_req_enum;
            reset = 0x0;
        } klad_srst_req[2:2];

        enum PERI_CRG56_dmac_clken_enum {
            DISABLED = 0 { name = "Disabled"; desc = "clock disabled"; };
            ENABLED = 1 { name = "Enabled"; desc = "clock enabled"; };
        };

        field {
            name = "dmac_clken";
            desc = "DMA clock gating";
            sw = rw;
            hw = r;
            encode = PERI_CRG56_dmac_clken_enum;
            reset = 0x0;
        } dmac_clken[1:1];

        enum PERI_CRG56_dmac_srst_req_enum {
            DEASSERT_RESET = 0 { name = "Deassert Reset"; desc = "reset deasserted"; };
            RESET = 1 { name = "Reset"; desc = "reset"; };
        };

        field {
            name = "dmac_srst_req";
            desc = "DMA soft reset";
            sw = rw;
            hw = r;
            encode = PERI_CRG56_dmac_srst_req_enum;
            reset = 0x0;
        } dmac_srst_req[0:0];
    } PERI_CRG56 @ 0xE0;

    reg {
        name = "Clock soft reset control register for other APB modules";
        desc = "PERI_CRG57 is a clock soft reset control register for other APB modules.

Clock gates, clock selects and soft resets of the low-speed APB peripherals (UART0-4 gates [24:20], SSP0-3, IR, I2C0-3 and T_CAP resets, PMC reset). uart_clksel [25] (0: SYS APB clock, 1: 24 MHz, reset 1) and i2c_clksel [26] (0: SYS APB clock, 1: 50 MHz, reset 1); the vendor U-Boot (platform.h PERI_CRG57 = 0xE4, UART_CKSEL_24M = 1 << 25, board.c board_init) sets bit 25, and the vendor Linux clk-hi3519.c gates are at 0xE4 bits 16..24 (SPI0-2 on bits 16-18, UART0-4 on bits 20-24), as in the data sheet. Reset 0x0E10_0000 = uart_clksel, i2c_clksel, test_clk_en and uart0_clken set. The data sheet text of bit 27/26 and of bits 3:0 is mangled by the PDF layout; names and meaning are taken from the bit table.

Data sheet 3.2.7 PERI_CRG57 (offset 0xE4, printed page 3-53, `hi3519v101--Hi3519V101-Datasheet.txt` line 6731).";

        enum PERI_CRG57_pmc_srst_req_enum {
            DEASSERT_RESET = 0 { name = "Deassert Reset"; desc = "reset deasserted"; };
            RESET = 1 { name = "Reset"; desc = "reset"; };
        };

        field {
            name = "pmc_srst_req";
            desc = "PMC soft reset";
            sw = rw;
            hw = r;
            encode = PERI_CRG57_pmc_srst_req_enum;
            reset = 0x0;
        } pmc_srst_req[29:29];

        enum PERI_CRG57_ssp3_clken_enum {
            DISABLED = 0 { name = "Disabled"; desc = "clock disabled"; };
            ENABLED = 1 { name = "Enabled"; desc = "clock enabled"; };
        };

        field {
            name = "ssp3_clken";
            desc = "SSP3 clock gating";
            sw = rw;
            hw = r;
            encode = PERI_CRG57_ssp3_clken_enum;
            reset = 0x0;
        } ssp3_clken[28:28];

        enum PERI_CRG57_test_clk_en_enum {
            DISABLED = 0 { name = "Disabled"; desc = "all test clocks are disabled"; };
            ENABLED = 1 { name = "Enabled"; desc = "all test clocks are enabled"; };
        };

        field {
            name = "test_clk_en";
            desc = "Test clock enable";
            sw = rw;
            hw = r;
            encode = PERI_CRG57_test_clk_en_enum;
            reset = 0x1;
        } test_clk_en[27:27];

        enum PERI_CRG57_i2c_clksel_enum {
            SYS_APB = 0 { name = "Sys Apb"; desc = "SYS APB clock"; };
            CLK_50MHZ = 1 { name = "Clk 50Mhz"; desc = "50 MHz clock"; };
        };

        field {
            name = "i2c_clksel";
            desc = "I2C clock select";
            sw = rw;
            hw = r;
            encode = PERI_CRG57_i2c_clksel_enum;
            reset = 0x1;
        } i2c_clksel[26:26];

        enum PERI_CRG57_uart_clksel_enum {
            SYS_APB = 0 { name = "Sys Apb"; desc = "SYS APB clock"; };
            CLK_24MHZ = 1 { name = "Clk 24Mhz"; desc = "24 MHz clock"; };
        };

        field {
            name = "uart_clksel";
            desc = "UART clock select";
            sw = rw;
            hw = r;
            encode = PERI_CRG57_uart_clksel_enum;
            reset = 0x1;
        } uart_clksel[25:25];

        enum PERI_CRG57_uart4_clken_enum {
            DISABLED = 0 { name = "Disabled"; desc = "clock disabled"; };
            ENABLED = 1 { name = "Enabled"; desc = "clock enabled"; };
        };

        field {
            name = "uart4_clken";
            desc = "UART4 clock gating";
            sw = rw;
            hw = r;
            encode = PERI_CRG57_uart4_clken_enum;
            reset = 0x0;
        } uart4_clken[24:24];

        enum PERI_CRG57_uart3_clken_enum {
            DISABLED = 0 { name = "Disabled"; desc = "clock disabled"; };
            ENABLED = 1 { name = "Enabled"; desc = "clock enabled"; };
        };

        field {
            name = "uart3_clken";
            desc = "UART3 clock gating";
            sw = rw;
            hw = r;
            encode = PERI_CRG57_uart3_clken_enum;
            reset = 0x0;
        } uart3_clken[23:23];

        enum PERI_CRG57_uart2_clken_enum {
            DISABLED = 0 { name = "Disabled"; desc = "clock disabled"; };
            ENABLED = 1 { name = "Enabled"; desc = "clock enabled"; };
        };

        field {
            name = "uart2_clken";
            desc = "UART2 clock gating";
            sw = rw;
            hw = r;
            encode = PERI_CRG57_uart2_clken_enum;
            reset = 0x0;
        } uart2_clken[22:22];

        enum PERI_CRG57_uart1_clken_enum {
            DISABLED = 0 { name = "Disabled"; desc = "clock disabled"; };
            ENABLED = 1 { name = "Enabled"; desc = "clock enabled"; };
        };

        field {
            name = "uart1_clken";
            desc = "UART1 clock gating";
            sw = rw;
            hw = r;
            encode = PERI_CRG57_uart1_clken_enum;
            reset = 0x0;
        } uart1_clken[21:21];

        enum PERI_CRG57_uart0_clken_enum {
            DISABLED = 0 { name = "Disabled"; desc = "clock disabled"; };
            ENABLED = 1 { name = "Enabled"; desc = "clock enabled"; };
        };

        field {
            name = "uart0_clken";
            desc = "UART0 clock gating";
            sw = rw;
            hw = r;
            encode = PERI_CRG57_uart0_clken_enum;
            reset = 0x1;
        } uart0_clken[20:20];

        enum PERI_CRG57_ir_clken_enum {
            DISABLED = 0 { name = "Disabled"; desc = "clock disabled"; };
            ENABLED = 1 { name = "Enabled"; desc = "clock enabled"; };
        };

        field {
            name = "ir_clken";
            desc = "IR clock gating";
            sw = rw;
            hw = r;
            encode = PERI_CRG57_ir_clken_enum;
            reset = 0x0;
        } ir_clken[19:19];

        enum PERI_CRG57_ssp2_clken_enum {
            DISABLED = 0 { name = "Disabled"; desc = "clock disabled"; };
            ENABLED = 1 { name = "Enabled"; desc = "clock enabled"; };
        };

        field {
            name = "ssp2_clken";
            desc = "SSP2 clock gating";
            sw = rw;
            hw = r;
            encode = PERI_CRG57_ssp2_clken_enum;
            reset = 0x0;
        } ssp2_clken[18:18];

        enum PERI_CRG57_ssp1_clken_enum {
            DISABLED = 0 { name = "Disabled"; desc = "clock disabled"; };
            ENABLED = 1 { name = "Enabled"; desc = "clock enabled"; };
        };

        field {
            name = "ssp1_clken";
            desc = "SSP1 clock gating";
            sw = rw;
            hw = r;
            encode = PERI_CRG57_ssp1_clken_enum;
            reset = 0x0;
        } ssp1_clken[17:17];

        enum PERI_CRG57_ssp0_clken_enum {
            DISABLED = 0 { name = "Disabled"; desc = "clock disabled"; };
            ENABLED = 1 { name = "Enabled"; desc = "clock enabled"; };
        };

        field {
            name = "ssp0_clken";
            desc = "SSP0 clock gating";
            sw = rw;
            hw = r;
            encode = PERI_CRG57_ssp0_clken_enum;
            reset = 0x0;
        } ssp0_clken[16:16];

        enum PERI_CRG57_ssp3_srst_req_enum {
            DEASSERT_RESET = 0 { name = "Deassert Reset"; desc = "reset deasserted"; };
            RESET = 1 { name = "Reset"; desc = "reset"; };
        };

        field {
            name = "ssp3_srst_req";
            desc = "SSP3 soft reset";
            sw = rw;
            hw = r;
            encode = PERI_CRG57_ssp3_srst_req_enum;
            reset = 0x0;
        } ssp3_srst_req[15:15];

        enum PERI_CRG57_i2c3_srst_req_enum {
            DEASSERT_RESET = 0 { name = "Deassert Reset"; desc = "reset deasserted"; };
            RESET = 1 { name = "Reset"; desc = "reset"; };
        };

        field {
            name = "i2c3_srst_req";
            desc = "I2C3 soft reset";
            sw = rw;
            hw = r;
            encode = PERI_CRG57_i2c3_srst_req_enum;
            reset = 0x0;
        } i2c3_srst_req[13:13];

        enum PERI_CRG57_uart4_srst_req_enum {
            DEASSERT_RESET = 0 { name = "Deassert Reset"; desc = "reset deasserted"; };
            RESET = 1 { name = "Reset"; desc = "reset"; };
        };

        field {
            name = "uart4_srst_req";
            desc = "UART4 soft reset";
            sw = rw;
            hw = r;
            encode = PERI_CRG57_uart4_srst_req_enum;
            reset = 0x0;
        } uart4_srst_req[12:12];

        enum PERI_CRG57_uart3_srst_req_enum {
            DEASSERT_RESET = 0 { name = "Deassert Reset"; desc = "reset deasserted"; };
            RESET = 1 { name = "Reset"; desc = "reset"; };
        };

        field {
            name = "uart3_srst_req";
            desc = "UART3 soft reset";
            sw = rw;
            hw = r;
            encode = PERI_CRG57_uart3_srst_req_enum;
            reset = 0x0;
        } uart3_srst_req[11:11];

        enum PERI_CRG57_uart2_srst_req_enum {
            DEASSERT_RESET = 0 { name = "Deassert Reset"; desc = "reset deasserted"; };
            RESET = 1 { name = "Reset"; desc = "reset"; };
        };

        field {
            name = "uart2_srst_req";
            desc = "UART2 soft reset";
            sw = rw;
            hw = r;
            encode = PERI_CRG57_uart2_srst_req_enum;
            reset = 0x0;
        } uart2_srst_req[10:10];

        enum PERI_CRG57_uart1_srst_req_enum {
            DEASSERT_RESET = 0 { name = "Deassert Reset"; desc = "reset deasserted"; };
            RESET = 1 { name = "Reset"; desc = "reset"; };
        };

        field {
            name = "uart1_srst_req";
            desc = "UART1 soft reset";
            sw = rw;
            hw = r;
            encode = PERI_CRG57_uart1_srst_req_enum;
            reset = 0x0;
        } uart1_srst_req[9:9];

        enum PERI_CRG57_uart0_srst_req_enum {
            DEASSERT_RESET = 0 { name = "Deassert Reset"; desc = "reset deasserted"; };
            RESET = 1 { name = "Reset"; desc = "reset"; };
        };

        field {
            name = "uart0_srst_req";
            desc = "UART0 soft reset";
            sw = rw;
            hw = r;
            encode = PERI_CRG57_uart0_srst_req_enum;
            reset = 0x0;
        } uart0_srst_req[8:8];

        enum PERI_CRG57_ir_srst_req_enum {
            DEASSERT_RESET = 0 { name = "Deassert Reset"; desc = "reset deasserted"; };
            RESET = 1 { name = "Reset"; desc = "reset"; };
        };

        field {
            name = "ir_srst_req";
            desc = "IR soft reset";
            sw = rw;
            hw = r;
            encode = PERI_CRG57_ir_srst_req_enum;
            reset = 0x0;
        } ir_srst_req[7:7];

        enum PERI_CRG57_ssp2_srst_req_enum {
            DEASSERT_RESET = 0 { name = "Deassert Reset"; desc = "reset deasserted"; };
            RESET = 1 { name = "Reset"; desc = "reset"; };
        };

        field {
            name = "ssp2_srst_req";
            desc = "SSP2 soft reset";
            sw = rw;
            hw = r;
            encode = PERI_CRG57_ssp2_srst_req_enum;
            reset = 0x0;
        } ssp2_srst_req[6:6];

        enum PERI_CRG57_ssp1_srst_req_enum {
            DEASSERT_RESET = 0 { name = "Deassert Reset"; desc = "reset deasserted"; };
            RESET = 1 { name = "Reset"; desc = "reset"; };
        };

        field {
            name = "ssp1_srst_req";
            desc = "SSP1 soft reset";
            sw = rw;
            hw = r;
            encode = PERI_CRG57_ssp1_srst_req_enum;
            reset = 0x0;
        } ssp1_srst_req[5:5];

        enum PERI_CRG57_ssp0_srst_req_enum {
            DEASSERT_RESET = 0 { name = "Deassert Reset"; desc = "reset deasserted"; };
            RESET = 1 { name = "Reset"; desc = "reset"; };
        };

        field {
            name = "ssp0_srst_req";
            desc = "SSP0 soft reset";
            sw = rw;
            hw = r;
            encode = PERI_CRG57_ssp0_srst_req_enum;
            reset = 0x0;
        } ssp0_srst_req[4:4];

        enum PERI_CRG57_t_cap_srst_req_enum {
            DEASSERT_RESET = 0 { name = "Deassert Reset"; desc = "reset deasserted"; };
            RESET = 1 { name = "Reset"; desc = "reset"; };
        };

        field {
            name = "t_cap_srst_req";
            desc = "T_CAP soft reset";
            sw = rw;
            hw = r;
            encode = PERI_CRG57_t_cap_srst_req_enum;
            reset = 0x0;
        } t_cap_srst_req[3:3];

        enum PERI_CRG57_i2c2_srst_req_enum {
            DEASSERT_RESET = 0 { name = "Deassert Reset"; desc = "reset deasserted"; };
            RESET = 1 { name = "Reset"; desc = "reset"; };
        };

        field {
            name = "i2c2_srst_req";
            desc = "I2C2 soft reset";
            sw = rw;
            hw = r;
            encode = PERI_CRG57_i2c2_srst_req_enum;
            reset = 0x0;
        } i2c2_srst_req[2:2];

        enum PERI_CRG57_i2c1_srst_req_enum {
            DEASSERT_RESET = 0 { name = "Deassert Reset"; desc = "reset deasserted"; };
            RESET = 1 { name = "Reset"; desc = "reset"; };
        };

        field {
            name = "i2c1_srst_req";
            desc = "I2C1 soft reset";
            sw = rw;
            hw = r;
            encode = PERI_CRG57_i2c1_srst_req_enum;
            reset = 0x0;
        } i2c1_srst_req[1:1];

        enum PERI_CRG57_i2c0_srst_req_enum {
            DEASSERT_RESET = 0 { name = "Deassert Reset"; desc = "reset deasserted"; };
            RESET = 1 { name = "Reset"; desc = "reset"; };
        };

        field {
            name = "i2c0_srst_req";
            desc = "I2C0 soft reset";
            sw = rw;
            hw = r;
            encode = PERI_CRG57_i2c0_srst_req_enum;
            reset = 0x0;
        } i2c0_srst_req[0:0];
    } PERI_CRG57 @ 0xE4;

    reg {
        name = "CRG status register";
        desc = "PERI_CRG58 is a CRG status register.

PLL lock status (read-only): apll_lock [0], dpll_lock [2], vpll_lock [3], epll_lock [4], gzip_rst_ok [8]. After changing a PLL wait 0.1 ms, then poll PERI_CRG58[4:0] until the PLL locks (DS 3.2.5.3).

Data sheet 3.2.7 PERI_CRG58 (offset 0xE8, printed page 3-56, `hi3519v101--Hi3519V101-Datasheet.txt` line 6877).";

        enum PERI_CRG58_gzip_rst_ok_enum {
            NOT_RESET = 0 { name = "Not Reset"; desc = "not reset"; };
            RESET = 1 { name = "Reset"; desc = "reset"; };
        };

        field {
            name = "gzip_rst_ok";
            desc = "GZIP reset status";
            sw = r;
            hw = w;
            encode = PERI_CRG58_gzip_rst_ok_enum;
            reset = 0x0;
        } gzip_rst_ok[8:8];

        enum PERI_CRG58_epll_lock_enum {
            UNLOCKED = 0 { name = "Unlocked"; desc = "unlocked"; };
            LOCKED = 1 { name = "Locked"; desc = "locked"; };
        };

        field {
            name = "epll_lock";
            desc = "EPLL lock status";
            sw = r;
            hw = w;
            encode = PERI_CRG58_epll_lock_enum;
            reset = 0x0;
        } epll_lock[4:4];

        enum PERI_CRG58_vpll_lock_enum {
            UNLOCKED = 0 { name = "Unlocked"; desc = "unlocked"; };
            LOCKED = 1 { name = "Locked"; desc = "locked"; };
        };

        field {
            name = "vpll_lock";
            desc = "VPLL lock status";
            sw = r;
            hw = w;
            encode = PERI_CRG58_vpll_lock_enum;
            reset = 0x0;
        } vpll_lock[3:3];

        enum PERI_CRG58_dpll_lock_enum {
            UNLOCKED = 0 { name = "Unlocked"; desc = "unlocked"; };
            LOCKED = 1 { name = "Locked"; desc = "locked"; };
        };

        field {
            name = "dpll_lock";
            desc = "DPLL lock status";
            sw = r;
            hw = w;
            encode = PERI_CRG58_dpll_lock_enum;
            reset = 0x0;
        } dpll_lock[2:2];

        enum PERI_CRG58_apll_lock_enum {
            UNLOCKED = 0 { name = "Unlocked"; desc = "unlocked"; };
            LOCKED = 1 { name = "Locked"; desc = "locked"; };
        };

        field {
            name = "apll_lock";
            desc = "APLL lock status";
            sw = r;
            hw = w;
            encode = PERI_CRG58_apll_lock_enum;
            reset = 0x0;
        } apll_lock[0:0];
    } PERI_CRG58 @ 0xE8;

    reg {
        name = "GMAC interface control register";
        desc = "PERI_CRG59 is a GMAC interface control register.

GMAC interface control (phy_select, speed, duplex, loopback); reset 0x3F = RGMII, full duplex, 100 Mbit/s, port_select 10/100.

Data sheet 3.2.7 PERI_CRG59 (offset 0xEC, printed page 3-57, `hi3519v101--Hi3519V101-Datasheet.txt` line 6930).";

        enum PERI_CRG59_loopback_mode_enum {
            DISABLED = 0 { name = "Disabled"; desc = "disabled"; };
            ENABLED = 1 { name = "Enabled"; desc = "enabled"; };
        };

        field {
            name = "loopback_mode";
            desc = "Loopback mode enable";
            sw = rw;
            hw = r;
            encode = PERI_CRG59_loopback_mode_enum;
            reset = 0x0;
        } loopback_mode[8:8];

        enum PERI_CRG59_phy_select_enum {
            GMII_MII = 0 { name = "Gmii Mii"; desc = "GMII/MII mode"; };
            RGMII = 1 { name = "Rgmii"; desc = "RGMII mode"; };
            RESERVED_2 = 2 { name = "Reserved 2"; desc = "reserved"; };
            RESERVED_3 = 3 { name = "Reserved 3"; desc = "reserved"; };
            RMII = 4 { name = "Rmii"; desc = "RMII mode"; };
            RESERVED_5 = 5 { name = "Reserved 5"; desc = "reserved"; };
            RESERVED_6 = 6 { name = "Reserved 6"; desc = "reserved"; };
            RESERVED_7 = 7 { name = "Reserved 7"; desc = "reserved"; };
        };

        field {
            name = "phy_select";
            desc = "PHY interface mode. Other values are reserved.";
            sw = rw;
            hw = r;
            encode = PERI_CRG59_phy_select_enum;
            reset = 0x1;
        } phy_select[7:5];

        enum PERI_CRG59_duplex_mode_enum {
            HALF_DUPLEX_MODE = 0 { name = "Half Duplex Mode"; desc = "half-duplex mode"; };
            FULL_DUPLEX_MODE = 1 { name = "Full Duplex Mode"; desc = "full-duplex mode"; };
        };

        field {
            name = "duplex_mode";
            desc = "PHY duplex mode";
            sw = rw;
            hw = r;
            encode = PERI_CRG59_duplex_mode_enum;
            reset = 0x1;
        } duplex_mode[4:4];

        enum PERI_CRG59_tx_config_enum {
            DISABLED = 0 { name = "Disabled"; desc = "disabled"; };
            ENABLED = 1 { name = "Enabled"; desc = "enabled"; };
        };

        field {
            name = "tx_config";
            desc = "TX configuration enable";
            sw = rw;
            hw = r;
            encode = PERI_CRG59_tx_config_enum;
            reset = 0x1;
        } tx_config[3:3];

        enum PERI_CRG59_link_status_enum {
            LINK_DOWN = 0 { name = "Link Down"; desc = "link down"; };
            LINK_UP = 1 { name = "Link Up"; desc = "link up"; };
        };

        field {
            name = "link_status";
            desc = "PHY link status";
            sw = rw;
            hw = r;
            encode = PERI_CRG59_link_status_enum;
            reset = 0x1;
        } link_status[2:2];

        enum PERI_CRG59_mac_speed_enum {
            RATE_10MBPS = 0 { name = "Rate 10Mbps"; desc = "10 Mbit/s"; };
            RATE_100MBPS = 1 { name = "Rate 100Mbps"; desc = "100 Mbit/s"; };
        };

        field {
            name = "mac_speed";
            desc = "10/100 Mbit/s mode";
            sw = rw;
            hw = r;
            encode = PERI_CRG59_mac_speed_enum;
            reset = 0x1;
        } mac_speed[1:1];

        enum PERI_CRG59_port_select_enum {
            GE_1000MBPS = 0 { name = "Ge 1000Mbps"; desc = "1000 Mbit/s port mode"; };
            FE_10_100MBPS = 1 { name = "Fe 10 100Mbps"; desc = "10/100 Mbit/s port mode"; };
        };

        field {
            name = "port_select";
            desc = "Network port mode select";
            sw = rw;
            hw = r;
            encode = PERI_CRG59_port_select_enum;
            reset = 0x1;
        } port_select[0:0];
    } PERI_CRG59 @ 0xEC;

    reg {
        name = "GMAC interface status register";
        desc = "PERI_CRG60 is a GMAC interface status register.

GMAC interface status (read-only): link status/speed/mode seen on the RGMII receive path when rxdv and rxer are 0.

Data sheet 3.2.7 PERI_CRG60 (offset 0xF0, printed page 3-58, `hi3519v101--Hi3519V101-Datasheet.txt` line 6986).";

        enum PERI_CRG60_link_status_enum {
            LINK_DOWN = 0 { name = "Link Down"; desc = "link down"; };
            LINK_UP = 1 { name = "Link Up"; desc = "link up"; };
        };

        field {
            name = "link_status";
            desc = "Link status when rxdv and rxer are 0 in RGMII mode";
            sw = r;
            hw = w;
            encode = PERI_CRG60_link_status_enum;
            reset = 0x0;
        } link_status[3:3];

        enum PERI_CRG60_link_speed_enum {
            CLK_2P5MHZ = 0 { name = "Clk 2P5Mhz"; desc = "2.5 MHz"; };
            CLK_25MHZ = 1 { name = "Clk 25Mhz"; desc = "25 MHz"; };
            CLK_125MHZ = 2 { name = "Clk 125Mhz"; desc = "125 MHz"; };
            RESERVED_3 = 3 { name = "Reserved 3"; desc = "reserved"; };
        };

        field {
            name = "link_speed";
            desc = "Rate status when rxdv and rxer are 0 in RGMII mode";
            sw = r;
            hw = w;
            encode = PERI_CRG60_link_speed_enum;
            reset = 0x0;
        } link_speed[2:1];

        enum PERI_CRG60_link_mode_enum {
            HALF_DUPLEX_MODE = 0 { name = "Half Duplex Mode"; desc = "half-duplex mode"; };
            FULL_DUPLEX_MODE = 1 { name = "Full Duplex Mode"; desc = "full-duplex mode"; };
        };

        field {
            name = "link_mode";
            desc = "Mode status when rxdv and rxer are 0 in RGMII mode";
            sw = r;
            hw = w;
            encode = PERI_CRG60_link_mode_enum;
            reset = 0x0;
        } link_mode[0:0];
    } PERI_CRG60 @ 0xF0;

    reg {
        name = "SoC frequency status register";
        desc = "PERI_CRG79 is an SoC frequency status register.

SoC frequency status (read-only): completion indicators for the PERI_CRG13 muxes, same encodings as the select fields (a7_sc_seled [2:0], a17_sc_seled [5:3], ddr_sc_seled [8:6], sysaxi_sc_seled [9]). Poll them after changing PERI_CRG13.

Data sheet 3.2.7 PERI_CRG79 (offset 0x13C, printed page 3-58, `hi3519v101--Hi3519V101-Datasheet.txt` line 7016).";

        enum PERI_CRG79_sysaxi_sc_seled_enum {
            CLK_24MHZ = 0 { name = "Clk 24Mhz"; desc = "The clock is switched to a 24 MHz clock."; };
            CLK_198MHZ = 1 { name = "Clk 198Mhz"; desc = "The clock is switched to a 198 MHz clock."; };
        };

        field {
            name = "sysaxi_sc_seled";
            desc = "SYSAXI clock switching completion indicator";
            sw = r;
            hw = w;
            encode = PERI_CRG79_sysaxi_sc_seled_enum;
            reset = 0x0;
        } sysaxi_sc_seled[9:9];

        enum PERI_CRG79_ddr_sc_seled_enum {
            CLK_24MHZ = 0 { name = "Clk 24Mhz"; desc = "The clock is switched to a 24 MHz clock."; };
            DPLL_POSTDIV = 1 { name = "Dpll Postdiv"; desc = "The clock is switched to the DPLL POSTDIV clock."; };
            RESERVED_2 = 2 { name = "Reserved 2"; desc = "reserved"; };
            CLK_396MHZ = 3 { name = "Clk 396Mhz"; desc = "The clock is switched to a 396 MHz clock."; };
            CLK_340MHZ = 4 { name = "Clk 340Mhz"; desc = "The clock is switched to a 340 MHz clock."; };
            CLK_300MHZ = 5 { name = "Clk 300Mhz"; desc = "The clock is switched to a 300 MHz clock."; };
            RESERVED_6 = 6 { name = "Reserved 6"; desc = "reserved"; };
            RESERVED_7 = 7 { name = "Reserved 7"; desc = "reserved"; };
        };

        field {
            name = "ddr_sc_seled";
            desc = "DDR clock switching completion indicator. Other values are reserved.";
            sw = r;
            hw = w;
            encode = PERI_CRG79_ddr_sc_seled_enum;
            reset = 0x0;
        } ddr_sc_seled[8:6];

        enum PERI_CRG79_a17_sc_seled_enum {
            CLK_24MHZ = 0 { name = "Clk 24Mhz"; desc = "The clock is switched to a 24 MHz clock."; };
            APLL_FOUTVCO = 1 { name = "Apll Foutvco"; desc = "The clock is switched to the APLL FOUTVCO clock."; };
            APLL_POSTDIV = 2 { name = "Apll Postdiv"; desc = "The clock is switched to the APLL POSTDIV clock."; };
            CLK_594MHZ = 3 { name = "Clk 594Mhz"; desc = "The clock is switched to a 594 MHz clock."; };
            CLK_792MHZ = 4 { name = "Clk 792Mhz"; desc = "The clock is switched to a 792 MHz clock."; };
            RESERVED_5 = 5 { name = "Reserved 5"; desc = "reserved"; };
            RESERVED_6 = 6 { name = "Reserved 6"; desc = "reserved"; };
            RESERVED_7 = 7 { name = "Reserved 7"; desc = "reserved"; };
        };

        field {
            name = "a17_sc_seled";
            desc = "A17 clock switching completion indicator. Other values are reserved.";
            sw = r;
            hw = w;
            encode = PERI_CRG79_a17_sc_seled_enum;
            reset = 0x0;
        } a17_sc_seled[5:3];

        enum PERI_CRG79_a7_sc_seled_enum {
            CLK_24MHZ = 0 { name = "Clk 24Mhz"; desc = "The clock is switched to a 24 MHz clock."; };
            RESERVED_1 = 1 { name = "Reserved 1"; desc = "reserved"; };
            APLL_POSTDIV = 2 { name = "Apll Postdiv"; desc = "The clock is switched to the APLL POSTDIV clock."; };
            CLK_792MHZ = 3 { name = "Clk 792Mhz"; desc = "The clock is switched to a 792 MHz clock."; };
            CLK_594MHZ = 4 { name = "Clk 594Mhz"; desc = "The clock is switched to a 594 MHz clock."; };
            RESERVED_5 = 5 { name = "Reserved 5"; desc = "reserved"; };
            RESERVED_6 = 6 { name = "Reserved 6"; desc = "reserved"; };
            RESERVED_7 = 7 { name = "Reserved 7"; desc = "reserved"; };
        };

        field {
            name = "a7_sc_seled";
            desc = "A7 clock switching completion indicator. Other values are reserved.";
            sw = r;
            hw = w;
            encode = PERI_CRG79_a7_sc_seled_enum;
            reset = 0x0;
        } a7_sc_seled[2:0];
    } PERI_CRG79 @ 0x13C;

};

`endif
