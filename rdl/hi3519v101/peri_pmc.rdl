`ifndef PMC_RDL
`define PMC_RDL

regfile ePERI_PMC {
    name = "Power management control (PMC)";

    reg {
        name = "Core AVS PWM configuration register";
        field {
            name = "core_pwm_duty";
            reset = 0x12;
        } core_pwm_duty[31:16];

        field {
            name = "core_pwm_period";
            reset = 0x78;
        } core_pwm_period[15:0];
    } PERI_PMC0 @ 0x0000;

    reg {
        name = "A17 AVS PWM configuration register";
        field {
            name = "a17_pwm_duty";
            reset = 0x12;
        } a17_pwm_duty[31:16];

        field {
            name = "a17_pwm_period";
            reset = 0x78;
        } a17_pwm_period[15:0];
    } PERI_PMC1 @ 0x0004;

    reg {
        name = "DDR AVS PWM configuration register";
        field {
            name = "ddr_pwm_duty";
            reset = 0x12;
        } ddr_pwm_duty[31:16];

        field {
            name = "ddr_pwm_period";
            reset = 0x78;
        } ddr_pwm_period[15:0];
    } PERI_PMC2 @ 0x0008;

    reg {
        name = "MDA0 AVS PWM configuration register";
        field {
            name = "mda0_pwm_duty";
            reset = 0x12;
        } mda0_pwm_duty[31:16];

        field {
            name = "mda0_pwm_period";
            reset = 0x78;
        } mda0_pwm_period[15:0];
    } PERI_PMC3 @ 0x000C;

    reg {
        name = "AVS PWM output source select configuration register";
        field {
            name = "pwm3_reuse_cfg";
            reset = 0x3;
        } pwm3_reuse_cfg[15:14];

        field {
            name = "pwm2_reuse_cfg";
            reset = 0x2;
        } pwm2_reuse_cfg[13:12];

        field {
            name = "pwm1_reuse_cfg";
            reset = 0x1;
        } pwm1_reuse_cfg[11:10];

        field {
            name = "pwm0_reuse_cfg";
            reset = 0x0;
        } pwm0_reuse_cfg[9:8];

        field {
            name = "mda_pwm_inv";
            reset = 0x0;
        } mda_pwm_inv[7:7];

        field {
            name = "mda_pwm_enable";
            reset = 0x0;
        } mda_pwm_enable[6:6];

        field {
            name = "ddr_pwm_inv";
            reset = 0x0;
        } ddr_pwm_inv[5:5];

        field {
            name = "ddr_pwm_enable";
            reset = 0x0;
        } ddr_pwm_enable[4:4];

        field {
            name = "a17_pwm_inv";
            reset = 0x0;
        } a17_pwm_inv[3:3];

        field {
            name = "a17_pwm_enable";
            reset = 0x0;
        } a17_pwm_enable[2:2];

        field {
            name = "core_pwm_inv";
            reset = 0x0;
        } core_pwm_inv[1:1];

        field {
            name = "core_pwm_enable";
            reset = 0x0;
        } core_pwm_enable[0:0];
    } PERI_PMC4 @ 0x0010;

    reg {
        name = "Core AVS control register";
        field {
            name = "core_avs_fsm_inc_pwm_step";
            reset = 0x0;
        } core_avs_fsm_inc_pwm_step[31:24];

        field {
            name = "core_avs_fsm_dec_pwm_step";
            reset = 0x0;
        } core_avs_fsm_dec_pwm_step[23:16];

        field {
            name = "core_avs_hpm_fsm_calc_mode";
            reset = 0x0;
        } core_avs_hpm_fsm_calc_mode[2:1];

        field {
            name = "core_hpm_fsm_en";
            reset = 0x0;
        } core_hpm_fsm_en[0:0];
    } PERI_PMC5 @ 0x0014;

    reg {
        name = "A17 AVS control register";
        field {
            name = "a17_avs_fsm_inc_pwm_step";
            reset = 0x0;
        } a17_avs_fsm_inc_pwm_step[31:24];

        field {
            name = "a17_avs_fsm_dec_pwm_step";
            reset = 0x0;
        } a17_avs_fsm_dec_pwm_step[23:16];

        field {
            name = "a17_avs_hpm_fsm_calc_mode";
            reset = 0x0;
        } a17_avs_hpm_fsm_calc_mode[2:1];

        field {
            name = "a17_hpm_fsm_en";
            reset = 0x0;
        } a17_hpm_fsm_en[0:0];
    } PERI_PMC6 @ 0x0018;

    reg {
        name = "DDR AVS control register";
        field {
            name = "ddr_avs_fsm_inc_pwm_step";
            reset = 0x0;
        } ddr_avs_fsm_inc_pwm_step[31:24];

        field {
            name = "ddr_avs_fsm_dec_pwm_step";
            reset = 0x0;
        } ddr_avs_fsm_dec_pwm_step[23:16];

        field {
            name = "ddr_avs_hpm_fsm_calc_mode";
            reset = 0x0;
        } ddr_avs_hpm_fsm_calc_mode[2:1];

        field {
            name = "ddr_hpm_fsm_en";
            reset = 0x0;
        } ddr_hpm_fsm_en[0:0];
    } PERI_PMC7 @ 0x001C;

    reg {
        name = "MDA0 AVS control register";
        field {
            name = "mda0_avs_fsm_inc_pwm_step";
            reset = 0x0;
        } mda0_avs_fsm_inc_pwm_step[31:24];

        field {
            name = "mda0_avs_fsm_dec_pwm_step";
            reset = 0x0;
        } mda0_avs_fsm_dec_pwm_step[23:16];

        field {
            name = "mda0_avs_hpm_fsm_calc_mode";
            reset = 0x0;
        } mda0_avs_hpm_fsm_calc_mode[2:1];

        field {
            name = "mda0_hpm_fsm_en";
            reset = 0x0;
        } mda0_hpm_fsm_en[0:0];
    } PERI_PMC8 @ 0x0020;

    reg {
        name = "Core HPM control register 0";
        field {
            name = "core_hpm_srst_req";
            reset = 0x0;
        } core_hpm_srst_req[27:27];

        field {
            name = "core_hpm_monitor_en";
            reset = 0x0;
        } core_hpm_monitor_en[26:26];

        field {
            name = "core_hpm_bypass";
            reset = 0x0;
        } core_hpm_bypass[25:25];

        field {
            name = "core_hpm_en";
            reset = 0x0;
        } core_hpm_en[24:24];

        field {
            name = "core_hpm_offset";
            reset = 0x0;
        } core_hpm_offset[21:12];

        field {
            name = "core_hpm_shift";
            reset = 0x0;
        } core_hpm_shift[9:8];

        field {
            name = "core_hpm_div";
            reset = 0xA;
        } core_hpm_div[5:0];
    } PERI_PMC10 @ 0x0028;

    reg {
        name = "Core HPM status register 1";
        field {
            name = "core_hpm_up_warning";
            sw = r;
            hw = w;
            reset = 0x0;
        } core_hpm_up_warning[25:25];

        field {
            name = "core_hpm_low_warning";
            sw = r;
            hw = w;
            reset = 0x0;
        } core_hpm_low_warning[24:24];

        field {
            name = "core_hpm_pc_record1";
            sw = r;
            hw = w;
            reset = 0x0;
        } core_hpm_pc_record1[21:12];

        field {
            name = "core_hpm_pc_valid";
            sw = r;
            hw = w;
            reset = 0x0;
        } core_hpm_pc_valid[10:10];

        field {
            name = "core_hpm_pc_record0";
            sw = r;
            hw = w;
            reset = 0x0;
        } core_hpm_pc_record0[9:0];
    } PERI_PMC11 @ 0x002C;

    reg {
        name = "Core HPM status register 2";
        field {
            name = "core_hpm_rcc";
            sw = r;
            hw = w;
            reset = 0x0;
        } core_hpm_rcc[28:24];

        field {
            name = "core_hpm_pc_record3";
            sw = r;
            hw = w;
            reset = 0x0;
        } core_hpm_pc_record3[21:12];

        field {
            name = "core_hpm_pc_record2";
            sw = r;
            hw = w;
            reset = 0x0;
        } core_hpm_pc_record2[9:0];
    } PERI_PMC12 @ 0x0030;

    reg {
        name = "Core HPM control register 3";
        field {
            name = "core_hpm_monitor_period";
            reset = 0x1;
        } core_hpm_monitor_period[31:24];

        field {
            name = "core_hpm_lowlimit";
            reset = 0x0;
        } core_hpm_lowlimit[21:12];

        field {
            name = "core_hpm_uplimit";
            reset = 0x0;
        } core_hpm_uplimit[9:0];
    } PERI_PMC13 @ 0x0034;

    reg {
        name = "A17 HPM control register 0";
        field {
            name = "a17_hpm_srst_req";
            reset = 0x0;
        } a17_hpm_srst_req[27:27];

        field {
            name = "a17_hpm_monitor_en";
            reset = 0x0;
        } a17_hpm_monitor_en[26:26];

        field {
            name = "a17_hpm_en";
            reset = 0x0;
        } a17_hpm_en[24:24];

        field {
            name = "a17_hpm_offset";
            reset = 0x0;
        } a17_hpm_offset[21:12];

        field {
            name = "a17_hpm_shift";
            reset = 0x0;
        } a17_hpm_shift[9:8];

        field {
            name = "a17_hpm_div";
            reset = 0xA;
        } a17_hpm_div[5:0];
    } PERI_PMC14 @ 0x0038;

    reg {
        name = "A17 HPM status register 1";
        field {
            name = "a17_hpm_up_warning";
            sw = r;
            hw = w;
            reset = 0x0;
        } a17_hpm_up_warning[25:25];

        field {
            name = "a17_hpm_low_warning";
            sw = r;
            hw = w;
            reset = 0x0;
        } a17_hpm_low_warning[24:24];

        field {
            name = "a17_hpm_pc_record1";
            sw = r;
            hw = w;
            reset = 0x0;
        } a17_hpm_pc_record1[21:12];

        field {
            name = "a17_hpm_pc_valid";
            sw = r;
            hw = w;
            reset = 0x0;
        } a17_hpm_pc_valid[10:10];

        field {
            name = "a17_hpm_pc_record0";
            sw = r;
            hw = w;
            reset = 0x0;
        } a17_hpm_pc_record0[9:0];
    } PERI_PMC15 @ 0x003C;

    reg {
        name = "A17 HPM status register 2";
        field {
            name = "a17_hpm_rcc";
            sw = r;
            hw = w;
            reset = 0x0;
        } a17_hpm_rcc[28:24];

        field {
            name = "a17_hpm_pc_record3";
            sw = r;
            hw = w;
            reset = 0x0;
        } a17_hpm_pc_record3[21:12];

        field {
            name = "a17_hpm_pc_record2";
            sw = r;
            hw = w;
            reset = 0x0;
        } a17_hpm_pc_record2[9:0];
    } PERI_PMC16 @ 0x0040;

    reg {
        name = "A17 HPM control register 3";
        field {
            name = "a17_hpm_monitor_period";
            reset = 0x1;
        } a17_hpm_monitor_period[31:24];

        field {
            name = "a17_hpm_lowlimit";
            reset = 0x0;
        } a17_hpm_lowlimit[21:12];

        field {
            name = "a17_hpm_uplimit";
            reset = 0x0;
        } a17_hpm_uplimit[9:0];
    } PERI_PMC17 @ 0x0044;

    reg {
        name = "DDR HPM control register 0";
        field {
            name = "ddr_hpm_srst_req";
            reset = 0x0;
        } ddr_hpm_srst_req[27:27];

        field {
            name = "ddr_hpm_monitor_en";
            reset = 0x0;
        } ddr_hpm_monitor_en[26:26];

        field {
            name = "ddr_hpm_en";
            reset = 0x0;
        } ddr_hpm_en[24:24];

        field {
            name = "ddr_hpm_offset";
            reset = 0x0;
        } ddr_hpm_offset[21:12];

        field {
            name = "ddr_hpm_shift";
            reset = 0x0;
        } ddr_hpm_shift[9:8];

        field {
            name = "ddr_hpm_div";
            reset = 0xA;
        } ddr_hpm_div[5:0];
    } PERI_PMC18 @ 0x0048;

    reg {
        name = "DDR HPM status register 1";
        field {
            name = "ddr_hpm_up_warning";
            sw = r;
            hw = w;
            reset = 0x0;
        } ddr_hpm_up_warning[25:25];

        field {
            name = "ddr_hpm_low_warning";
            sw = r;
            hw = w;
            reset = 0x0;
        } ddr_hpm_low_warning[24:24];

        field {
            name = "ddr_hpm_pc_record1";
            sw = r;
            hw = w;
            reset = 0x0;
        } ddr_hpm_pc_record1[21:12];

        field {
            name = "ddr_hpm_pc_valid";
            sw = r;
            hw = w;
            reset = 0x0;
        } ddr_hpm_pc_valid[10:10];

        field {
            name = "ddr_hpm_pc_record0";
            sw = r;
            hw = w;
            reset = 0x0;
        } ddr_hpm_pc_record0[9:0];
    } PERI_PMC19 @ 0x004C;

    reg {
        name = "DDR HPM status register 2";
        field {
            name = "ddr_hpm_rcc";
            sw = r;
            hw = w;
            reset = 0x0;
        } ddr_hpm_rcc[28:24];

        field {
            name = "ddr_hpm_pc_record3";
            sw = r;
            hw = w;
            reset = 0x0;
        } ddr_hpm_pc_record3[21:12];

        field {
            name = "ddr_hpm_pc_record2";
            sw = r;
            hw = w;
            reset = 0x0;
        } ddr_hpm_pc_record2[9:0];
    } PERI_PMC20 @ 0x0050;

    reg {
        name = "DDR HPM control register 3";
        field {
            name = "ddr_hpm_monitor_period";
            reset = 0x1;
        } ddr_hpm_monitor_period[31:24];

        field {
            name = "ddr_hpm_lowlimit";
            reset = 0x0;
        } ddr_hpm_lowlimit[21:12];

        field {
            name = "ddr_hpm_uplimit";
            reset = 0x0;
        } ddr_hpm_uplimit[9:0];
    } PERI_PMC21 @ 0x0054;

    reg {
        name = "MDA0 HPM control register 0";
        field {
            name = "mda0_hpm_srst_req";
            reset = 0x0;
        } mda0_hpm_srst_req[27:27];

        field {
            name = "mda0_hpm_monitor_en";
            reset = 0x0;
        } mda0_hpm_monitor_en[26:26];

        field {
            name = "mda0_hpm_en";
            reset = 0x0;
        } mda0_hpm_en[24:24];

        field {
            name = "mda0_hpm_offset";
            reset = 0x0;
        } mda0_hpm_offset[21:12];

        field {
            name = "mda0_hpm_shift";
            reset = 0x0;
        } mda0_hpm_shift[9:8];

        field {
            name = "mda0_hpm_div";
            reset = 0xA;
        } mda0_hpm_div[5:0];
    } PERI_PMC22 @ 0x0058;

    reg {
        name = "MDA0 HPM status register 1";
        field {
            name = "mda0_hpm_up_warning";
            sw = r;
            hw = w;
            reset = 0x0;
        } mda0_hpm_up_warning[25:25];

        field {
            name = "mda0_hpm_low_warning";
            sw = r;
            hw = w;
            reset = 0x0;
        } mda0_hpm_low_warning[24:24];

        field {
            name = "mda0_hpm_pc_record1";
            sw = r;
            hw = w;
            reset = 0x0;
        } mda0_hpm_pc_record1[21:12];

        field {
            name = "mda0_hpm_pc_valid";
            sw = r;
            hw = w;
            reset = 0x0;
        } mda0_hpm_pc_valid[10:10];

        field {
            name = "mda0_hpm_pc_record0";
            sw = r;
            hw = w;
            reset = 0x0;
        } mda0_hpm_pc_record0[9:0];
    } PERI_PMC23 @ 0x005C;

    reg {
        name = "MDA0 HPM status register 2";
        field {
            name = "mda0_hpm_rcc";
            sw = r;
            hw = w;
            reset = 0x0;
        } mda0_hpm_rcc[28:24];

        field {
            name = "mda0_hpm_pc_record3";
            sw = r;
            hw = w;
            reset = 0x0;
        } mda0_hpm_pc_record3[21:12];

        field {
            name = "mda0_hpm_pc_record2";
            sw = r;
            hw = w;
            reset = 0x0;
        } mda0_hpm_pc_record2[9:0];
    } PERI_PMC24 @ 0x0060;

    reg {
        name = "MDA0 HPM control register 3";
        field {
            name = "mda0_hpm_monitor_period";
            reset = 0x1;
        } mda0_hpm_monitor_period[31:24];

        field {
            name = "mda0_hpm_lowlimit";
            reset = 0x0;
        } mda0_hpm_lowlimit[21:12];

        field {
            name = "mda0_hpm_uplimit";
            reset = 0x0;
        } mda0_hpm_uplimit[9:0];
    } PERI_PMC25 @ 0x0064;

    reg {
        name = "HPM cyclic monitoring fine-tuning control register 1";
        field {
            name = "a17_hpm_monitor_period_fine";
            reset = 0x0;
        } a17_hpm_monitor_period_fine[31:24];

        field {
            name = "ddr_hpm_monitor_period_fine";
            reset = 0x0;
        } ddr_hpm_monitor_period_fine[23:16];

        field {
            name = "mda0_hpm_monitor_period_fine";
            reset = 0x0;
        } mda0_hpm_monitor_period_fine[15:8];
    } PERI_PMC30 @ 0x0078;

    reg {
        name = "HPM cyclic monitoring fine-tuning control register 2";
        field {
            name = "core_hpm_monitor_period_fine";
            reset = 0x0;
        } core_hpm_monitor_period_fine[7:0];
    } PERI_PMC31 @ 0x007C;

    reg {
        name = "Tsensor control register";
        field {
            name = "tsensor_en";
            reset = 0x0;
        } tsensor_en[30:30];

        field {
            name = "tsensor_monitor_en";
            reset = 0x0;
        } tsensor_monitor_en[29:29];

        field {
            name = "tsensor_monitor_period";
            reset = 0x0;
        } tsensor_monitor_period[23:16];
    } PERI_PMC68 @ 0x0110 ;

    reg {
        name = "Tsensor overflow/underflow configuration register";
        field {
            name = "tsensor_temp_uplimit";
            reset = 0x0;
        } tsensor_temp_uplimit[25:16];

        field {
            name = "tsensor_temp_lowlimit";
            reset = 0x0;
        } tsensor_temp_lowlimit[9:0];
    } PERI_PMC69 @ 0x0114;

    reg {
        name = "Tsensor measurement value 0/1 register";
        field {
            name = "tsensor_temp_code1";
            sw = r;
            hw = w;
            reset = 0x0;
        } tsensor_temp_code1[25:16];

        field {
            name = "tsensor_temp_code0";
            sw = r;
            hw = w;
            reset = 0x0;
        } tsensor_temp_code0[9:0];
    } PERI_PMC70 @ 0x0118;

    reg {
        name = "Tsensor measurement value 2/3 register";
        field {
            name = "tsensor_temp_code3";
            sw = r;
            hw = w;
            reset = 0x0;
        } tsensor_temp_code3[25:16];

        field {
            name = "tsensor_temp_code2";
            sw = r;
            hw = w;
            reset = 0x0;
        } tsensor_temp_code2[9:0];
    } PERI_PMC71 @ 0x011C;

    reg {
        name = "Tsensor measurement value 4/5 register";
        field {
            name = "tsensor_temp_code5";
            sw = r;
            hw = w;
            reset = 0x0;
        } tsensor_temp_code5[25:16];

        field {
            name = "tsensor_temp_code4";
            sw = r;
            hw = w;
            reset = 0x0;
        } tsensor_temp_code4[9:0];
    } PERI_PMC72 @ 0x0120;

    reg {
        name = "Tsensor measurement value 6/7 register";
        field {
            name = "tsensor_temp_code7";
            sw = r;
            hw = w;
            reset = 0x0;
        } tsensor_temp_code7[25:16];

        field {
            name = "tsensor_temp_code6";
            sw = r;
            hw = w;
            reset = 0x0;
        } tsensor_temp_code6[9:0];
    } PERI_PMC73 @ 0x0124;

    reg {
        name = "Tsensor overflow/underflow alarm flag register";
        field {
            name = "tsensor_low_warning";
            sw = r;
            hw = w;
            reset = 0x0;
        } tsensor_low_warning[1:1];

        field {
            name = "tsensor_up_warning";
            sw = r;
            hw = w;
            reset = 0x0;
        } tsensor_up_warning[0:0];
    } PERI_PMC74 @ 0x0128;

    reg {
        name = "VICAP1 power-on/power-off control register";
        field {
            name = "vicap1_pwrdn_ack";
            sw = r;
            hw = w;
            reset = 0x0;
        } vicap1_pwrdn_ack[2:2];

        field {
            name = "vicap1_pwrdn_req";
            reset = 0x0;
        } vicap1_pwrdn_req[1:1];

        field {
            name = "vicap1_pwrdn_iso";
            reset = 0x1;
        } vicap1_pwrdn_iso[0:0];
    } PERI_PMC75 @ 0x012C;

    reg {
        name = "A17 power-on/power-off control register 0";
        field {
            name = "mtcoms_wait_mode_sel";
            reset = 0x0;
        } mtcoms_wait_mode_sel[3:2];

        field {
            name = "a17_pwrdn_ack_mode";
            reset = 0x0;
        } a17_pwrdn_ack_mode[1:1];

        field {
            name = "a17_pwrdn_req_mode";
            reset = 0x0;
        } a17_pwrdn_req_mode[0:0];
    } PERI_PMC76 @ 0x0130;

    reg {
        name = "A17 power-on/power-off control register 1";
        field {
            name = "a17_poweroff_flag";
            sw = r;
            hw = w;
            reset = 0x1;
        } a17_poweroff_flag[24:24];

        field {
            name = "a17_poweron_flag";
            sw = r;
            hw = w;
            reset = 0x0;
        } a17_poweron_flag[23:23];

        field {
            name = "a17_mtcmos_overtime";
            reset = 0xFF;
        } a17_mtcmos_overtime[20:13];

        field {
            name = "a17_mtcmos_overtime_en";
            reset = 0x0;
        } a17_mtcmos_overtime_en[12:12];

        field {
            name = "a17_irq_n";
            sw = r;
            hw = w;
            reset = 0x1;
        } a17_irq_n[11:11];

        field {
            name = "a17_fiq_n";
            sw = r;
            hw = w;
            reset = 0x1;
        } a17_fiq_n[10:10];

        field {
            name = "a17_standbywfe";
            sw = r;
            hw = w;
            reset = 0x0;
        } a17_standbywfe[9:9];

        field {
            name = "a17_standbywfil2";
            sw = r;
            hw = w;
            reset = 0x0;
        } a17_standbywfil2[8:8];

        field {
            name = "a17_standbywfi";
            sw = r;
            hw = w;
            reset = 0x0;
        } a17_standbywfi[7:7];

        field {
            name = "a17_bus_pwrdn_ack_n";
            sw = r;
            hw = w;
            reset = 0x0;
        } a17_bus_pwrdn_ack_n[6:6];

        field {
            name = "a17_bus_pwrdn_req_n_cfg";
            reset = 0x0;
        } a17_bus_pwrdn_req_n_cfg[5:5];

        field {
            name = "a17_bus_cactives";
            sw = r;
            hw = w;
            reset = 0x0;
        } a17_bus_cactives[4:4];

        field {
            name = "a17_bus_cactivem";
            sw = r;
            hw = w;
            reset = 0x0;
        } a17_bus_cactivem[3:3];

        field {
            name = "a17_pwrdn_ack";
            sw = r;
            hw = w;
            reset = 0x0;
        } a17_pwrdn_ack[2:2];

        field {
            name = "a17_pwrdn_req_cfg";
            reset = 0x0;
        } a17_pwrdn_req_cfg[1:1];

        field {
            name = "a17_pwrdn_iso_cfg";
            reset = 0x1;
        } a17_pwrdn_iso_cfg[0:0];
    } PERI_PMC77 @ 0x0134;

    reg {
        name = "A17 and CCI low-power control configuration register";
        field {
            name = "cci_arch_clkgate_enable";
            reset = 0x0;
        } cci_arch_clkgate_enable[12:12];

        field {
            name = "use_cs_pr";
            reset = 0x0;
        } use_cs_pr[11:11];

        field {
            name = "lp_mode_en";
            reset = 0x0;
        } lp_mode_en[10:10];

        field {
            name = "wfi_ret_en";
            reset = 0x0;
        } wfi_ret_en[9:9];

        field {
            name = "pgen_pulse_width";
            reset = 0x0;
        } pgen_pulse_width[8:8];

        field {
            name = "pgenf2retnr_timing";
            reset = 0x0;
        } pgenf2retnr_timing[7:7];

        field {
            name = "retnf2pgenr_timing";
            reset = 0x0;
        } retnf2pgenr_timing[6:6];

        field {
            name = "a17_l2_ram_lp_mode";
            reset = 0x0;
        } a17_l2_ram_lp_mode[5:4];

        field {
            name = "cci_sf_ram_lp_mode_update";
            reset = 0x0;
        } cci_sf_ram_lp_mode_update[3:3];

        field {
            name = "cci_sf_ram_lp_mode";
            reset = 0x0;
        } cci_sf_ram_lp_mode[2:0];
    } PERI_PMC78 @ 0x0138;

    reg {
        name = "A17 power-on/power-off control register 2";
        field {
            name = "a17_pon_rstime";
            reset = 0xFF;
        } a17_pon_rstime[23:16];

        field {
            name = "a17_ac_inactive";
            reset = 0x0;
        } a17_ac_inactive[8:8];

        field {
            name = "irq_poweron_en";
            reset = 0x0;
        } irq_poweron_en[7:7];

        field {
            name = "fiq_poweron_en";
            reset = 0x0;
        } fiq_poweron_en[6:6];

        field {
            name = "trigger_mode";
            reset = 0x0;
        } trigger_mode[5:5];

        field {
            name = "power_off_en";
            reset = 0x0;
        } power_off_en[4:4];

        field {
            name = "power_on_en";
            reset = 0x0;
        } power_on_en[3:3];

        field {
            name = "fsm_step";
            reset = 0x0;
        } fsm_step[2:2];

        field {
            name = "mode_onoff";
            reset = 0x0;
        } mode_onoff[1:0];
    } PERI_PMC79 @ 0x013C;

    reg {
        name = "A17 power-on times register";
        field {
            name = "a17_power_on_cnt";
            sw = r;
            hw = w;
            reset = 0x0;
        } a17_power_on_cnt[31:0];
    } PERI_PMC80 @ 0x0140;

    reg {
        name = "A17 power-off times register";
        field {
            name = "a17_power_off_cnt";
            sw = r;
            hw = w;
            reset = 0x0;
        } a17_power_off_cnt[31:0];
    } PERI_PMC81 @ 0x0144;

    reg {
        name = "A17 power-on time register 0";
        field {
            name = "a17_power_on_time_max";
            sw = r;
            hw = w;
            reset = 0x0;
        } a17_power_on_time_max[31:16];

        field {
            name = "a17_power_on_time_min";
            sw = r;
            hw = w;
            reset = 0x0;
        } a17_power_on_time_min[15:0];
    } PERI_PMC82 @ 0x0148;

    reg {
        name = "A17 power-on time register 1";
        field {
            name = "a17_power_on_time_now";
            sw = r;
            hw = w;
            reset = 0x0;
        } a17_power_on_time_now[15:0];
    } PERI_PMC83 @ 0x014C;

    reg {
        name = "A17 power-on time register 2";
        field {
            name = "a17_power_on_time_sum";
            sw = r;
            hw = w;
            reset = 0x0;
        } a17_power_on_time_sum[31:0];
    } PERI_PMC84 @ 0x0150;

    reg {
        name = "A17 power-on time counting termination configuration register";
        field {
            name = "stop_a17_poweron_time_cnt";
            reset = 0x0;
        } stop_a17_poweron_time_cnt[0:0];
    } PERI_PMC85 @ 0x0154;

    reg {
        name = "A17 power-off time register 0";
        field {
            name = "a17_power_off_time_max";
            sw = r;
            hw = w;
            reset = 0x0;
        } a17_power_off_time_max[31:16];

        field {
            name = "a17_power_off_time_min";
            sw = r;
            hw = w;
            reset = 0x0;
        } a17_power_off_time_min[15:0];
    } PERI_PMC86 @ 0x0158;

    reg {
        name = "A17 power-off time register 1";
        field {
            name = "a17_power_off_time_now";
            sw = r;
            hw = w;
            reset = 0x0;
        } a17_power_off_time_now[15:0];
    } PERI_PMC87 @ 0x015C;

    reg {
        name = "A17 power-off time register 2";
        field {
            name = "a17_power_off_time_sum";
            sw = r;
            hw = w;
            reset = 0x0;
        } a17_power_off_time_sum[31:0];
    } PERI_PMC88 @ 0x0160;
};
`endif
